// Design: example/inverter_tb
simulator lang=spectre
global 0
parameters vg=0.3 vdd=0.5

// example/inverter_tb/schematic
C3 (vin 0) capacitor c=200a
C2 (vout vin) capacitor c=200a
C0 (vin vout) capacitor c=200a
C1 (vdd vin) capacitor c=200a
I14 (vout vin 0) SiNanosheetFET_NFET_ML tox=2 Lg=10 eps_ox=4 V_th=0.2 ln_eps=1e-05 smooth_delta=1e-12 vds_floor=1e-06 vds_sign_smooth=0.001 exp_arg_limit=80 log_id_min=-120 log_id_max=80 gmin_ds=1e-12 Wid=1 qraw_to_c=1e-16 qdensity_scale=1
V2 (net1 0) vsource dc=250.00m mag=1 type=sine
I15 (vout vin vdd) SiNanosheetFET_PFET_ML tox=2 Lg=10 eps_ox=4 V_th=-0.2 ln_eps=1e-05 smooth_delta=1e-12 vds_floor=1e-06 vds_sign_smooth=0.001 exp_arg_limit=80 log_id_min=-120 log_id_max=80 gmin_ds=1e-12 Wid=1 qraw_to_c=1e-16 qdensity_scale=1
V1 (vdd 0) vsource dc=vdd type=dc
V3 (net2 0) vsource dc=vg type=dc
V0 (vin 0) vsource dc=200.0m type=pulse val0=0 val1=500.0m period=100p delay=0 rise=1p fall=1p width=50p
simulatorOptions options temp=27
tran tran stop=400p
save vin vout
ahdl_include "/ecel/UFAD/tanvir.ahmed/Desktop/Verilog/SiNanosheetFET/ade/example/nfet/veriloga/veriloga.va"
ahdl_include "/ecel/UFAD/tanvir.ahmed/Desktop/Verilog/SiNanosheetFET/ade/example/pfet/veriloga/veriloga.va"
