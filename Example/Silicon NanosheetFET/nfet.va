`include "constants.vams"
`include "disciplines.vams"

module SiNanosheetFET_NFET_ML(d, g, s);
  inout d, g, s;
  electrical d, g, s;

  // Device/model parameters
  // tox [nm], Lg [nm], eps_ox relative permittivity, V_th [V]
  parameter real tox = 2.0;
  parameter real Lg = 10.0;
  parameter real eps_ox = 4.0;
  parameter real V_th = 0.20;

  // Numerical safety / convergence knobs
  parameter real ln_eps = 1e-5;
  parameter real smooth_delta = 1e-12;
  parameter real vds_floor = 1e-6;
  parameter real vds_sign_smooth = 1e-3;
  parameter real exp_arg_limit = 80.0;
  parameter real log_id_min = -120.0;
  parameter real log_id_max = 80.0;
  parameter real gmin_ds = 1e-12;
  parameter real Wid = 1.0 from [0:inf);
  parameter real qraw_to_c = 1.0e-16 from [0:inf); // same scaling used in sifet.py for Q---update from 10^-6
  parameter real qdensity_scale = 1.0 from [0:inf);

  // Internal scalars
  real vgs, vds, vgs_shift, vds_pos, vds_abs, sign_vds;
  real tox_eff, lg_eff, eps_eff, dev0, dev1, dev2;
  real n_raw, v0_raw, beta_raw, n_par, v0_par, b_par, vt_pred, vdsat_raw, vdsat;
  real cinv, f_softplus, log_vds, log_vdsat, lse, log_id, log_id_lim, ids_mag, ids;
  real tmp_a, tmp_b;
  real q_ml_raw, qg, qs, qd;
  real alpha_d, fvd;

  // LayerNorm helper temps
  real mean_tmp, var_tmp;

  analog function real smooth_pos;
  input x, dlt;
  real x, dlt;
  begin
      smooth_pos = 0.5*(x + sqrt(x*x + dlt*dlt));
  end
  endfunction

  analog function real smooth_clip;
    input  x, limit;
    real  x, limit;
    begin
      smooth_clip = limit * tanh(x / limit);
    end
  endfunction

  analog function real sigmoid_lim;
    input  x;
    real x;
    begin
      sigmoid_lim = 1.0 / (1.0 + exp(-x));
    end
  endfunction

  analog function real gelu_approx;
    input  x;
    real  x;
    real c;
    begin
      c = 0.79788456080286541; // sqrt(2/pi)
      gelu_approx = 0.5 * x * (1.0 + tanh(c * (x + 0.044715*x*x*x)));
    end
  endfunction

  analog function real logsumexp2_smooth;
    input  a, b, dlt;
    real a, b, dlt;
    real m;
    begin
      m = 0.5*(a + b + sqrt((a-b)*(a-b) + dlt));
      logsumexp2_smooth = m + ln(exp(a-m) + exp(b-m));
    end
  endfunction

  // Device token 0
  real dt0_l0_0;
  real dt0_l0_1;
  real dt0_l0_2;
  real dt0_l0_3;
  real dt0_l0_4;
  real dt0_l0_5;
  real dt0_l0_6;
  real dt0_l0_7;
  real dt0_l0_8;
  real dt0_l0_9;
  real dt0_l0_10;
  real dt0_l0_11;
  real dt0_l0_12;
  real dt0_l0_13;
  real dt0_l0_14;
  real dt0_l0_15;
  real dt0_l0_16;
  real dt0_l0_17;
  real dt0_l0_18;
  real dt0_l0_19;
  real dt0_l0_20;
  real dt0_l0_21;
  real dt0_l0_22;
  real dt0_l0_23;
  real dt0_l0_24;
  real dt0_l0_25;
  real dt0_l0_26;
  real dt0_l0_27;
  real dt0_l0_28;
  real dt0_l0_29;
  real dt0_l0_30;
  real dt0_l0_31;
  real dt0_n0_0;
  real dt0_n0_1;
  real dt0_n0_2;
  real dt0_n0_3;
  real dt0_n0_4;
  real dt0_n0_5;
  real dt0_n0_6;
  real dt0_n0_7;
  real dt0_n0_8;
  real dt0_n0_9;
  real dt0_n0_10;
  real dt0_n0_11;
  real dt0_n0_12;
  real dt0_n0_13;
  real dt0_n0_14;
  real dt0_n0_15;
  real dt0_n0_16;
  real dt0_n0_17;
  real dt0_n0_18;
  real dt0_n0_19;
  real dt0_n0_20;
  real dt0_n0_21;
  real dt0_n0_22;
  real dt0_n0_23;
  real dt0_n0_24;
  real dt0_n0_25;
  real dt0_n0_26;
  real dt0_n0_27;
  real dt0_n0_28;
  real dt0_n0_29;
  real dt0_n0_30;
  real dt0_n0_31;
  real dt0_g0_0;
  real dt0_g0_1;
  real dt0_g0_2;
  real dt0_g0_3;
  real dt0_g0_4;
  real dt0_g0_5;
  real dt0_g0_6;
  real dt0_g0_7;
  real dt0_g0_8;
  real dt0_g0_9;
  real dt0_g0_10;
  real dt0_g0_11;
  real dt0_g0_12;
  real dt0_g0_13;
  real dt0_g0_14;
  real dt0_g0_15;
  real dt0_g0_16;
  real dt0_g0_17;
  real dt0_g0_18;
  real dt0_g0_19;
  real dt0_g0_20;
  real dt0_g0_21;
  real dt0_g0_22;
  real dt0_g0_23;
  real dt0_g0_24;
  real dt0_g0_25;
  real dt0_g0_26;
  real dt0_g0_27;
  real dt0_g0_28;
  real dt0_g0_29;
  real dt0_g0_30;
  real dt0_g0_31;
  real dt0_l1_0;
  real dt0_l1_1;
  real dt0_l1_2;
  real dt0_l1_3;
  real dt0_l1_4;
  real dt0_l1_5;
  real dt0_l1_6;
  real dt0_l1_7;
  real dt0_l1_8;
  real dt0_l1_9;
  real dt0_l1_10;
  real dt0_l1_11;
  real dt0_l1_12;
  real dt0_l1_13;
  real dt0_l1_14;
  real dt0_l1_15;
  real dt0_mean;
  real dt0_var;

  // Device token 1
  real dt1_l0_0;
  real dt1_l0_1;
  real dt1_l0_2;
  real dt1_l0_3;
  real dt1_l0_4;
  real dt1_l0_5;
  real dt1_l0_6;
  real dt1_l0_7;
  real dt1_l0_8;
  real dt1_l0_9;
  real dt1_l0_10;
  real dt1_l0_11;
  real dt1_l0_12;
  real dt1_l0_13;
  real dt1_l0_14;
  real dt1_l0_15;
  real dt1_l0_16;
  real dt1_l0_17;
  real dt1_l0_18;
  real dt1_l0_19;
  real dt1_l0_20;
  real dt1_l0_21;
  real dt1_l0_22;
  real dt1_l0_23;
  real dt1_l0_24;
  real dt1_l0_25;
  real dt1_l0_26;
  real dt1_l0_27;
  real dt1_l0_28;
  real dt1_l0_29;
  real dt1_l0_30;
  real dt1_l0_31;
  real dt1_n0_0;
  real dt1_n0_1;
  real dt1_n0_2;
  real dt1_n0_3;
  real dt1_n0_4;
  real dt1_n0_5;
  real dt1_n0_6;
  real dt1_n0_7;
  real dt1_n0_8;
  real dt1_n0_9;
  real dt1_n0_10;
  real dt1_n0_11;
  real dt1_n0_12;
  real dt1_n0_13;
  real dt1_n0_14;
  real dt1_n0_15;
  real dt1_n0_16;
  real dt1_n0_17;
  real dt1_n0_18;
  real dt1_n0_19;
  real dt1_n0_20;
  real dt1_n0_21;
  real dt1_n0_22;
  real dt1_n0_23;
  real dt1_n0_24;
  real dt1_n0_25;
  real dt1_n0_26;
  real dt1_n0_27;
  real dt1_n0_28;
  real dt1_n0_29;
  real dt1_n0_30;
  real dt1_n0_31;
  real dt1_g0_0;
  real dt1_g0_1;
  real dt1_g0_2;
  real dt1_g0_3;
  real dt1_g0_4;
  real dt1_g0_5;
  real dt1_g0_6;
  real dt1_g0_7;
  real dt1_g0_8;
  real dt1_g0_9;
  real dt1_g0_10;
  real dt1_g0_11;
  real dt1_g0_12;
  real dt1_g0_13;
  real dt1_g0_14;
  real dt1_g0_15;
  real dt1_g0_16;
  real dt1_g0_17;
  real dt1_g0_18;
  real dt1_g0_19;
  real dt1_g0_20;
  real dt1_g0_21;
  real dt1_g0_22;
  real dt1_g0_23;
  real dt1_g0_24;
  real dt1_g0_25;
  real dt1_g0_26;
  real dt1_g0_27;
  real dt1_g0_28;
  real dt1_g0_29;
  real dt1_g0_30;
  real dt1_g0_31;
  real dt1_l1_0;
  real dt1_l1_1;
  real dt1_l1_2;
  real dt1_l1_3;
  real dt1_l1_4;
  real dt1_l1_5;
  real dt1_l1_6;
  real dt1_l1_7;
  real dt1_l1_8;
  real dt1_l1_9;
  real dt1_l1_10;
  real dt1_l1_11;
  real dt1_l1_12;
  real dt1_l1_13;
  real dt1_l1_14;
  real dt1_l1_15;
  real dt1_mean;
  real dt1_var;

  // Device token 2
  real dt2_l0_0;
  real dt2_l0_1;
  real dt2_l0_2;
  real dt2_l0_3;
  real dt2_l0_4;
  real dt2_l0_5;
  real dt2_l0_6;
  real dt2_l0_7;
  real dt2_l0_8;
  real dt2_l0_9;
  real dt2_l0_10;
  real dt2_l0_11;
  real dt2_l0_12;
  real dt2_l0_13;
  real dt2_l0_14;
  real dt2_l0_15;
  real dt2_l0_16;
  real dt2_l0_17;
  real dt2_l0_18;
  real dt2_l0_19;
  real dt2_l0_20;
  real dt2_l0_21;
  real dt2_l0_22;
  real dt2_l0_23;
  real dt2_l0_24;
  real dt2_l0_25;
  real dt2_l0_26;
  real dt2_l0_27;
  real dt2_l0_28;
  real dt2_l0_29;
  real dt2_l0_30;
  real dt2_l0_31;
  real dt2_n0_0;
  real dt2_n0_1;
  real dt2_n0_2;
  real dt2_n0_3;
  real dt2_n0_4;
  real dt2_n0_5;
  real dt2_n0_6;
  real dt2_n0_7;
  real dt2_n0_8;
  real dt2_n0_9;
  real dt2_n0_10;
  real dt2_n0_11;
  real dt2_n0_12;
  real dt2_n0_13;
  real dt2_n0_14;
  real dt2_n0_15;
  real dt2_n0_16;
  real dt2_n0_17;
  real dt2_n0_18;
  real dt2_n0_19;
  real dt2_n0_20;
  real dt2_n0_21;
  real dt2_n0_22;
  real dt2_n0_23;
  real dt2_n0_24;
  real dt2_n0_25;
  real dt2_n0_26;
  real dt2_n0_27;
  real dt2_n0_28;
  real dt2_n0_29;
  real dt2_n0_30;
  real dt2_n0_31;
  real dt2_g0_0;
  real dt2_g0_1;
  real dt2_g0_2;
  real dt2_g0_3;
  real dt2_g0_4;
  real dt2_g0_5;
  real dt2_g0_6;
  real dt2_g0_7;
  real dt2_g0_8;
  real dt2_g0_9;
  real dt2_g0_10;
  real dt2_g0_11;
  real dt2_g0_12;
  real dt2_g0_13;
  real dt2_g0_14;
  real dt2_g0_15;
  real dt2_g0_16;
  real dt2_g0_17;
  real dt2_g0_18;
  real dt2_g0_19;
  real dt2_g0_20;
  real dt2_g0_21;
  real dt2_g0_22;
  real dt2_g0_23;
  real dt2_g0_24;
  real dt2_g0_25;
  real dt2_g0_26;
  real dt2_g0_27;
  real dt2_g0_28;
  real dt2_g0_29;
  real dt2_g0_30;
  real dt2_g0_31;
  real dt2_l1_0;
  real dt2_l1_1;
  real dt2_l1_2;
  real dt2_l1_3;
  real dt2_l1_4;
  real dt2_l1_5;
  real dt2_l1_6;
  real dt2_l1_7;
  real dt2_l1_8;
  real dt2_l1_9;
  real dt2_l1_10;
  real dt2_l1_11;
  real dt2_l1_12;
  real dt2_l1_13;
  real dt2_l1_14;
  real dt2_l1_15;
  real dt2_mean;
  real dt2_var;

  real hp_0;
  real hp_1;
  real hp_2;
  real hp_3;
  real hp_4;
  real hp_5;
  real hp_6;
  real hp_7;
  real hp_8;
  real hp_9;
  real hp_10;
  real hp_11;
  real hp_12;
  real hp_13;
  real hp_14;
  real hp_15;
  real hpn_0;
  real hpn_1;
  real hpn_2;
  real hpn_3;
  real hpn_4;
  real hpn_5;
  real hpn_6;
  real hpn_7;
  real hpn_8;
  real hpn_9;
  real hpn_10;
  real hpn_11;
  real hpn_12;
  real hpn_13;
  real hpn_14;
  real hpn_15;
  real hp_mean;
  real hp_var;

  real bt_l0_0;
  real bt_l0_1;
  real bt_l0_2;
  real bt_l0_3;
  real bt_l0_4;
  real bt_l0_5;
  real bt_l0_6;
  real bt_l0_7;
  real bt_l0_8;
  real bt_l0_9;
  real bt_l0_10;
  real bt_l0_11;
  real bt_l0_12;
  real bt_l0_13;
  real bt_l0_14;
  real bt_l0_15;
  real bt_l0_16;
  real bt_l0_17;
  real bt_l0_18;
  real bt_l0_19;
  real bt_l0_20;
  real bt_l0_21;
  real bt_l0_22;
  real bt_l0_23;
  real bt_l0_24;
  real bt_l0_25;
  real bt_l0_26;
  real bt_l0_27;
  real bt_l0_28;
  real bt_l0_29;
  real bt_l0_30;
  real bt_l0_31;
  real bt_l0_32;
  real bt_l0_33;
  real bt_l0_34;
  real bt_l0_35;
  real bt_l0_36;
  real bt_l0_37;
  real bt_l0_38;
  real bt_l0_39;
  real bt_l0_40;
  real bt_l0_41;
  real bt_l0_42;
  real bt_l0_43;
  real bt_l0_44;
  real bt_l0_45;
  real bt_l0_46;
  real bt_l0_47;
  real bt_l0_48;
  real bt_l0_49;
  real bt_l0_50;
  real bt_l0_51;
  real bt_l0_52;
  real bt_l0_53;
  real bt_l0_54;
  real bt_l0_55;
  real bt_l0_56;
  real bt_l0_57;
  real bt_l0_58;
  real bt_l0_59;
  real bt_l0_60;
  real bt_l0_61;
  real bt_l0_62;
  real bt_l0_63;
  real bt_n0_0;
  real bt_n0_1;
  real bt_n0_2;
  real bt_n0_3;
  real bt_n0_4;
  real bt_n0_5;
  real bt_n0_6;
  real bt_n0_7;
  real bt_n0_8;
  real bt_n0_9;
  real bt_n0_10;
  real bt_n0_11;
  real bt_n0_12;
  real bt_n0_13;
  real bt_n0_14;
  real bt_n0_15;
  real bt_n0_16;
  real bt_n0_17;
  real bt_n0_18;
  real bt_n0_19;
  real bt_n0_20;
  real bt_n0_21;
  real bt_n0_22;
  real bt_n0_23;
  real bt_n0_24;
  real bt_n0_25;
  real bt_n0_26;
  real bt_n0_27;
  real bt_n0_28;
  real bt_n0_29;
  real bt_n0_30;
  real bt_n0_31;
  real bt_n0_32;
  real bt_n0_33;
  real bt_n0_34;
  real bt_n0_35;
  real bt_n0_36;
  real bt_n0_37;
  real bt_n0_38;
  real bt_n0_39;
  real bt_n0_40;
  real bt_n0_41;
  real bt_n0_42;
  real bt_n0_43;
  real bt_n0_44;
  real bt_n0_45;
  real bt_n0_46;
  real bt_n0_47;
  real bt_n0_48;
  real bt_n0_49;
  real bt_n0_50;
  real bt_n0_51;
  real bt_n0_52;
  real bt_n0_53;
  real bt_n0_54;
  real bt_n0_55;
  real bt_n0_56;
  real bt_n0_57;
  real bt_n0_58;
  real bt_n0_59;
  real bt_n0_60;
  real bt_n0_61;
  real bt_n0_62;
  real bt_n0_63;
  real bt_g0_0;
  real bt_g0_1;
  real bt_g0_2;
  real bt_g0_3;
  real bt_g0_4;
  real bt_g0_5;
  real bt_g0_6;
  real bt_g0_7;
  real bt_g0_8;
  real bt_g0_9;
  real bt_g0_10;
  real bt_g0_11;
  real bt_g0_12;
  real bt_g0_13;
  real bt_g0_14;
  real bt_g0_15;
  real bt_g0_16;
  real bt_g0_17;
  real bt_g0_18;
  real bt_g0_19;
  real bt_g0_20;
  real bt_g0_21;
  real bt_g0_22;
  real bt_g0_23;
  real bt_g0_24;
  real bt_g0_25;
  real bt_g0_26;
  real bt_g0_27;
  real bt_g0_28;
  real bt_g0_29;
  real bt_g0_30;
  real bt_g0_31;
  real bt_g0_32;
  real bt_g0_33;
  real bt_g0_34;
  real bt_g0_35;
  real bt_g0_36;
  real bt_g0_37;
  real bt_g0_38;
  real bt_g0_39;
  real bt_g0_40;
  real bt_g0_41;
  real bt_g0_42;
  real bt_g0_43;
  real bt_g0_44;
  real bt_g0_45;
  real bt_g0_46;
  real bt_g0_47;
  real bt_g0_48;
  real bt_g0_49;
  real bt_g0_50;
  real bt_g0_51;
  real bt_g0_52;
  real bt_g0_53;
  real bt_g0_54;
  real bt_g0_55;
  real bt_g0_56;
  real bt_g0_57;
  real bt_g0_58;
  real bt_g0_59;
  real bt_g0_60;
  real bt_g0_61;
  real bt_g0_62;
  real bt_g0_63;
  real bt_l1_0;
  real bt_l1_1;
  real bt_l1_2;
  real bt_l1_3;
  real bt_l1_4;
  real bt_l1_5;
  real bt_l1_6;
  real bt_l1_7;
  real bt_l1_8;
  real bt_l1_9;
  real bt_l1_10;
  real bt_l1_11;
  real bt_l1_12;
  real bt_l1_13;
  real bt_l1_14;
  real bt_l1_15;
  real bt_l1_16;
  real bt_l1_17;
  real bt_l1_18;
  real bt_l1_19;
  real bt_l1_20;
  real bt_l1_21;
  real bt_l1_22;
  real bt_l1_23;
  real bt_l1_24;
  real bt_l1_25;
  real bt_l1_26;
  real bt_l1_27;
  real bt_l1_28;
  real bt_l1_29;
  real bt_l1_30;
  real bt_l1_31;
  real bt_l1_32;
  real bt_l1_33;
  real bt_l1_34;
  real bt_l1_35;
  real bt_l1_36;
  real bt_l1_37;
  real bt_l1_38;
  real bt_l1_39;
  real bt_l1_40;
  real bt_l1_41;
  real bt_l1_42;
  real bt_l1_43;
  real bt_l1_44;
  real bt_l1_45;
  real bt_l1_46;
  real bt_l1_47;
  real bt_l1_48;
  real bt_l1_49;
  real bt_l1_50;
  real bt_l1_51;
  real bt_l1_52;
  real bt_l1_53;
  real bt_l1_54;
  real bt_l1_55;
  real bt_l1_56;
  real bt_l1_57;
  real bt_l1_58;
  real bt_l1_59;
  real bt_l1_60;
  real bt_l1_61;
  real bt_l1_62;
  real bt_l1_63;
  real bt_n1_0;
  real bt_n1_1;
  real bt_n1_2;
  real bt_n1_3;
  real bt_n1_4;
  real bt_n1_5;
  real bt_n1_6;
  real bt_n1_7;
  real bt_n1_8;
  real bt_n1_9;
  real bt_n1_10;
  real bt_n1_11;
  real bt_n1_12;
  real bt_n1_13;
  real bt_n1_14;
  real bt_n1_15;
  real bt_n1_16;
  real bt_n1_17;
  real bt_n1_18;
  real bt_n1_19;
  real bt_n1_20;
  real bt_n1_21;
  real bt_n1_22;
  real bt_n1_23;
  real bt_n1_24;
  real bt_n1_25;
  real bt_n1_26;
  real bt_n1_27;
  real bt_n1_28;
  real bt_n1_29;
  real bt_n1_30;
  real bt_n1_31;
  real bt_n1_32;
  real bt_n1_33;
  real bt_n1_34;
  real bt_n1_35;
  real bt_n1_36;
  real bt_n1_37;
  real bt_n1_38;
  real bt_n1_39;
  real bt_n1_40;
  real bt_n1_41;
  real bt_n1_42;
  real bt_n1_43;
  real bt_n1_44;
  real bt_n1_45;
  real bt_n1_46;
  real bt_n1_47;
  real bt_n1_48;
  real bt_n1_49;
  real bt_n1_50;
  real bt_n1_51;
  real bt_n1_52;
  real bt_n1_53;
  real bt_n1_54;
  real bt_n1_55;
  real bt_n1_56;
  real bt_n1_57;
  real bt_n1_58;
  real bt_n1_59;
  real bt_n1_60;
  real bt_n1_61;
  real bt_n1_62;
  real bt_n1_63;
  real bt_g1_0;
  real bt_g1_1;
  real bt_g1_2;
  real bt_g1_3;
  real bt_g1_4;
  real bt_g1_5;
  real bt_g1_6;
  real bt_g1_7;
  real bt_g1_8;
  real bt_g1_9;
  real bt_g1_10;
  real bt_g1_11;
  real bt_g1_12;
  real bt_g1_13;
  real bt_g1_14;
  real bt_g1_15;
  real bt_g1_16;
  real bt_g1_17;
  real bt_g1_18;
  real bt_g1_19;
  real bt_g1_20;
  real bt_g1_21;
  real bt_g1_22;
  real bt_g1_23;
  real bt_g1_24;
  real bt_g1_25;
  real bt_g1_26;
  real bt_g1_27;
  real bt_g1_28;
  real bt_g1_29;
  real bt_g1_30;
  real bt_g1_31;
  real bt_g1_32;
  real bt_g1_33;
  real bt_g1_34;
  real bt_g1_35;
  real bt_g1_36;
  real bt_g1_37;
  real bt_g1_38;
  real bt_g1_39;
  real bt_g1_40;
  real bt_g1_41;
  real bt_g1_42;
  real bt_g1_43;
  real bt_g1_44;
  real bt_g1_45;
  real bt_g1_46;
  real bt_g1_47;
  real bt_g1_48;
  real bt_g1_49;
  real bt_g1_50;
  real bt_g1_51;
  real bt_g1_52;
  real bt_g1_53;
  real bt_g1_54;
  real bt_g1_55;
  real bt_g1_56;
  real bt_g1_57;
  real bt_g1_58;
  real bt_g1_59;
  real bt_g1_60;
  real bt_g1_61;
  real bt_g1_62;
  real bt_g1_63;
  real hv_0;
  real hv_1;
  real hv_2;
  real hv_3;
  real hv_4;
  real hv_5;
  real hv_6;
  real hv_7;
  real hv_8;
  real hv_9;
  real hv_10;
  real hv_11;
  real hv_12;
  real hv_13;
  real hv_14;
  real hv_15;
  real bt0_mean;
  real bt0_var;
  real bt1_mean;
  real bt1_var;

  real dh_l0_0;
  real dh_l0_1;
  real dh_l0_2;
  real dh_l0_3;
  real dh_l0_4;
  real dh_l0_5;
  real dh_l0_6;
  real dh_l0_7;
  real dh_l0_8;
  real dh_l0_9;
  real dh_l0_10;
  real dh_l0_11;
  real dh_l0_12;
  real dh_l0_13;
  real dh_l0_14;
  real dh_l0_15;
  real dh_l0_16;
  real dh_l0_17;
  real dh_l0_18;
  real dh_l0_19;
  real dh_l0_20;
  real dh_l0_21;
  real dh_l0_22;
  real dh_l0_23;
  real dh_l0_24;
  real dh_l0_25;
  real dh_l0_26;
  real dh_l0_27;
  real dh_l0_28;
  real dh_l0_29;
  real dh_l0_30;
  real dh_l0_31;
  real dh_n0_0;
  real dh_n0_1;
  real dh_n0_2;
  real dh_n0_3;
  real dh_n0_4;
  real dh_n0_5;
  real dh_n0_6;
  real dh_n0_7;
  real dh_n0_8;
  real dh_n0_9;
  real dh_n0_10;
  real dh_n0_11;
  real dh_n0_12;
  real dh_n0_13;
  real dh_n0_14;
  real dh_n0_15;
  real dh_n0_16;
  real dh_n0_17;
  real dh_n0_18;
  real dh_n0_19;
  real dh_n0_20;
  real dh_n0_21;
  real dh_n0_22;
  real dh_n0_23;
  real dh_n0_24;
  real dh_n0_25;
  real dh_n0_26;
  real dh_n0_27;
  real dh_n0_28;
  real dh_n0_29;
  real dh_n0_30;
  real dh_n0_31;
  real dh_g0_0;
  real dh_g0_1;
  real dh_g0_2;
  real dh_g0_3;
  real dh_g0_4;
  real dh_g0_5;
  real dh_g0_6;
  real dh_g0_7;
  real dh_g0_8;
  real dh_g0_9;
  real dh_g0_10;
  real dh_g0_11;
  real dh_g0_12;
  real dh_g0_13;
  real dh_g0_14;
  real dh_g0_15;
  real dh_g0_16;
  real dh_g0_17;
  real dh_g0_18;
  real dh_g0_19;
  real dh_g0_20;
  real dh_g0_21;
  real dh_g0_22;
  real dh_g0_23;
  real dh_g0_24;
  real dh_g0_25;
  real dh_g0_26;
  real dh_g0_27;
  real dh_g0_28;
  real dh_g0_29;
  real dh_g0_30;
  real dh_g0_31;
  real dh_l1_0;
  real dh_l1_1;
  real dh_l1_2;
  real dh_l1_3;
  real dh0_mean;
  real dh0_var;

  real film_0;
  real film_1;
  real film_2;
  real film_3;
  real film_4;
  real film_5;
  real film_6;
  real film_7;
  real film_8;
  real film_9;
  real film_10;
  real film_11;
  real film_12;
  real film_13;
  real film_14;
  real film_15;
  real film_16;
  real film_17;
  real film_18;
  real film_19;
  real film_20;
  real film_21;
  real film_22;
  real film_23;
  real film_24;
  real film_25;
  real film_26;
  real film_27;
  real film_28;
  real film_29;
  real film_30;
  real film_31;
  real hfp_0;
  real hfp_1;
  real hfp_2;
  real hfp_3;
  real hfp_4;
  real hfp_5;
  real hfp_6;
  real hfp_7;
  real hfp_8;
  real hfp_9;
  real hfp_10;
  real hfp_11;
  real hfp_12;
  real hfp_13;
  real hfp_14;
  real hfp_15;
  real hfn_0;
  real hfn_1;
  real hfn_2;
  real hfn_3;
  real hfn_4;
  real hfn_5;
  real hfn_6;
  real hfn_7;
  real hfn_8;
  real hfn_9;
  real hfn_10;
  real hfn_11;
  real hfn_12;
  real hfn_13;
  real hfn_14;
  real hfn_15;
  real fh_l0_0;
  real fh_l0_1;
  real fh_l0_2;
  real fh_l0_3;
  real fh_l0_4;
  real fh_l0_5;
  real fh_l0_6;
  real fh_l0_7;
  real fh_l0_8;
  real fh_l0_9;
  real fh_l0_10;
  real fh_l0_11;
  real fh_l0_12;
  real fh_l0_13;
  real fh_l0_14;
  real fh_l0_15;
  real fh_l0_16;
  real fh_l0_17;
  real fh_l0_18;
  real fh_l0_19;
  real fh_l0_20;
  real fh_l0_21;
  real fh_l0_22;
  real fh_l0_23;
  real fh_l0_24;
  real fh_l0_25;
  real fh_l0_26;
  real fh_l0_27;
  real fh_l0_28;
  real fh_l0_29;
  real fh_l0_30;
  real fh_l0_31;
  real fh_n0_0;
  real fh_n0_1;
  real fh_n0_2;
  real fh_n0_3;
  real fh_n0_4;
  real fh_n0_5;
  real fh_n0_6;
  real fh_n0_7;
  real fh_n0_8;
  real fh_n0_9;
  real fh_n0_10;
  real fh_n0_11;
  real fh_n0_12;
  real fh_n0_13;
  real fh_n0_14;
  real fh_n0_15;
  real fh_n0_16;
  real fh_n0_17;
  real fh_n0_18;
  real fh_n0_19;
  real fh_n0_20;
  real fh_n0_21;
  real fh_n0_22;
  real fh_n0_23;
  real fh_n0_24;
  real fh_n0_25;
  real fh_n0_26;
  real fh_n0_27;
  real fh_n0_28;
  real fh_n0_29;
  real fh_n0_30;
  real fh_n0_31;
  real fh_g0_0;
  real fh_g0_1;
  real fh_g0_2;
  real fh_g0_3;
  real fh_g0_4;
  real fh_g0_5;
  real fh_g0_6;
  real fh_g0_7;
  real fh_g0_8;
  real fh_g0_9;
  real fh_g0_10;
  real fh_g0_11;
  real fh_g0_12;
  real fh_g0_13;
  real fh_g0_14;
  real fh_g0_15;
  real fh_g0_16;
  real fh_g0_17;
  real fh_g0_18;
  real fh_g0_19;
  real fh_g0_20;
  real fh_g0_21;
  real fh_g0_22;
  real fh_g0_23;
  real fh_g0_24;
  real fh_g0_25;
  real fh_g0_26;
  real fh_g0_27;
  real fh_g0_28;
  real fh_g0_29;
  real fh_g0_30;
  real fh_g0_31;
  real fh_l1_0;
  real fh_l1_1;
  real fh_l1_2;
  real hf_mean;
  real hf_var;
  real fh0_mean;
  real fh0_var;

  analog begin
    // Terminal voltages
    vgs = V(g,s);
    vds = V(d,s);
    vgs_shift = vgs - (V_th - 0.20);

    // Positive-only proxies used by the trained model equations
    vds_abs = sqrt(vds*vds + vds_floor*vds_floor);
    vds_pos = smooth_pos(vds_abs, vds_floor);
    sign_vds = vds / sqrt(vds*vds + vds_sign_smooth*vds_sign_smooth);

    tox_eff = smooth_pos(tox, smooth_delta);
    lg_eff = smooth_pos(Lg, smooth_delta);
    eps_eff = smooth_pos(eps_ox, smooth_delta);

    dev0 = tox_eff / 10.0;
    dev1 = lg_eff / 100.0;
    dev2 = eps_eff / 100.0;

    // Device tower token 0
    dt0_l0_0 = (-0.31431568098848012) + (1.2195616960525513)*dev0;
    dt0_l0_1 = (0.04751739101352527) + (0.018948320299386978)*dev0;
    dt0_l0_2 = (-0.027284051798522571) + (-0.00044691961375065148)*dev0;
    dt0_l0_3 = (0.084451876577377488) + (0.027163483202457428)*dev0;
    dt0_l0_4 = (0.1175373942692214) + (0.033691637217998505)*dev0;
    dt0_l0_5 = (-0.23993642982193547) + (-0.86946827173233032)*dev0;
    dt0_l0_6 = (0.052978088334746279) + (0.020761676132678986)*dev0;
    dt0_l0_7 = (0.060619622745260164) + (0.021645240485668182)*dev0;
    dt0_l0_8 = (0.22014473036953963) + (0.055928267538547516)*dev0;
    dt0_l0_9 = (0.13076945525648953) + (0.035811524838209152)*dev0;
    dt0_l0_10 = (0.039380058754339267) + (0.016222704201936722)*dev0;
    dt0_l0_11 = (-0.006788407475213934) + (0.01910720206797123)*dev0;
    dt0_l0_12 = (0.063863105567314782) + (0.022229747846722603)*dev0;
    dt0_l0_13 = (0.079046049014772607) + (0.02716631256043911)*dev0;
    dt0_l0_14 = (-0.069986437386431122) + (0.47177079319953918)*dev0;
    dt0_l0_15 = (0.079532147666002875) + (0.02563852071762085)*dev0;
    dt0_l0_16 = (-0.16873852038852635) + (-0.8715357780456543)*dev0;
    dt0_l0_17 = (0.046961170742138798) + (0.019475888460874557)*dev0;
    dt0_l0_18 = (0.070020979457444427) + (0.023528816178441048)*dev0;
    dt0_l0_19 = (-0.28566245291639047) + (0.92190909385681152)*dev0;
    dt0_l0_20 = (0.054496514891022405) + (0.020385686308145523)*dev0;
    dt0_l0_21 = (0.17076097094357898) + (-1.0305671691894531)*dev0;
    dt0_l0_22 = (-0.017118739869118771) + (-1.5255454778671265)*dev0;
    dt0_l0_23 = (0.103842551154872) + (0.031063420698046684)*dev0;
    dt0_l0_24 = (0.047862333100331236) + (0.018535159528255463)*dev0;
    dt0_l0_25 = (0.059082290740160345) + (0.022205263376235962)*dev0;
    dt0_l0_26 = (0.039530669765871121) + (0.016815893352031708)*dev0;
    dt0_l0_27 = (0.032343466008309285) + (0.01488249097019434)*dev0;
    dt0_l0_28 = (0.066797314823681453) + (0.022590510547161102)*dev0;
    dt0_l0_29 = (0.1187851963802633) + (0.034689158201217651)*dev0;
    dt0_l0_30 = (0.097950624569893355) + (0.029342725872993469)*dev0;
    dt0_l0_31 = (-0.49410748098656598) + (1.0588947534561157)*dev0;
    dt0_mean = (dt0_l0_0 + dt0_l0_1 + dt0_l0_2 + dt0_l0_3 + dt0_l0_4 + dt0_l0_5 + dt0_l0_6 + dt0_l0_7 + dt0_l0_8 + dt0_l0_9 + dt0_l0_10 + dt0_l0_11 + dt0_l0_12 + dt0_l0_13 + dt0_l0_14 + dt0_l0_15 + dt0_l0_16 + dt0_l0_17 + dt0_l0_18 + dt0_l0_19 + dt0_l0_20 + dt0_l0_21 + dt0_l0_22 + dt0_l0_23 + dt0_l0_24 + dt0_l0_25 + dt0_l0_26 + dt0_l0_27 + dt0_l0_28 + dt0_l0_29 + dt0_l0_30 + dt0_l0_31) / 32;
    dt0_var = (((dt0_l0_0) - dt0_mean)*((dt0_l0_0) - dt0_mean) + ((dt0_l0_1) - dt0_mean)*((dt0_l0_1) - dt0_mean) + ((dt0_l0_2) - dt0_mean)*((dt0_l0_2) - dt0_mean) + ((dt0_l0_3) - dt0_mean)*((dt0_l0_3) - dt0_mean) + ((dt0_l0_4) - dt0_mean)*((dt0_l0_4) - dt0_mean) + ((dt0_l0_5) - dt0_mean)*((dt0_l0_5) - dt0_mean) + ((dt0_l0_6) - dt0_mean)*((dt0_l0_6) - dt0_mean) + ((dt0_l0_7) - dt0_mean)*((dt0_l0_7) - dt0_mean) + ((dt0_l0_8) - dt0_mean)*((dt0_l0_8) - dt0_mean) + ((dt0_l0_9) - dt0_mean)*((dt0_l0_9) - dt0_mean) + ((dt0_l0_10) - dt0_mean)*((dt0_l0_10) - dt0_mean) + ((dt0_l0_11) - dt0_mean)*((dt0_l0_11) - dt0_mean) + ((dt0_l0_12) - dt0_mean)*((dt0_l0_12) - dt0_mean) + ((dt0_l0_13) - dt0_mean)*((dt0_l0_13) - dt0_mean) + ((dt0_l0_14) - dt0_mean)*((dt0_l0_14) - dt0_mean) + ((dt0_l0_15) - dt0_mean)*((dt0_l0_15) - dt0_mean) + ((dt0_l0_16) - dt0_mean)*((dt0_l0_16) - dt0_mean) + ((dt0_l0_17) - dt0_mean)*((dt0_l0_17) - dt0_mean) + ((dt0_l0_18) - dt0_mean)*((dt0_l0_18) - dt0_mean) + ((dt0_l0_19) - dt0_mean)*((dt0_l0_19) - dt0_mean) + ((dt0_l0_20) - dt0_mean)*((dt0_l0_20) - dt0_mean) + ((dt0_l0_21) - dt0_mean)*((dt0_l0_21) - dt0_mean) + ((dt0_l0_22) - dt0_mean)*((dt0_l0_22) - dt0_mean) + ((dt0_l0_23) - dt0_mean)*((dt0_l0_23) - dt0_mean) + ((dt0_l0_24) - dt0_mean)*((dt0_l0_24) - dt0_mean) + ((dt0_l0_25) - dt0_mean)*((dt0_l0_25) - dt0_mean) + ((dt0_l0_26) - dt0_mean)*((dt0_l0_26) - dt0_mean) + ((dt0_l0_27) - dt0_mean)*((dt0_l0_27) - dt0_mean) + ((dt0_l0_28) - dt0_mean)*((dt0_l0_28) - dt0_mean) + ((dt0_l0_29) - dt0_mean)*((dt0_l0_29) - dt0_mean) + ((dt0_l0_30) - dt0_mean)*((dt0_l0_30) - dt0_mean) + ((dt0_l0_31) - dt0_mean)*((dt0_l0_31) - dt0_mean)) / 32;
    dt0_n0_0 = (((dt0_l0_0) - dt0_mean) / sqrt(dt0_var + ln_eps)) * (0.843211829662323) + (0.10046378523111343);
    dt0_n0_1 = (((dt0_l0_1) - dt0_mean) / sqrt(dt0_var + ln_eps)) * (2.7206051527173258e-06) + (-1.6632851611575461e-06);
    dt0_n0_2 = (((dt0_l0_2) - dt0_mean) / sqrt(dt0_var + ln_eps)) * (-6.2584508668805938e-06) + (1.0455639767315006e-06);
    dt0_n0_3 = (((dt0_l0_3) - dt0_mean) / sqrt(dt0_var + ln_eps)) * (-6.9736793193442281e-06) + (-1.0999922778864857e-05);
    dt0_n0_4 = (((dt0_l0_4) - dt0_mean) / sqrt(dt0_var + ln_eps)) * (9.8267028079135343e-06) + (-6.5247531892964616e-06);
    dt0_n0_5 = (((dt0_l0_5) - dt0_mean) / sqrt(dt0_var + ln_eps)) * (0.27213570475578308) + (-0.0039989589713513851);
    dt0_n0_6 = (((dt0_l0_6) - dt0_mean) / sqrt(dt0_var + ln_eps)) * (-3.4977392715518363e-06) + (3.6835772210253026e-09);
    dt0_n0_7 = (((dt0_l0_7) - dt0_mean) / sqrt(dt0_var + ln_eps)) * (2.5401395760127343e-06) + (-7.8833654697518796e-06);
    dt0_n0_8 = (((dt0_l0_8) - dt0_mean) / sqrt(dt0_var + ln_eps)) * (4.0655754673935007e-06) + (-3.8788698475400452e-06);
    dt0_n0_9 = (((dt0_l0_9) - dt0_mean) / sqrt(dt0_var + ln_eps)) * (-4.6432196540990844e-06) + (7.3355377026018687e-06);
    dt0_n0_10 = (((dt0_l0_10) - dt0_mean) / sqrt(dt0_var + ln_eps)) * (3.574464471967076e-06) + (-2.2624096800427651e-06);
    dt0_n0_11 = (((dt0_l0_11) - dt0_mean) / sqrt(dt0_var + ln_eps)) * (1.3387105354922824e-05) + (2.8874530926259467e-06);
    dt0_n0_12 = (((dt0_l0_12) - dt0_mean) / sqrt(dt0_var + ln_eps)) * (-1.8776631804939825e-06) + (1.60305955887452e-06);
    dt0_n0_13 = (((dt0_l0_13) - dt0_mean) / sqrt(dt0_var + ln_eps)) * (1.0976241355820093e-06) + (-1.4980198557168478e-06);
    dt0_n0_14 = (((dt0_l0_14) - dt0_mean) / sqrt(dt0_var + ln_eps)) * (0.84664261341094971) + (-0.10655493289232254);
    dt0_n0_15 = (((dt0_l0_15) - dt0_mean) / sqrt(dt0_var + ln_eps)) * (2.9659940992132761e-06) + (1.6667630688971258e-06);
    dt0_n0_16 = (((dt0_l0_16) - dt0_mean) / sqrt(dt0_var + ln_eps)) * (1.0360937118530273) + (0.083679109811782837);
    dt0_n0_17 = (((dt0_l0_17) - dt0_mean) / sqrt(dt0_var + ln_eps)) * (-3.2341320093109971e-06) + (5.0602602641447447e-07);
    dt0_n0_18 = (((dt0_l0_18) - dt0_mean) / sqrt(dt0_var + ln_eps)) * (-6.2578095594290062e-07) + (-2.8663500870607095e-06);
    dt0_n0_19 = (((dt0_l0_19) - dt0_mean) / sqrt(dt0_var + ln_eps)) * (0.78893840312957764) + (-0.077350124716758728);
    dt0_n0_20 = (((dt0_l0_20) - dt0_mean) / sqrt(dt0_var + ln_eps)) * (4.0180102587328292e-06) + (-4.8921708639682038e-07);
    dt0_n0_21 = (((dt0_l0_21) - dt0_mean) / sqrt(dt0_var + ln_eps)) * (0.85818284749984741) + (-0.028547178953886032);
    dt0_n0_22 = (((dt0_l0_22) - dt0_mean) / sqrt(dt0_var + ln_eps)) * (0.83205467462539673) + (0.17346389591693878);
    dt0_n0_23 = (((dt0_l0_23) - dt0_mean) / sqrt(dt0_var + ln_eps)) * (1.504554438724881e-05) + (9.2961727204965428e-06);
    dt0_n0_24 = (((dt0_l0_24) - dt0_mean) / sqrt(dt0_var + ln_eps)) * (-1.26005252241157e-05) + (3.5688885873241816e-06);
    dt0_n0_25 = (((dt0_l0_25) - dt0_mean) / sqrt(dt0_var + ln_eps)) * (1.1577288205444347e-05) + (-4.1063835851673502e-06);
    dt0_n0_26 = (((dt0_l0_26) - dt0_mean) / sqrt(dt0_var + ln_eps)) * (-1.030867042572936e-05) + (3.3574026474525454e-06);
    dt0_n0_27 = (((dt0_l0_27) - dt0_mean) / sqrt(dt0_var + ln_eps)) * (8.7807520685601048e-06) + (-6.0104152908024844e-06);
    dt0_n0_28 = (((dt0_l0_28) - dt0_mean) / sqrt(dt0_var + ln_eps)) * (1.1751266356441192e-05) + (3.8589575979131041e-07);
    dt0_n0_29 = (((dt0_l0_29) - dt0_mean) / sqrt(dt0_var + ln_eps)) * (-1.6195903072002693e-06) + (3.1835461413720623e-06);
    dt0_n0_30 = (((dt0_l0_30) - dt0_mean) / sqrt(dt0_var + ln_eps)) * (-4.8718366087996401e-06) + (5.3302196647564415e-06);
    dt0_n0_31 = (((dt0_l0_31) - dt0_mean) / sqrt(dt0_var + ln_eps)) * (0.53329497575759888) + (-0.060209508985280991);
    dt0_g0_0 = gelu_approx(dt0_n0_0);
    dt0_g0_1 = gelu_approx(dt0_n0_1);
    dt0_g0_2 = gelu_approx(dt0_n0_2);
    dt0_g0_3 = gelu_approx(dt0_n0_3);
    dt0_g0_4 = gelu_approx(dt0_n0_4);
    dt0_g0_5 = gelu_approx(dt0_n0_5);
    dt0_g0_6 = gelu_approx(dt0_n0_6);
    dt0_g0_7 = gelu_approx(dt0_n0_7);
    dt0_g0_8 = gelu_approx(dt0_n0_8);
    dt0_g0_9 = gelu_approx(dt0_n0_9);
    dt0_g0_10 = gelu_approx(dt0_n0_10);
    dt0_g0_11 = gelu_approx(dt0_n0_11);
    dt0_g0_12 = gelu_approx(dt0_n0_12);
    dt0_g0_13 = gelu_approx(dt0_n0_13);
    dt0_g0_14 = gelu_approx(dt0_n0_14);
    dt0_g0_15 = gelu_approx(dt0_n0_15);
    dt0_g0_16 = gelu_approx(dt0_n0_16);
    dt0_g0_17 = gelu_approx(dt0_n0_17);
    dt0_g0_18 = gelu_approx(dt0_n0_18);
    dt0_g0_19 = gelu_approx(dt0_n0_19);
    dt0_g0_20 = gelu_approx(dt0_n0_20);
    dt0_g0_21 = gelu_approx(dt0_n0_21);
    dt0_g0_22 = gelu_approx(dt0_n0_22);
    dt0_g0_23 = gelu_approx(dt0_n0_23);
    dt0_g0_24 = gelu_approx(dt0_n0_24);
    dt0_g0_25 = gelu_approx(dt0_n0_25);
    dt0_g0_26 = gelu_approx(dt0_n0_26);
    dt0_g0_27 = gelu_approx(dt0_n0_27);
    dt0_g0_28 = gelu_approx(dt0_n0_28);
    dt0_g0_29 = gelu_approx(dt0_n0_29);
    dt0_g0_30 = gelu_approx(dt0_n0_30);
    dt0_g0_31 = gelu_approx(dt0_n0_31);
    dt0_l1_0 = 0.07863936573266983;
    dt0_l1_0 = dt0_l1_0 + (0.09521186351776123)*dt0_g0_0;
    dt0_l1_0 = dt0_l1_0 + (-2.6276595235685818e-05)*dt0_g0_1;
    dt0_l1_0 = dt0_l1_0 + (-2.5888028176268563e-05)*dt0_g0_2;
    dt0_l1_0 = dt0_l1_0 + (-5.9903377405134961e-05)*dt0_g0_3;
    dt0_l1_0 = dt0_l1_0 + (-3.0735114705748856e-05)*dt0_g0_4;
    dt0_l1_0 = dt0_l1_0 + (0.20419855415821075)*dt0_g0_5;
    dt0_l1_0 = dt0_l1_0 + (1.9859808162436821e-05)*dt0_g0_6;
    dt0_l1_0 = dt0_l1_0 + (-4.5337787014432251e-05)*dt0_g0_7;
    dt0_l1_0 = dt0_l1_0 + (-2.5618910513003357e-05)*dt0_g0_8;
    dt0_l1_0 = dt0_l1_0 + (3.65683481504675e-05)*dt0_g0_9;
    dt0_l1_0 = dt0_l1_0 + (8.6936415755189955e-06)*dt0_g0_10;
    dt0_l1_0 = dt0_l1_0 + (4.0928891394287348e-05)*dt0_g0_11;
    dt0_l1_0 = dt0_l1_0 + (-1.9896786398021504e-05)*dt0_g0_12;
    dt0_l1_0 = dt0_l1_0 + (-2.837985084624961e-05)*dt0_g0_13;
    dt0_l1_0 = dt0_l1_0 + (0.3629240095615387)*dt0_g0_14;
    dt0_l1_0 = dt0_l1_0 + (-9.6212206699419767e-06)*dt0_g0_15;
    dt0_l1_0 = dt0_l1_0 + (0.067542426288127899)*dt0_g0_16;
    dt0_l1_0 = dt0_l1_0 + (2.2813670511823148e-05)*dt0_g0_17;
    dt0_l1_0 = dt0_l1_0 + (-3.8062858948251233e-05)*dt0_g0_18;
    dt0_l1_0 = dt0_l1_0 + (0.0051724417135119438)*dt0_g0_19;
    dt0_l1_0 = dt0_l1_0 + (-1.3537222912418656e-05)*dt0_g0_20;
    dt0_l1_0 = dt0_l1_0 + (-0.32233437895774841)*dt0_g0_21;
    dt0_l1_0 = dt0_l1_0 + (-0.039486300200223923)*dt0_g0_22;
    dt0_l1_0 = dt0_l1_0 + (4.4735566916642711e-05)*dt0_g0_23;
    dt0_l1_0 = dt0_l1_0 + (2.3966475055203773e-05)*dt0_g0_24;
    dt0_l1_0 = dt0_l1_0 + (-3.0044160666875541e-05)*dt0_g0_25;
    dt0_l1_0 = dt0_l1_0 + (2.1940304577583447e-05)*dt0_g0_26;
    dt0_l1_0 = dt0_l1_0 + (-3.2977310183923692e-05)*dt0_g0_27;
    dt0_l1_0 = dt0_l1_0 + (1.5462126611964777e-05)*dt0_g0_28;
    dt0_l1_0 = dt0_l1_0 + (2.3663053070777096e-05)*dt0_g0_29;
    dt0_l1_0 = dt0_l1_0 + (3.0054983653826639e-05)*dt0_g0_30;
    dt0_l1_0 = dt0_l1_0 + (0.067137621343135834)*dt0_g0_31;
    dt0_l1_1 = -0.0092202415689826012;
    dt0_l1_1 = dt0_l1_1 + (0.0074171749874949455)*dt0_g0_0;
    dt0_l1_1 = dt0_l1_1 + (-4.7950475163816009e-06)*dt0_g0_1;
    dt0_l1_1 = dt0_l1_1 + (-3.4282065826118924e-06)*dt0_g0_2;
    dt0_l1_1 = dt0_l1_1 + (-1.1316158634144813e-05)*dt0_g0_3;
    dt0_l1_1 = dt0_l1_1 + (-5.4483066378452349e-06)*dt0_g0_4;
    dt0_l1_1 = dt0_l1_1 + (0.0012443787418305874)*dt0_g0_5;
    dt0_l1_1 = dt0_l1_1 + (3.5001457945327275e-06)*dt0_g0_6;
    dt0_l1_1 = dt0_l1_1 + (-7.4570029937603977e-06)*dt0_g0_7;
    dt0_l1_1 = dt0_l1_1 + (-6.29967280474375e-06)*dt0_g0_8;
    dt0_l1_1 = dt0_l1_1 + (7.0403816607722547e-06)*dt0_g0_9;
    dt0_l1_1 = dt0_l1_1 + (-3.6051681036042282e-06)*dt0_g0_10;
    dt0_l1_1 = dt0_l1_1 + (5.5118712225521449e-06)*dt0_g0_11;
    dt0_l1_1 = dt0_l1_1 + (-3.8914945434953552e-06)*dt0_g0_12;
    dt0_l1_1 = dt0_l1_1 + (-5.0223870857735164e-06)*dt0_g0_13;
    dt0_l1_1 = dt0_l1_1 + (0.011062460020184517)*dt0_g0_14;
    dt0_l1_1 = dt0_l1_1 + (-6.3501947806798853e-06)*dt0_g0_15;
    dt0_l1_1 = dt0_l1_1 + (0.0049811596982181072)*dt0_g0_16;
    dt0_l1_1 = dt0_l1_1 + (3.2094264952320373e-06)*dt0_g0_17;
    dt0_l1_1 = dt0_l1_1 + (-5.8456348597246688e-06)*dt0_g0_18;
    dt0_l1_1 = dt0_l1_1 + (-0.0062924828380346298)*dt0_g0_19;
    dt0_l1_1 = dt0_l1_1 + (-2.8774959446309367e-06)*dt0_g0_20;
    dt0_l1_1 = dt0_l1_1 + (-0.0077515658922493458)*dt0_g0_21;
    dt0_l1_1 = dt0_l1_1 + (0.022175149992108345)*dt0_g0_22;
    dt0_l1_1 = dt0_l1_1 + (2.4248131467174971e-06)*dt0_g0_23;
    dt0_l1_1 = dt0_l1_1 + (4.3025020204368047e-06)*dt0_g0_24;
    dt0_l1_1 = dt0_l1_1 + (-4.8939637053990737e-06)*dt0_g0_25;
    dt0_l1_1 = dt0_l1_1 + (3.7552931644313503e-06)*dt0_g0_26;
    dt0_l1_1 = dt0_l1_1 + (-5.4787583394499961e-06)*dt0_g0_27;
    dt0_l1_1 = dt0_l1_1 + (6.0630209191003814e-06)*dt0_g0_28;
    dt0_l1_1 = dt0_l1_1 + (5.0053927225235384e-06)*dt0_g0_29;
    dt0_l1_1 = dt0_l1_1 + (5.9157014220545534e-06)*dt0_g0_30;
    dt0_l1_1 = dt0_l1_1 + (-0.0013698715483769774)*dt0_g0_31;
    dt0_l1_2 = -0.054556742310523987;
    dt0_l1_2 = dt0_l1_2 + (-0.11475023627281189)*dt0_g0_0;
    dt0_l1_2 = dt0_l1_2 + (-2.2050206098356284e-05)*dt0_g0_1;
    dt0_l1_2 = dt0_l1_2 + (-2.3636228434043005e-05)*dt0_g0_2;
    dt0_l1_2 = dt0_l1_2 + (-4.0239618101622909e-05)*dt0_g0_3;
    dt0_l1_2 = dt0_l1_2 + (-2.4587043299106881e-05)*dt0_g0_4;
    dt0_l1_2 = dt0_l1_2 + (-0.081742040812969208)*dt0_g0_5;
    dt0_l1_2 = dt0_l1_2 + (1.778024306986481e-05)*dt0_g0_6;
    dt0_l1_2 = dt0_l1_2 + (-3.4487980883568525e-05)*dt0_g0_7;
    dt0_l1_2 = dt0_l1_2 + (-1.8637536413734779e-05)*dt0_g0_8;
    dt0_l1_2 = dt0_l1_2 + (2.5554181775078177e-05)*dt0_g0_9;
    dt0_l1_2 = dt0_l1_2 + (1.6197418517549522e-05)*dt0_g0_10;
    dt0_l1_2 = dt0_l1_2 + (2.9932547477073967e-05)*dt0_g0_11;
    dt0_l1_2 = dt0_l1_2 + (-1.8899074348155409e-05)*dt0_g0_12;
    dt0_l1_2 = dt0_l1_2 + (-2.3010863515082747e-05)*dt0_g0_13;
    dt0_l1_2 = dt0_l1_2 + (-0.091811060905456543)*dt0_g0_14;
    dt0_l1_2 = dt0_l1_2 + (-1.1534952136571519e-05)*dt0_g0_15;
    dt0_l1_2 = dt0_l1_2 + (-0.14485783874988556)*dt0_g0_16;
    dt0_l1_2 = dt0_l1_2 + (2.2519809135701507e-05)*dt0_g0_17;
    dt0_l1_2 = dt0_l1_2 + (-3.1300496630137786e-05)*dt0_g0_18;
    dt0_l1_2 = dt0_l1_2 + (-0.11977535486221313)*dt0_g0_19;
    dt0_l1_2 = dt0_l1_2 + (-1.1793315934482962e-05)*dt0_g0_20;
    dt0_l1_2 = dt0_l1_2 + (0.25181648135185242)*dt0_g0_21;
    dt0_l1_2 = dt0_l1_2 + (-0.20050008594989777)*dt0_g0_22;
    dt0_l1_2 = dt0_l1_2 + (3.3441781852161512e-05)*dt0_g0_23;
    dt0_l1_2 = dt0_l1_2 + (2.4673528969287872e-05)*dt0_g0_24;
    dt0_l1_2 = dt0_l1_2 + (-2.8681350158876739e-05)*dt0_g0_25;
    dt0_l1_2 = dt0_l1_2 + (1.8679962522583082e-05)*dt0_g0_26;
    dt0_l1_2 = dt0_l1_2 + (-2.4577928343205713e-05)*dt0_g0_27;
    dt0_l1_2 = dt0_l1_2 + (2.2437554889620515e-06)*dt0_g0_28;
    dt0_l1_2 = dt0_l1_2 + (1.5454967069672421e-05)*dt0_g0_29;
    dt0_l1_2 = dt0_l1_2 + (2.1073970856377855e-05)*dt0_g0_30;
    dt0_l1_2 = dt0_l1_2 + (0.28076320886611938)*dt0_g0_31;
    dt0_l1_3 = 0.0069250846281647682;
    dt0_l1_3 = dt0_l1_3 + (-0.20002850890159607)*dt0_g0_0;
    dt0_l1_3 = dt0_l1_3 + (0.00012122812040615827)*dt0_g0_1;
    dt0_l1_3 = dt0_l1_3 + (0.00010440648475196213)*dt0_g0_2;
    dt0_l1_3 = dt0_l1_3 + (0.00020597409456968307)*dt0_g0_3;
    dt0_l1_3 = dt0_l1_3 + (0.0001197444653371349)*dt0_g0_4;
    dt0_l1_3 = dt0_l1_3 + (0.11727102845907211)*dt0_g0_5;
    dt0_l1_3 = dt0_l1_3 + (-0.0001155518984887749)*dt0_g0_6;
    dt0_l1_3 = dt0_l1_3 + (0.00015998477465473115)*dt0_g0_7;
    dt0_l1_3 = dt0_l1_3 + (0.00013909452536609024)*dt0_g0_8;
    dt0_l1_3 = dt0_l1_3 + (-0.00017011263116728514)*dt0_g0_9;
    dt0_l1_3 = dt0_l1_3 + (5.9865098592126742e-05)*dt0_g0_10;
    dt0_l1_3 = dt0_l1_3 + (-0.00015404204896185547)*dt0_g0_11;
    dt0_l1_3 = dt0_l1_3 + (9.32334951357916e-05)*dt0_g0_12;
    dt0_l1_3 = dt0_l1_3 + (0.000120447417430114)*dt0_g0_13;
    dt0_l1_3 = dt0_l1_3 + (-0.083557084202766418)*dt0_g0_14;
    dt0_l1_3 = dt0_l1_3 + (4.2947609472321346e-05)*dt0_g0_15;
    dt0_l1_3 = dt0_l1_3 + (0.093954339623451233)*dt0_g0_16;
    dt0_l1_3 = dt0_l1_3 + (-3.5744946217164397e-05)*dt0_g0_17;
    dt0_l1_3 = dt0_l1_3 + (0.00013965979451313615)*dt0_g0_18;
    dt0_l1_3 = dt0_l1_3 + (0.23021359741687775)*dt0_g0_19;
    dt0_l1_3 = dt0_l1_3 + (7.7469136158470064e-05)*dt0_g0_20;
    dt0_l1_3 = dt0_l1_3 + (0.25050327181816101)*dt0_g0_21;
    dt0_l1_3 = dt0_l1_3 + (0.061861880123615265)*dt0_g0_22;
    dt0_l1_3 = dt0_l1_3 + (-7.4739029514603317e-05)*dt0_g0_23;
    dt0_l1_3 = dt0_l1_3 + (-4.0087521483656019e-05)*dt0_g0_24;
    dt0_l1_3 = dt0_l1_3 + (0.00010163952538277954)*dt0_g0_25;
    dt0_l1_3 = dt0_l1_3 + (-0.00011079228715971112)*dt0_g0_26;
    dt0_l1_3 = dt0_l1_3 + (0.00015467824414372444)*dt0_g0_27;
    dt0_l1_3 = dt0_l1_3 + (-0.00013554334873333573)*dt0_g0_28;
    dt0_l1_3 = dt0_l1_3 + (-0.00012356755905784667)*dt0_g0_29;
    dt0_l1_3 = dt0_l1_3 + (-0.00015409041952807456)*dt0_g0_30;
    dt0_l1_3 = dt0_l1_3 + (-0.16506032645702362)*dt0_g0_31;
    dt0_l1_4 = -0.009220244362950325;
    dt0_l1_4 = dt0_l1_4 + (0.0074171894229948521)*dt0_g0_0;
    dt0_l1_4 = dt0_l1_4 + (-4.7950984480849002e-06)*dt0_g0_1;
    dt0_l1_4 = dt0_l1_4 + (-3.4282509204786038e-06)*dt0_g0_2;
    dt0_l1_4 = dt0_l1_4 + (-1.131618773797527e-05)*dt0_g0_3;
    dt0_l1_4 = dt0_l1_4 + (-5.4483616622746922e-06)*dt0_g0_4;
    dt0_l1_4 = dt0_l1_4 + (0.0012444290332496166)*dt0_g0_5;
    dt0_l1_4 = dt0_l1_4 + (3.5001980904780794e-06)*dt0_g0_6;
    dt0_l1_4 = dt0_l1_4 + (-7.4570571086951531e-06)*dt0_g0_7;
    dt0_l1_4 = dt0_l1_4 + (-6.299732831394067e-06)*dt0_g0_8;
    dt0_l1_4 = dt0_l1_4 + (7.0404253165179398e-06)*dt0_g0_9;
    dt0_l1_4 = dt0_l1_4 + (-3.6051631013833685e-06)*dt0_g0_10;
    dt0_l1_4 = dt0_l1_4 + (5.5119116950663738e-06)*dt0_g0_11;
    dt0_l1_4 = dt0_l1_4 + (-3.8915482036827598e-06)*dt0_g0_12;
    dt0_l1_4 = dt0_l1_4 + (-5.0224366532347631e-06)*dt0_g0_13;
    dt0_l1_4 = dt0_l1_4 + (0.011062382720410824)*dt0_g0_14;
    dt0_l1_4 = dt0_l1_4 + (-6.350232069962658e-06)*dt0_g0_15;
    dt0_l1_4 = dt0_l1_4 + (0.0049811564385890961)*dt0_g0_16;
    dt0_l1_4 = dt0_l1_4 + (3.2094562811835203e-06)*dt0_g0_17;
    dt0_l1_4 = dt0_l1_4 + (-5.845689884154126e-06)*dt0_g0_18;
    dt0_l1_4 = dt0_l1_4 + (-0.006292473990470171)*dt0_g0_19;
    dt0_l1_4 = dt0_l1_4 + (-2.8775357350241393e-06)*dt0_g0_20;
    dt0_l1_4 = dt0_l1_4 + (-0.0077515956945717335)*dt0_g0_21;
    dt0_l1_4 = dt0_l1_4 + (0.022175129503011703)*dt0_g0_22;
    dt0_l1_4 = dt0_l1_4 + (2.4248633962997701e-06)*dt0_g0_23;
    dt0_l1_4 = dt0_l1_4 + (4.3025429476983845e-06)*dt0_g0_24;
    dt0_l1_4 = dt0_l1_4 + (-4.8940241867967416e-06)*dt0_g0_25;
    dt0_l1_4 = dt0_l1_4 + (3.7553436413872987e-06)*dt0_g0_26;
    dt0_l1_4 = dt0_l1_4 + (-5.4788001762062777e-06)*dt0_g0_27;
    dt0_l1_4 = dt0_l1_4 + (6.0630350162682589e-06)*dt0_g0_28;
    dt0_l1_4 = dt0_l1_4 + (5.0054395615006797e-06)*dt0_g0_29;
    dt0_l1_4 = dt0_l1_4 + (5.9157500800210983e-06)*dt0_g0_30;
    dt0_l1_4 = dt0_l1_4 + (-0.0013698672410100698)*dt0_g0_31;
    dt0_l1_5 = -0.010299425572156906;
    dt0_l1_5 = dt0_l1_5 + (-0.019222021102905273)*dt0_g0_0;
    dt0_l1_5 = dt0_l1_5 + (-1.0141934581042733e-05)*dt0_g0_1;
    dt0_l1_5 = dt0_l1_5 + (-3.5136697533744154e-06)*dt0_g0_2;
    dt0_l1_5 = dt0_l1_5 + (3.7071269616717473e-05)*dt0_g0_3;
    dt0_l1_5 = dt0_l1_5 + (-2.195977913288516e-06)*dt0_g0_4;
    dt0_l1_5 = dt0_l1_5 + (-0.0010503833182156086)*dt0_g0_5;
    dt0_l1_5 = dt0_l1_5 + (7.927470505819656e-06)*dt0_g0_6;
    dt0_l1_5 = dt0_l1_5 + (1.3052414942649193e-05)*dt0_g0_7;
    dt0_l1_5 = dt0_l1_5 + (4.0837808228388894e-06)*dt0_g0_8;
    dt0_l1_5 = dt0_l1_5 + (-9.3975322670303285e-06)*dt0_g0_9;
    dt0_l1_5 = dt0_l1_5 + (-3.5394165024627e-05)*dt0_g0_10;
    dt0_l1_5 = dt0_l1_5 + (-1.9062243154621683e-05)*dt0_g0_11;
    dt0_l1_5 = dt0_l1_5 + (-1.4862144780636299e-05)*dt0_g0_12;
    dt0_l1_5 = dt0_l1_5 + (-9.2636173576465808e-06)*dt0_g0_13;
    dt0_l1_5 = dt0_l1_5 + (-0.097159318625926971)*dt0_g0_14;
    dt0_l1_5 = dt0_l1_5 + (2.0512221453827806e-05)*dt0_g0_15;
    dt0_l1_5 = dt0_l1_5 + (0.2089591771364212)*dt0_g0_16;
    dt0_l1_5 = dt0_l1_5 + (-2.2365591121342732e-06)*dt0_g0_17;
    dt0_l1_5 = dt0_l1_5 + (7.9388446465600282e-06)*dt0_g0_18;
    dt0_l1_5 = dt0_l1_5 + (-0.042912889271974564)*dt0_g0_19;
    dt0_l1_5 = dt0_l1_5 + (-2.026791207754286e-06)*dt0_g0_20;
    dt0_l1_5 = dt0_l1_5 + (-0.073992572724819183)*dt0_g0_21;
    dt0_l1_5 = dt0_l1_5 + (0.047116514295339584)*dt0_g0_22;
    dt0_l1_5 = dt0_l1_5 + (-0.00010094667959492654)*dt0_g0_23;
    dt0_l1_5 = dt0_l1_5 + (-4.6528043640137184e-06)*dt0_g0_24;
    dt0_l1_5 = dt0_l1_5 + (-1.2978689483134076e-05)*dt0_g0_25;
    dt0_l1_5 = dt0_l1_5 + (9.7785505204228684e-06)*dt0_g0_26;
    dt0_l1_5 = dt0_l1_5 + (4.0318846004083753e-06)*dt0_g0_27;
    dt0_l1_5 = dt0_l1_5 + (-2.9880278816563077e-05)*dt0_g0_28;
    dt0_l1_5 = dt0_l1_5 + (-8.4235762187745422e-06)*dt0_g0_29;
    dt0_l1_5 = dt0_l1_5 + (-4.9168957048095763e-06)*dt0_g0_30;
    dt0_l1_5 = dt0_l1_5 + (0.14125142991542816)*dt0_g0_31;
    dt0_l1_6 = -0.1312904953956604;
    dt0_l1_6 = dt0_l1_6 + (0.37175250053405762)*dt0_g0_0;
    dt0_l1_6 = dt0_l1_6 + (4.33431523561012e-06)*dt0_g0_1;
    dt0_l1_6 = dt0_l1_6 + (2.5241517960239435e-06)*dt0_g0_2;
    dt0_l1_6 = dt0_l1_6 + (-1.1879010344273411e-05)*dt0_g0_3;
    dt0_l1_6 = dt0_l1_6 + (1.5745153802981804e-07)*dt0_g0_4;
    dt0_l1_6 = dt0_l1_6 + (-0.0010415823198854923)*dt0_g0_5;
    dt0_l1_6 = dt0_l1_6 + (-9.7839092632057145e-06)*dt0_g0_6;
    dt0_l1_6 = dt0_l1_6 + (-2.3084953681973275e-06)*dt0_g0_7;
    dt0_l1_6 = dt0_l1_6 + (7.4807148848776706e-06)*dt0_g0_8;
    dt0_l1_6 = dt0_l1_6 + (-3.9429028220183682e-06)*dt0_g0_9;
    dt0_l1_6 = dt0_l1_6 + (1.4638950233347714e-05)*dt0_g0_10;
    dt0_l1_6 = dt0_l1_6 + (1.5910354704828933e-06)*dt0_g0_11;
    dt0_l1_6 = dt0_l1_6 + (4.8954902922559995e-06)*dt0_g0_12;
    dt0_l1_6 = dt0_l1_6 + (1.329232873104047e-06)*dt0_g0_13;
    dt0_l1_6 = dt0_l1_6 + (0.06737133115530014)*dt0_g0_14;
    dt0_l1_6 = dt0_l1_6 + (4.4838479880127124e-06)*dt0_g0_15;
    dt0_l1_6 = dt0_l1_6 + (0.1200924813747406)*dt0_g0_16;
    dt0_l1_6 = dt0_l1_6 + (1.022621199808782e-05)*dt0_g0_17;
    dt0_l1_6 = dt0_l1_6 + (-6.015204121467832e-07)*dt0_g0_18;
    dt0_l1_6 = dt0_l1_6 + (-0.1717676967382431)*dt0_g0_19;
    dt0_l1_6 = dt0_l1_6 + (5.7488582569931168e-06)*dt0_g0_20;
    dt0_l1_6 = dt0_l1_6 + (-0.51570415496826172)*dt0_g0_21;
    dt0_l1_6 = dt0_l1_6 + (0.25729447603225708)*dt0_g0_22;
    dt0_l1_6 = dt0_l1_6 + (1.7876456695375964e-05)*dt0_g0_23;
    dt0_l1_6 = dt0_l1_6 + (7.6119772529636975e-06)*dt0_g0_24;
    dt0_l1_6 = dt0_l1_6 + (8.7904209067346528e-07)*dt0_g0_25;
    dt0_l1_6 = dt0_l1_6 + (-5.5410837376257405e-06)*dt0_g0_26;
    dt0_l1_6 = dt0_l1_6 + (4.990774868929293e-06)*dt0_g0_27;
    dt0_l1_6 = dt0_l1_6 + (-1.391522164340131e-05)*dt0_g0_28;
    dt0_l1_6 = dt0_l1_6 + (-2.9012385311943945e-06)*dt0_g0_29;
    dt0_l1_6 = dt0_l1_6 + (-6.6828770286520012e-06)*dt0_g0_30;
    dt0_l1_6 = dt0_l1_6 + (-0.1837390661239624)*dt0_g0_31;
    dt0_l1_7 = -0.0092202471569180489;
    dt0_l1_7 = dt0_l1_7 + (0.0074172001332044601)*dt0_g0_0;
    dt0_l1_7 = dt0_l1_7 + (-4.7951166379789356e-06)*dt0_g0_1;
    dt0_l1_7 = dt0_l1_7 + (-3.4282647902728058e-06)*dt0_g0_2;
    dt0_l1_7 = dt0_l1_7 + (-1.1316169548081234e-05)*dt0_g0_3;
    dt0_l1_7 = dt0_l1_7 + (-5.4483793974213768e-06)*dt0_g0_4;
    dt0_l1_7 = dt0_l1_7 + (0.0012444410240277648)*dt0_g0_5;
    dt0_l1_7 = dt0_l1_7 + (3.500225602692808e-06)*dt0_g0_6;
    dt0_l1_7 = dt0_l1_7 + (-7.4570561992004514e-06)*dt0_g0_7;
    dt0_l1_7 = dt0_l1_7 + (-6.299752840277506e-06)*dt0_g0_8;
    dt0_l1_7 = dt0_l1_7 + (7.0404362304543611e-06)*dt0_g0_9;
    dt0_l1_7 = dt0_l1_7 + (-3.6051565075467806e-06)*dt0_g0_10;
    dt0_l1_7 = dt0_l1_7 + (5.511910785571672e-06)*dt0_g0_11;
    dt0_l1_7 = dt0_l1_7 + (-3.8915704863029532e-06)*dt0_g0_12;
    dt0_l1_7 = dt0_l1_7 + (-5.022457116865553e-06)*dt0_g0_13;
    dt0_l1_7 = dt0_l1_7 + (0.011062324047088623)*dt0_g0_14;
    dt0_l1_7 = dt0_l1_7 + (-6.3502366174361669e-06)*dt0_g0_15;
    dt0_l1_7 = dt0_l1_7 + (0.0049811298958957195)*dt0_g0_16;
    dt0_l1_7 = dt0_l1_7 + (3.2094646940095117e-06)*dt0_g0_17;
    dt0_l1_7 = dt0_l1_7 + (-5.8456971601117402e-06)*dt0_g0_18;
    dt0_l1_7 = dt0_l1_7 + (-0.0062924656085669994)*dt0_g0_19;
    dt0_l1_7 = dt0_l1_7 + (-2.8775493774446659e-06)*dt0_g0_20;
    dt0_l1_7 = dt0_l1_7 + (-0.0077516557648777962)*dt0_g0_21;
    dt0_l1_7 = dt0_l1_7 + (0.022175146266818047)*dt0_g0_22;
    dt0_l1_7 = dt0_l1_7 + (2.4248424779216293e-06)*dt0_g0_23;
    dt0_l1_7 = dt0_l1_7 + (4.3025506784033496e-06)*dt0_g0_24;
    dt0_l1_7 = dt0_l1_7 + (-4.8940369197225664e-06)*dt0_g0_25;
    dt0_l1_7 = dt0_l1_7 + (3.7553681977442466e-06)*dt0_g0_26;
    dt0_l1_7 = dt0_l1_7 + (-5.4788124543847516e-06)*dt0_g0_27;
    dt0_l1_7 = dt0_l1_7 + (6.0630140978901181e-06)*dt0_g0_28;
    dt0_l1_7 = dt0_l1_7 + (5.0054572966473643e-06)*dt0_g0_29;
    dt0_l1_7 = dt0_l1_7 + (5.9157628129469231e-06)*dt0_g0_30;
    dt0_l1_7 = dt0_l1_7 + (-0.001369859091937542)*dt0_g0_31;
    dt0_l1_8 = 0.020557314157485962;
    dt0_l1_8 = dt0_l1_8 + (-0.02749934047460556)*dt0_g0_0;
    dt0_l1_8 = dt0_l1_8 + (4.5106888137524948e-05)*dt0_g0_1;
    dt0_l1_8 = dt0_l1_8 + (3.0896659154677764e-05)*dt0_g0_2;
    dt0_l1_8 = dt0_l1_8 + (3.470234150881879e-05)*dt0_g0_3;
    dt0_l1_8 = dt0_l1_8 + (3.6544974136631936e-05)*dt0_g0_4;
    dt0_l1_8 = dt0_l1_8 + (0.036568496376276016)*dt0_g0_5;
    dt0_l1_8 = dt0_l1_8 + (-2.9665154215763323e-05)*dt0_g0_6;
    dt0_l1_8 = dt0_l1_8 + (5.0898033805424348e-05)*dt0_g0_7;
    dt0_l1_8 = dt0_l1_8 + (4.1536517528584227e-05)*dt0_g0_8;
    dt0_l1_8 = dt0_l1_8 + (-3.6097739211982116e-05)*dt0_g0_9;
    dt0_l1_8 = dt0_l1_8 + (6.7573055275715888e-05)*dt0_g0_10;
    dt0_l1_8 = dt0_l1_8 + (-3.7935555155854672e-05)*dt0_g0_11;
    dt0_l1_8 = dt0_l1_8 + (4.3670381273841485e-05)*dt0_g0_12;
    dt0_l1_8 = dt0_l1_8 + (3.9244692743523046e-05)*dt0_g0_13;
    dt0_l1_8 = dt0_l1_8 + (-0.11672371625900269)*dt0_g0_14;
    dt0_l1_8 = dt0_l1_8 + (1.1185228686372284e-05)*dt0_g0_15;
    dt0_l1_8 = dt0_l1_8 + (0.17020195722579956)*dt0_g0_16;
    dt0_l1_8 = dt0_l1_8 + (1.007986611512024e-05)*dt0_g0_17;
    dt0_l1_8 = dt0_l1_8 + (3.2511354220332578e-05)*dt0_g0_18;
    dt0_l1_8 = dt0_l1_8 + (-0.16241995990276337)*dt0_g0_19;
    dt0_l1_8 = dt0_l1_8 + (2.8980930437683128e-05)*dt0_g0_20;
    dt0_l1_8 = dt0_l1_8 + (0.1997077465057373)*dt0_g0_21;
    dt0_l1_8 = dt0_l1_8 + (-0.093216530978679657)*dt0_g0_22;
    dt0_l1_8 = dt0_l1_8 + (4.9495127996124211e-07)*dt0_g0_23;
    dt0_l1_8 = dt0_l1_8 + (8.4393386714509688e-06)*dt0_g0_24;
    dt0_l1_8 = dt0_l1_8 + (3.7210011214483529e-05)*dt0_g0_25;
    dt0_l1_8 = dt0_l1_8 + (-3.6352652386995032e-05)*dt0_g0_26;
    dt0_l1_8 = dt0_l1_8 + (3.4836764825740829e-05)*dt0_g0_27;
    dt0_l1_8 = dt0_l1_8 + (-4.8265545046888292e-05)*dt0_g0_28;
    dt0_l1_8 = dt0_l1_8 + (-3.795682277996093e-05)*dt0_g0_29;
    dt0_l1_8 = dt0_l1_8 + (-4.3928794184466824e-05)*dt0_g0_30;
    dt0_l1_8 = dt0_l1_8 + (-0.12958551943302155)*dt0_g0_31;
    dt0_l1_9 = -0.0092202425003051758;
    dt0_l1_9 = dt0_l1_9 + (0.0074171698652207851)*dt0_g0_0;
    dt0_l1_9 = dt0_l1_9 + (-4.7950575208233204e-06)*dt0_g0_1;
    dt0_l1_9 = dt0_l1_9 + (-3.4282215892744716e-06)*dt0_g0_2;
    dt0_l1_9 = dt0_l1_9 + (-1.1316167729091831e-05)*dt0_g0_3;
    dt0_l1_9 = dt0_l1_9 + (-5.4483211897604633e-06)*dt0_g0_4;
    dt0_l1_9 = dt0_l1_9 + (0.0012443937594071031)*dt0_g0_5;
    dt0_l1_9 = dt0_l1_9 + (3.5001571632164996e-06)*dt0_g0_6;
    dt0_l1_9 = dt0_l1_9 + (-7.4570170909282751e-06)*dt0_g0_7;
    dt0_l1_9 = dt0_l1_9 + (-6.2996896303957328e-06)*dt0_g0_8;
    dt0_l1_9 = dt0_l1_9 + (7.0403862082457636e-06)*dt0_g0_9;
    dt0_l1_9 = dt0_l1_9 + (-3.6051455936103594e-06)*dt0_g0_10;
    dt0_l1_9 = dt0_l1_9 + (5.5118821364885662e-06)*dt0_g0_11;
    dt0_l1_9 = dt0_l1_9 + (-3.8915086406632327e-06)*dt0_g0_12;
    dt0_l1_9 = dt0_l1_9 + (-5.0223939069837797e-06)*dt0_g0_13;
    dt0_l1_9 = dt0_l1_9 + (0.011062433011829853)*dt0_g0_14;
    dt0_l1_9 = dt0_l1_9 + (-6.350199782900745e-06)*dt0_g0_15;
    dt0_l1_9 = dt0_l1_9 + (0.0049811415374279022)*dt0_g0_16;
    dt0_l1_9 = dt0_l1_9 + (3.2094371817947831e-06)*dt0_g0_17;
    dt0_l1_9 = dt0_l1_9 + (-5.8456557781028096e-06)*dt0_g0_18;
    dt0_l1_9 = dt0_l1_9 + (-0.0062924628145992756)*dt0_g0_19;
    dt0_l1_9 = dt0_l1_9 + (-2.8775123155355686e-06)*dt0_g0_20;
    dt0_l1_9 = dt0_l1_9 + (-0.0077515621669590473)*dt0_g0_21;
    dt0_l1_9 = dt0_l1_9 + (0.022175146266818047)*dt0_g0_22;
    dt0_l1_9 = dt0_l1_9 + (2.4248686258943053e-06)*dt0_g0_23;
    dt0_l1_9 = dt0_l1_9 + (4.3025188460887875e-06)*dt0_g0_24;
    dt0_l1_9 = dt0_l1_9 + (-4.8939868975139689e-06)*dt0_g0_25;
    dt0_l1_9 = dt0_l1_9 + (3.7553047604887979e-06)*dt0_g0_26;
    dt0_l1_9 = dt0_l1_9 + (-5.4787642511655577e-06)*dt0_g0_27;
    dt0_l1_9 = dt0_l1_9 + (6.0630191001109779e-06)*dt0_g0_28;
    dt0_l1_9 = dt0_l1_9 + (5.0054045459546614e-06)*dt0_g0_29;
    dt0_l1_9 = dt0_l1_9 + (5.9157059695280623e-06)*dt0_g0_30;
    dt0_l1_9 = dt0_l1_9 + (-0.0013698835391551256)*dt0_g0_31;
    dt0_l1_10 = -0.0092202359810471535;
    dt0_l1_10 = dt0_l1_10 + (0.0074171759188175201)*dt0_g0_0;
    dt0_l1_10 = dt0_l1_10 + (-4.7950411499186885e-06)*dt0_g0_1;
    dt0_l1_10 = dt0_l1_10 + (-3.4281986245332519e-06)*dt0_g0_2;
    dt0_l1_10 = dt0_l1_10 + (-1.1316120435367338e-05)*dt0_g0_3;
    dt0_l1_10 = dt0_l1_10 + (-5.4482907216879539e-06)*dt0_g0_4;
    dt0_l1_10 = dt0_l1_10 + (0.0012443602317944169)*dt0_g0_5;
    dt0_l1_10 = dt0_l1_10 + (3.5001487503905082e-06)*dt0_g0_6;
    dt0_l1_10 = dt0_l1_10 + (-7.4569761636666954e-06)*dt0_g0_7;
    dt0_l1_10 = dt0_l1_10 + (-6.2996518863656092e-06)*dt0_g0_8;
    dt0_l1_10 = dt0_l1_10 + (7.0403648351202719e-06)*dt0_g0_9;
    dt0_l1_10 = dt0_l1_10 + (-3.6051535516889999e-06)*dt0_g0_10;
    dt0_l1_10 = dt0_l1_10 + (5.5118475756898988e-06)*dt0_g0_11;
    dt0_l1_10 = dt0_l1_10 + (-3.8914909055165481e-06)*dt0_g0_12;
    dt0_l1_10 = dt0_l1_10 + (-5.0223793550685514e-06)*dt0_g0_13;
    dt0_l1_10 = dt0_l1_10 + (0.011062489822506905)*dt0_g0_14;
    dt0_l1_10 = dt0_l1_10 + (-6.3502006923954468e-06)*dt0_g0_15;
    dt0_l1_10 = dt0_l1_10 + (0.0049811867065727711)*dt0_g0_16;
    dt0_l1_10 = dt0_l1_10 + (3.209429451089818e-06)*dt0_g0_17;
    dt0_l1_10 = dt0_l1_10 + (-5.8456148508412298e-06)*dt0_g0_18;
    dt0_l1_10 = dt0_l1_10 + (-0.0062924814410507679)*dt0_g0_19;
    dt0_l1_10 = dt0_l1_10 + (-2.8774877591786208e-06)*dt0_g0_20;
    dt0_l1_10 = dt0_l1_10 + (-0.0077515454031527042)*dt0_g0_21;
    dt0_l1_10 = dt0_l1_10 + (0.0221751369535923)*dt0_g0_22;
    dt0_l1_10 = dt0_l1_10 + (2.4247860892501194e-06)*dt0_g0_23;
    dt0_l1_10 = dt0_l1_10 + (4.3025074774050154e-06)*dt0_g0_24;
    dt0_l1_10 = dt0_l1_10 + (-4.8939550651994068e-06)*dt0_g0_25;
    dt0_l1_10 = dt0_l1_10 + (3.7552933918050257e-06)*dt0_g0_26;
    dt0_l1_10 = dt0_l1_10 + (-5.478746970766224e-06)*dt0_g0_27;
    dt0_l1_10 = dt0_l1_10 + (6.0629840845649596e-06)*dt0_g0_28;
    dt0_l1_10 = dt0_l1_10 + (5.0053731683874503e-06)*dt0_g0_29;
    dt0_l1_10 = dt0_l1_10 + (5.9156841416552197e-06)*dt0_g0_30;
    dt0_l1_10 = dt0_l1_10 + (-0.0013698776019737124)*dt0_g0_31;
    dt0_l1_11 = -0.031666874885559082;
    dt0_l1_11 = dt0_l1_11 + (-0.0090516367927193642)*dt0_g0_0;
    dt0_l1_11 = dt0_l1_11 + (-3.6104283935856074e-06)*dt0_g0_1;
    dt0_l1_11 = dt0_l1_11 + (3.3615731354075251e-06)*dt0_g0_2;
    dt0_l1_11 = dt0_l1_11 + (-2.9356197046581656e-05)*dt0_g0_3;
    dt0_l1_11 = dt0_l1_11 + (-4.9025970838556532e-06)*dt0_g0_4;
    dt0_l1_11 = dt0_l1_11 + (0.032653413712978363)*dt0_g0_5;
    dt0_l1_11 = dt0_l1_11 + (-1.1354838534316514e-05)*dt0_g0_6;
    dt0_l1_11 = dt0_l1_11 + (-2.8711381219181931e-06)*dt0_g0_7;
    dt0_l1_11 = dt0_l1_11 + (1.7906284028867958e-06)*dt0_g0_8;
    dt0_l1_11 = dt0_l1_11 + (-2.0090806174266618e-06)*dt0_g0_9;
    dt0_l1_11 = dt0_l1_11 + (-3.0071541914367117e-05)*dt0_g0_10;
    dt0_l1_11 = dt0_l1_11 + (4.3423965507827234e-06)*dt0_g0_11;
    dt0_l1_11 = dt0_l1_11 + (-2.758038135652896e-06)*dt0_g0_12;
    dt0_l1_11 = dt0_l1_11 + (-7.9959409049479291e-06)*dt0_g0_13;
    dt0_l1_11 = dt0_l1_11 + (-0.20774281024932861)*dt0_g0_14;
    dt0_l1_11 = dt0_l1_11 + (2.0053932530572638e-05)*dt0_g0_15;
    dt0_l1_11 = dt0_l1_11 + (-0.52271997928619385)*dt0_g0_16;
    dt0_l1_11 = dt0_l1_11 + (1.244521513399377e-06)*dt0_g0_17;
    dt0_l1_11 = dt0_l1_11 + (6.2670633269590326e-06)*dt0_g0_18;
    dt0_l1_11 = dt0_l1_11 + (-0.14912067353725433)*dt0_g0_19;
    dt0_l1_11 = dt0_l1_11 + (1.7956307374333846e-06)*dt0_g0_20;
    dt0_l1_11 = dt0_l1_11 + (0.013506163842976093)*dt0_g0_21;
    dt0_l1_11 = dt0_l1_11 + (0.22161626815795898)*dt0_g0_22;
    dt0_l1_11 = dt0_l1_11 + (6.394238425855292e-06)*dt0_g0_23;
    dt0_l1_11 = dt0_l1_11 + (-9.9945018519065343e-06)*dt0_g0_24;
    dt0_l1_11 = dt0_l1_11 + (8.6194522737059742e-06)*dt0_g0_25;
    dt0_l1_11 = dt0_l1_11 + (1.6400816775785643e-06)*dt0_g0_26;
    dt0_l1_11 = dt0_l1_11 + (4.8755159696156625e-06)*dt0_g0_27;
    dt0_l1_11 = dt0_l1_11 + (1.2272440471861046e-05)*dt0_g0_28;
    dt0_l1_11 = dt0_l1_11 + (1.5524121408816427e-05)*dt0_g0_29;
    dt0_l1_11 = dt0_l1_11 + (-2.8816376129725541e-07)*dt0_g0_30;
    dt0_l1_11 = dt0_l1_11 + (0.033976655453443527)*dt0_g0_31;
    dt0_l1_12 = -0.0062166904099285603;
    dt0_l1_12 = dt0_l1_12 + (-0.20158196985721588)*dt0_g0_0;
    dt0_l1_12 = dt0_l1_12 + (-2.5460631150053814e-05)*dt0_g0_1;
    dt0_l1_12 = dt0_l1_12 + (-1.2765068277076352e-05)*dt0_g0_2;
    dt0_l1_12 = dt0_l1_12 + (-5.9611073083942756e-05)*dt0_g0_3;
    dt0_l1_12 = dt0_l1_12 + (-2.8436412321752869e-05)*dt0_g0_4;
    dt0_l1_12 = dt0_l1_12 + (-0.070834442973136902)*dt0_g0_5;
    dt0_l1_12 = dt0_l1_12 + (1.9341910956427455e-05)*dt0_g0_6;
    dt0_l1_12 = dt0_l1_12 + (-1.7865977497422136e-05)*dt0_g0_7;
    dt0_l1_12 = dt0_l1_12 + (-3.0507761039189063e-05)*dt0_g0_8;
    dt0_l1_12 = dt0_l1_12 + (3.4206932468805462e-05)*dt0_g0_9;
    dt0_l1_12 = dt0_l1_12 + (-4.9364174628863111e-05)*dt0_g0_10;
    dt0_l1_12 = dt0_l1_12 + (2.2953419829718769e-05)*dt0_g0_11;
    dt0_l1_12 = dt0_l1_12 + (-1.7751313862390816e-05)*dt0_g0_12;
    dt0_l1_12 = dt0_l1_12 + (-3.3157830330310389e-05)*dt0_g0_13;
    dt0_l1_12 = dt0_l1_12 + (0.23380187153816223)*dt0_g0_14;
    dt0_l1_12 = dt0_l1_12 + (8.4281946328701451e-06)*dt0_g0_15;
    dt0_l1_12 = dt0_l1_12 + (-0.033117271959781647)*dt0_g0_16;
    dt0_l1_12 = dt0_l1_12 + (1.6616057109786198e-05)*dt0_g0_17;
    dt0_l1_12 = dt0_l1_12 + (-1.5353301932918839e-05)*dt0_g0_18;
    dt0_l1_12 = dt0_l1_12 + (0.21899636089801788)*dt0_g0_19;
    dt0_l1_12 = dt0_l1_12 + (-1.448372768209083e-05)*dt0_g0_20;
    dt0_l1_12 = dt0_l1_12 + (-0.25044834613800049)*dt0_g0_21;
    dt0_l1_12 = dt0_l1_12 + (-0.082819655537605286)*dt0_g0_22;
    dt0_l1_12 = dt0_l1_12 + (-1.9269737094873562e-05)*dt0_g0_23;
    dt0_l1_12 = dt0_l1_12 + (3.4321240036661038e-06)*dt0_g0_24;
    dt0_l1_12 = dt0_l1_12 + (-3.6190251648804406e-06)*dt0_g0_25;
    dt0_l1_12 = dt0_l1_12 + (2.7439115001470782e-05)*dt0_g0_26;
    dt0_l1_12 = dt0_l1_12 + (-2.7384579880163074e-05)*dt0_g0_27;
    dt0_l1_12 = dt0_l1_12 + (3.4130844142055139e-05)*dt0_g0_28;
    dt0_l1_12 = dt0_l1_12 + (4.4185537262819707e-05)*dt0_g0_29;
    dt0_l1_12 = dt0_l1_12 + (3.1103158107725903e-05)*dt0_g0_30;
    dt0_l1_12 = dt0_l1_12 + (-0.043129730969667435)*dt0_g0_31;
    dt0_l1_13 = 0.025530295446515083;
    dt0_l1_13 = dt0_l1_13 + (0.15520049631595612)*dt0_g0_0;
    dt0_l1_13 = dt0_l1_13 + (-3.6660232581198215e-05)*dt0_g0_1;
    dt0_l1_13 = dt0_l1_13 + (-4.5534681703429669e-05)*dt0_g0_2;
    dt0_l1_13 = dt0_l1_13 + (-1.5075123656060896e-06)*dt0_g0_3;
    dt0_l1_13 = dt0_l1_13 + (-4.3669286242220551e-05)*dt0_g0_4;
    dt0_l1_13 = dt0_l1_13 + (-0.056243117898702621)*dt0_g0_5;
    dt0_l1_13 = dt0_l1_13 + (3.8529615267179906e-05)*dt0_g0_6;
    dt0_l1_13 = dt0_l1_13 + (-3.3103522582678124e-05)*dt0_g0_7;
    dt0_l1_13 = dt0_l1_13 + (-6.0722995840478688e-05)*dt0_g0_8;
    dt0_l1_13 = dt0_l1_13 + (1.8956392523250543e-05)*dt0_g0_9;
    dt0_l1_13 = dt0_l1_13 + (-4.2252195271430537e-05)*dt0_g0_10;
    dt0_l1_13 = dt0_l1_13 + (1.7601305444259197e-05)*dt0_g0_11;
    dt0_l1_13 = dt0_l1_13 + (-4.4738491851603612e-05)*dt0_g0_12;
    dt0_l1_13 = dt0_l1_13 + (-3.2803858630359173e-05)*dt0_g0_13;
    dt0_l1_13 = dt0_l1_13 + (-0.036114614456892014)*dt0_g0_14;
    dt0_l1_13 = dt0_l1_13 + (-2.1566211216850206e-05)*dt0_g0_15;
    dt0_l1_13 = dt0_l1_13 + (-0.046159509569406509)*dt0_g0_16;
    dt0_l1_13 = dt0_l1_13 + (1.0234629371552728e-05)*dt0_g0_17;
    dt0_l1_13 = dt0_l1_13 + (-4.3925567297264934e-05)*dt0_g0_18;
    dt0_l1_13 = dt0_l1_13 + (0.19555991888046265)*dt0_g0_19;
    dt0_l1_13 = dt0_l1_13 + (-5.9092217270517722e-05)*dt0_g0_20;
    dt0_l1_13 = dt0_l1_13 + (0.16028957068920135)*dt0_g0_21;
    dt0_l1_13 = dt0_l1_13 + (0.049317475408315659)*dt0_g0_22;
    dt0_l1_13 = dt0_l1_13 + (-4.824435745831579e-05)*dt0_g0_23;
    dt0_l1_13 = dt0_l1_13 + (1.0115571058122441e-05)*dt0_g0_24;
    dt0_l1_13 = dt0_l1_13 + (-5.9595429775072262e-05)*dt0_g0_25;
    dt0_l1_13 = dt0_l1_13 + (2.9068874937365763e-05)*dt0_g0_26;
    dt0_l1_13 = dt0_l1_13 + (-1.774632437445689e-05)*dt0_g0_27;
    dt0_l1_13 = dt0_l1_13 + (9.8679178336169571e-05)*dt0_g0_28;
    dt0_l1_13 = dt0_l1_13 + (4.5977485569892451e-05)*dt0_g0_29;
    dt0_l1_13 = dt0_l1_13 + (3.5101438697893173e-05)*dt0_g0_30;
    dt0_l1_13 = dt0_l1_13 + (0.06762385368347168)*dt0_g0_31;
    dt0_l1_14 = -0.0092202425003051758;
    dt0_l1_14 = dt0_l1_14 + (0.007417190819978714)*dt0_g0_0;
    dt0_l1_14 = dt0_l1_14 + (-4.7950729822332505e-06)*dt0_g0_1;
    dt0_l1_14 = dt0_l1_14 + (-3.4282297747267876e-06)*dt0_g0_2;
    dt0_l1_14 = dt0_l1_14 + (-1.1316120435367338e-05)*dt0_g0_3;
    dt0_l1_14 = dt0_l1_14 + (-5.4483316489495337e-06)*dt0_g0_4;
    dt0_l1_14 = dt0_l1_14 + (0.001244421349838376)*dt0_g0_5;
    dt0_l1_14 = dt0_l1_14 + (3.5001903597731143e-06)*dt0_g0_6;
    dt0_l1_14 = dt0_l1_14 + (-7.4570052674971521e-06)*dt0_g0_7;
    dt0_l1_14 = dt0_l1_14 + (-6.299705091805663e-06)*dt0_g0_8;
    dt0_l1_14 = dt0_l1_14 + (7.0403930294560269e-06)*dt0_g0_9;
    dt0_l1_14 = dt0_l1_14 + (-3.6051565075467806e-06)*dt0_g0_10;
    dt0_l1_14 = dt0_l1_14 + (5.5118730415415484e-06)*dt0_g0_11;
    dt0_l1_14 = dt0_l1_14 + (-3.8915281947993208e-06)*dt0_g0_12;
    dt0_l1_14 = dt0_l1_14 + (-5.0224139158672187e-06)*dt0_g0_13;
    dt0_l1_14 = dt0_l1_14 + (0.01106240414083004)*dt0_g0_14;
    dt0_l1_14 = dt0_l1_14 + (-6.3502138800686225e-06)*dt0_g0_15;
    dt0_l1_14 = dt0_l1_14 + (0.0049811620265245438)*dt0_g0_16;
    dt0_l1_14 = dt0_l1_14 + (3.2094451398734236e-06)*dt0_g0_17;
    dt0_l1_14 = dt0_l1_14 + (-5.8456530496187042e-06)*dt0_g0_18;
    dt0_l1_14 = dt0_l1_14 + (-0.0062924702651798725)*dt0_g0_19;
    dt0_l1_14 = dt0_l1_14 + (-2.8775179998774547e-06)*dt0_g0_20;
    dt0_l1_14 = dt0_l1_14 + (-0.0077515854500234127)*dt0_g0_21;
    dt0_l1_14 = dt0_l1_14 + (0.022175131365656853)*dt0_g0_22;
    dt0_l1_14 = dt0_l1_14 + (2.4247879082395229e-06)*dt0_g0_23;
    dt0_l1_14 = dt0_l1_14 + (4.3025261220464017e-06)*dt0_g0_24;
    dt0_l1_14 = dt0_l1_14 + (-4.8939937187242322e-06)*dt0_g0_25;
    dt0_l1_14 = dt0_l1_14 + (3.755326360987965e-06)*dt0_g0_26;
    dt0_l1_14 = dt0_l1_14 + (-5.4787733461125754e-06)*dt0_g0_27;
    dt0_l1_14 = dt0_l1_14 + (6.0629909057752229e-06)*dt0_g0_28;
    dt0_l1_14 = dt0_l1_14 + (5.0054122766596265e-06)*dt0_g0_29;
    dt0_l1_14 = dt0_l1_14 + (5.9157187024538871e-06)*dt0_g0_30;
    dt0_l1_14 = dt0_l1_14 + (-0.0013698783004656434)*dt0_g0_31;
    dt0_l1_15 = -0.0092202462255954742;
    dt0_l1_15 = dt0_l1_15 + (0.0074171922169625759)*dt0_g0_0;
    dt0_l1_15 = dt0_l1_15 + (-4.795107088284567e-06)*dt0_g0_1;
    dt0_l1_15 = dt0_l1_15 + (-3.4282566048204899e-06)*dt0_g0_2;
    dt0_l1_15 = dt0_l1_15 + (-1.1316198651911691e-05)*dt0_g0_3;
    dt0_l1_15 = dt0_l1_15 + (-5.4483693929796573e-06)*dt0_g0_4;
    dt0_l1_15 = dt0_l1_15 + (0.0012444109888747334)*dt0_g0_5;
    dt0_l1_15 = dt0_l1_15 + (3.500215825624764e-06)*dt0_g0_6;
    dt0_l1_15 = dt0_l1_15 + (-7.4570530159689952e-06)*dt0_g0_7;
    dt0_l1_15 = dt0_l1_15 + (-6.2997446548251901e-06)*dt0_g0_8;
    dt0_l1_15 = dt0_l1_15 + (7.0404357757070102e-06)*dt0_g0_9;
    dt0_l1_15 = dt0_l1_15 + (-3.6051590086572105e-06)*dt0_g0_10;
    dt0_l1_15 = dt0_l1_15 + (5.5119098760769702e-06)*dt0_g0_11;
    dt0_l1_15 = dt0_l1_15 + (-3.8915586628718302e-06)*dt0_g0_12;
    dt0_l1_15 = dt0_l1_15 + (-5.0224475671711843e-06)*dt0_g0_13;
    dt0_l1_15 = dt0_l1_15 + (0.011062385514378548)*dt0_g0_14;
    dt0_l1_15 = dt0_l1_15 + (-6.3502375269308686e-06)*dt0_g0_15;
    dt0_l1_15 = dt0_l1_15 + (0.0049811168573796749)*dt0_g0_16;
    dt0_l1_15 = dt0_l1_15 + (3.2094642392621608e-06)*dt0_g0_17;
    dt0_l1_15 = dt0_l1_15 + (-5.845693976880284e-06)*dt0_g0_18;
    dt0_l1_15 = dt0_l1_15 + (-0.0062924632802605629)*dt0_g0_19;
    dt0_l1_15 = dt0_l1_15 + (-2.8775432383554289e-06)*dt0_g0_20;
    dt0_l1_15 = dt0_l1_15 + (-0.0077516329474747181)*dt0_g0_21;
    dt0_l1_15 = dt0_l1_15 + (0.022175148129463196)*dt0_g0_22;
    dt0_l1_15 = dt0_l1_15 + (2.4248483896371908e-06)*dt0_g0_23;
    dt0_l1_15 = dt0_l1_15 + (4.3025515878980514e-06)*dt0_g0_24;
    dt0_l1_15 = dt0_l1_15 + (-4.8940296437649522e-06)*dt0_g0_25;
    dt0_l1_15 = dt0_l1_15 + (3.755356601686799e-06)*dt0_g0_26;
    dt0_l1_15 = dt0_l1_15 + (-5.4788088164059445e-06)*dt0_g0_27;
    dt0_l1_15 = dt0_l1_15 + (6.0630241023318376e-06)*dt0_g0_28;
    dt0_l1_15 = dt0_l1_15 + (5.0054468374582939e-06)*dt0_g0_29;
    dt0_l1_15 = dt0_l1_15 + (5.9157559917366598e-06)*dt0_g0_30;
    dt0_l1_15 = dt0_l1_15 + (-0.0013698734110221267)*dt0_g0_31;

    // Device tower token 1
    dt1_l0_0 = (-0.31454805458175983) + (1.2195616960525513)*dev1;
    dt1_l0_1 = (0.027215388828151034) + (0.018948320299386978)*dev1;
    dt1_l0_2 = (0.032705838203499683) + (-0.00044691961375065148)*dev1;
    dt1_l0_3 = (0.024796708712832738) + (0.027163483202457428)*dev1;
    dt1_l0_4 = (0.02299285550228785) + (0.033691637217998505)*dev1;
    dt1_l0_5 = (0.15769120337995712) + (-0.86946827173233032)*dev1;
    dt1_l0_6 = (0.026635257250755624) + (0.020761676132678986)*dev1;
    dt1_l0_7 = (0.026430104703749239) + (0.021645240485668182)*dev1;
    dt1_l0_8 = (0.017073446438784438) + (0.055928267538547516)*dev1;
    dt1_l0_9 = (0.022410726043902547) + (0.035811524838209152)*dev1;
    dt1_l0_10 = (0.028057087390596015) + (0.016222704201936722)*dev1;
    dt1_l0_11 = (0.028147550329519978) + (0.01910720206797123)*dev1;
    dt1_l0_12 = (0.026261281395291138) + (0.022229747846722603)*dev1;
    dt1_l0_13 = (0.024735308005729283) + (0.02716631256043911)*dev1;
    dt1_l0_14 = (-0.19359040426706431) + (0.47177079319953918)*dev1;
    dt1_l0_15 = (0.025265331428988635) + (0.02563852071762085)*dev1;
    dt1_l0_16 = (0.019587695913253569) + (-0.8715357780456543)*dev1;
    dt1_l0_17 = (0.026894373615494085) + (0.019475888460874557)*dev1;
    dt1_l0_18 = (0.025879430630957757) + (0.023528816178441048)*dev1;
    dt1_l0_19 = (-0.13557817386124246) + (0.92190909385681152)*dev1;
    dt1_l0_20 = (0.026794743765944699) + (0.020385686308145523)*dev1;
    dt1_l0_21 = (-0.019923195096789647) + (-1.0305671691894531)*dev1;
    dt1_l0_22 = (0.18187455026192284) + (-1.5255454778671265)*dev1;
    dt1_l0_23 = (0.023731961565821674) + (0.031063420698046684)*dev1;
    dt1_l0_24 = (0.02734788305231153) + (0.018535159528255463)*dev1;
    dt1_l0_25 = (0.026198108908093116) + (0.022205263376235962)*dev1;
    dt1_l0_26 = (0.027841217681184655) + (0.016815893352031708)*dev1;
    dt1_l0_27 = (0.028403285287527835) + (0.01488249097019434)*dev1;
    dt1_l0_28 = (0.026160597797448882) + (0.022590510547161102)*dev1;
    dt1_l0_29 = (0.022724185179638104) + (0.034689158201217651)*dev1;
    dt1_l0_30 = (0.024199684662133434) + (0.029342725872993469)*dev1;
    dt1_l0_31 = (-0.15386920784231811) + (1.0588947534561157)*dev1;
    dt1_mean = (dt1_l0_0 + dt1_l0_1 + dt1_l0_2 + dt1_l0_3 + dt1_l0_4 + dt1_l0_5 + dt1_l0_6 + dt1_l0_7 + dt1_l0_8 + dt1_l0_9 + dt1_l0_10 + dt1_l0_11 + dt1_l0_12 + dt1_l0_13 + dt1_l0_14 + dt1_l0_15 + dt1_l0_16 + dt1_l0_17 + dt1_l0_18 + dt1_l0_19 + dt1_l0_20 + dt1_l0_21 + dt1_l0_22 + dt1_l0_23 + dt1_l0_24 + dt1_l0_25 + dt1_l0_26 + dt1_l0_27 + dt1_l0_28 + dt1_l0_29 + dt1_l0_30 + dt1_l0_31) / 32;
    dt1_var = (((dt1_l0_0) - dt1_mean)*((dt1_l0_0) - dt1_mean) + ((dt1_l0_1) - dt1_mean)*((dt1_l0_1) - dt1_mean) + ((dt1_l0_2) - dt1_mean)*((dt1_l0_2) - dt1_mean) + ((dt1_l0_3) - dt1_mean)*((dt1_l0_3) - dt1_mean) + ((dt1_l0_4) - dt1_mean)*((dt1_l0_4) - dt1_mean) + ((dt1_l0_5) - dt1_mean)*((dt1_l0_5) - dt1_mean) + ((dt1_l0_6) - dt1_mean)*((dt1_l0_6) - dt1_mean) + ((dt1_l0_7) - dt1_mean)*((dt1_l0_7) - dt1_mean) + ((dt1_l0_8) - dt1_mean)*((dt1_l0_8) - dt1_mean) + ((dt1_l0_9) - dt1_mean)*((dt1_l0_9) - dt1_mean) + ((dt1_l0_10) - dt1_mean)*((dt1_l0_10) - dt1_mean) + ((dt1_l0_11) - dt1_mean)*((dt1_l0_11) - dt1_mean) + ((dt1_l0_12) - dt1_mean)*((dt1_l0_12) - dt1_mean) + ((dt1_l0_13) - dt1_mean)*((dt1_l0_13) - dt1_mean) + ((dt1_l0_14) - dt1_mean)*((dt1_l0_14) - dt1_mean) + ((dt1_l0_15) - dt1_mean)*((dt1_l0_15) - dt1_mean) + ((dt1_l0_16) - dt1_mean)*((dt1_l0_16) - dt1_mean) + ((dt1_l0_17) - dt1_mean)*((dt1_l0_17) - dt1_mean) + ((dt1_l0_18) - dt1_mean)*((dt1_l0_18) - dt1_mean) + ((dt1_l0_19) - dt1_mean)*((dt1_l0_19) - dt1_mean) + ((dt1_l0_20) - dt1_mean)*((dt1_l0_20) - dt1_mean) + ((dt1_l0_21) - dt1_mean)*((dt1_l0_21) - dt1_mean) + ((dt1_l0_22) - dt1_mean)*((dt1_l0_22) - dt1_mean) + ((dt1_l0_23) - dt1_mean)*((dt1_l0_23) - dt1_mean) + ((dt1_l0_24) - dt1_mean)*((dt1_l0_24) - dt1_mean) + ((dt1_l0_25) - dt1_mean)*((dt1_l0_25) - dt1_mean) + ((dt1_l0_26) - dt1_mean)*((dt1_l0_26) - dt1_mean) + ((dt1_l0_27) - dt1_mean)*((dt1_l0_27) - dt1_mean) + ((dt1_l0_28) - dt1_mean)*((dt1_l0_28) - dt1_mean) + ((dt1_l0_29) - dt1_mean)*((dt1_l0_29) - dt1_mean) + ((dt1_l0_30) - dt1_mean)*((dt1_l0_30) - dt1_mean) + ((dt1_l0_31) - dt1_mean)*((dt1_l0_31) - dt1_mean)) / 32;
    dt1_n0_0 = (((dt1_l0_0) - dt1_mean) / sqrt(dt1_var + ln_eps)) * (0.843211829662323) + (0.10046378523111343);
    dt1_n0_1 = (((dt1_l0_1) - dt1_mean) / sqrt(dt1_var + ln_eps)) * (2.7206051527173258e-06) + (-1.6632851611575461e-06);
    dt1_n0_2 = (((dt1_l0_2) - dt1_mean) / sqrt(dt1_var + ln_eps)) * (-6.2584508668805938e-06) + (1.0455639767315006e-06);
    dt1_n0_3 = (((dt1_l0_3) - dt1_mean) / sqrt(dt1_var + ln_eps)) * (-6.9736793193442281e-06) + (-1.0999922778864857e-05);
    dt1_n0_4 = (((dt1_l0_4) - dt1_mean) / sqrt(dt1_var + ln_eps)) * (9.8267028079135343e-06) + (-6.5247531892964616e-06);
    dt1_n0_5 = (((dt1_l0_5) - dt1_mean) / sqrt(dt1_var + ln_eps)) * (0.27213570475578308) + (-0.0039989589713513851);
    dt1_n0_6 = (((dt1_l0_6) - dt1_mean) / sqrt(dt1_var + ln_eps)) * (-3.4977392715518363e-06) + (3.6835772210253026e-09);
    dt1_n0_7 = (((dt1_l0_7) - dt1_mean) / sqrt(dt1_var + ln_eps)) * (2.5401395760127343e-06) + (-7.8833654697518796e-06);
    dt1_n0_8 = (((dt1_l0_8) - dt1_mean) / sqrt(dt1_var + ln_eps)) * (4.0655754673935007e-06) + (-3.8788698475400452e-06);
    dt1_n0_9 = (((dt1_l0_9) - dt1_mean) / sqrt(dt1_var + ln_eps)) * (-4.6432196540990844e-06) + (7.3355377026018687e-06);
    dt1_n0_10 = (((dt1_l0_10) - dt1_mean) / sqrt(dt1_var + ln_eps)) * (3.574464471967076e-06) + (-2.2624096800427651e-06);
    dt1_n0_11 = (((dt1_l0_11) - dt1_mean) / sqrt(dt1_var + ln_eps)) * (1.3387105354922824e-05) + (2.8874530926259467e-06);
    dt1_n0_12 = (((dt1_l0_12) - dt1_mean) / sqrt(dt1_var + ln_eps)) * (-1.8776631804939825e-06) + (1.60305955887452e-06);
    dt1_n0_13 = (((dt1_l0_13) - dt1_mean) / sqrt(dt1_var + ln_eps)) * (1.0976241355820093e-06) + (-1.4980198557168478e-06);
    dt1_n0_14 = (((dt1_l0_14) - dt1_mean) / sqrt(dt1_var + ln_eps)) * (0.84664261341094971) + (-0.10655493289232254);
    dt1_n0_15 = (((dt1_l0_15) - dt1_mean) / sqrt(dt1_var + ln_eps)) * (2.9659940992132761e-06) + (1.6667630688971258e-06);
    dt1_n0_16 = (((dt1_l0_16) - dt1_mean) / sqrt(dt1_var + ln_eps)) * (1.0360937118530273) + (0.083679109811782837);
    dt1_n0_17 = (((dt1_l0_17) - dt1_mean) / sqrt(dt1_var + ln_eps)) * (-3.2341320093109971e-06) + (5.0602602641447447e-07);
    dt1_n0_18 = (((dt1_l0_18) - dt1_mean) / sqrt(dt1_var + ln_eps)) * (-6.2578095594290062e-07) + (-2.8663500870607095e-06);
    dt1_n0_19 = (((dt1_l0_19) - dt1_mean) / sqrt(dt1_var + ln_eps)) * (0.78893840312957764) + (-0.077350124716758728);
    dt1_n0_20 = (((dt1_l0_20) - dt1_mean) / sqrt(dt1_var + ln_eps)) * (4.0180102587328292e-06) + (-4.8921708639682038e-07);
    dt1_n0_21 = (((dt1_l0_21) - dt1_mean) / sqrt(dt1_var + ln_eps)) * (0.85818284749984741) + (-0.028547178953886032);
    dt1_n0_22 = (((dt1_l0_22) - dt1_mean) / sqrt(dt1_var + ln_eps)) * (0.83205467462539673) + (0.17346389591693878);
    dt1_n0_23 = (((dt1_l0_23) - dt1_mean) / sqrt(dt1_var + ln_eps)) * (1.504554438724881e-05) + (9.2961727204965428e-06);
    dt1_n0_24 = (((dt1_l0_24) - dt1_mean) / sqrt(dt1_var + ln_eps)) * (-1.26005252241157e-05) + (3.5688885873241816e-06);
    dt1_n0_25 = (((dt1_l0_25) - dt1_mean) / sqrt(dt1_var + ln_eps)) * (1.1577288205444347e-05) + (-4.1063835851673502e-06);
    dt1_n0_26 = (((dt1_l0_26) - dt1_mean) / sqrt(dt1_var + ln_eps)) * (-1.030867042572936e-05) + (3.3574026474525454e-06);
    dt1_n0_27 = (((dt1_l0_27) - dt1_mean) / sqrt(dt1_var + ln_eps)) * (8.7807520685601048e-06) + (-6.0104152908024844e-06);
    dt1_n0_28 = (((dt1_l0_28) - dt1_mean) / sqrt(dt1_var + ln_eps)) * (1.1751266356441192e-05) + (3.8589575979131041e-07);
    dt1_n0_29 = (((dt1_l0_29) - dt1_mean) / sqrt(dt1_var + ln_eps)) * (-1.6195903072002693e-06) + (3.1835461413720623e-06);
    dt1_n0_30 = (((dt1_l0_30) - dt1_mean) / sqrt(dt1_var + ln_eps)) * (-4.8718366087996401e-06) + (5.3302196647564415e-06);
    dt1_n0_31 = (((dt1_l0_31) - dt1_mean) / sqrt(dt1_var + ln_eps)) * (0.53329497575759888) + (-0.060209508985280991);
    dt1_g0_0 = gelu_approx(dt1_n0_0);
    dt1_g0_1 = gelu_approx(dt1_n0_1);
    dt1_g0_2 = gelu_approx(dt1_n0_2);
    dt1_g0_3 = gelu_approx(dt1_n0_3);
    dt1_g0_4 = gelu_approx(dt1_n0_4);
    dt1_g0_5 = gelu_approx(dt1_n0_5);
    dt1_g0_6 = gelu_approx(dt1_n0_6);
    dt1_g0_7 = gelu_approx(dt1_n0_7);
    dt1_g0_8 = gelu_approx(dt1_n0_8);
    dt1_g0_9 = gelu_approx(dt1_n0_9);
    dt1_g0_10 = gelu_approx(dt1_n0_10);
    dt1_g0_11 = gelu_approx(dt1_n0_11);
    dt1_g0_12 = gelu_approx(dt1_n0_12);
    dt1_g0_13 = gelu_approx(dt1_n0_13);
    dt1_g0_14 = gelu_approx(dt1_n0_14);
    dt1_g0_15 = gelu_approx(dt1_n0_15);
    dt1_g0_16 = gelu_approx(dt1_n0_16);
    dt1_g0_17 = gelu_approx(dt1_n0_17);
    dt1_g0_18 = gelu_approx(dt1_n0_18);
    dt1_g0_19 = gelu_approx(dt1_n0_19);
    dt1_g0_20 = gelu_approx(dt1_n0_20);
    dt1_g0_21 = gelu_approx(dt1_n0_21);
    dt1_g0_22 = gelu_approx(dt1_n0_22);
    dt1_g0_23 = gelu_approx(dt1_n0_23);
    dt1_g0_24 = gelu_approx(dt1_n0_24);
    dt1_g0_25 = gelu_approx(dt1_n0_25);
    dt1_g0_26 = gelu_approx(dt1_n0_26);
    dt1_g0_27 = gelu_approx(dt1_n0_27);
    dt1_g0_28 = gelu_approx(dt1_n0_28);
    dt1_g0_29 = gelu_approx(dt1_n0_29);
    dt1_g0_30 = gelu_approx(dt1_n0_30);
    dt1_g0_31 = gelu_approx(dt1_n0_31);
    dt1_l1_0 = 0.07863936573266983;
    dt1_l1_0 = dt1_l1_0 + (0.09521186351776123)*dt1_g0_0;
    dt1_l1_0 = dt1_l1_0 + (-2.6276595235685818e-05)*dt1_g0_1;
    dt1_l1_0 = dt1_l1_0 + (-2.5888028176268563e-05)*dt1_g0_2;
    dt1_l1_0 = dt1_l1_0 + (-5.9903377405134961e-05)*dt1_g0_3;
    dt1_l1_0 = dt1_l1_0 + (-3.0735114705748856e-05)*dt1_g0_4;
    dt1_l1_0 = dt1_l1_0 + (0.20419855415821075)*dt1_g0_5;
    dt1_l1_0 = dt1_l1_0 + (1.9859808162436821e-05)*dt1_g0_6;
    dt1_l1_0 = dt1_l1_0 + (-4.5337787014432251e-05)*dt1_g0_7;
    dt1_l1_0 = dt1_l1_0 + (-2.5618910513003357e-05)*dt1_g0_8;
    dt1_l1_0 = dt1_l1_0 + (3.65683481504675e-05)*dt1_g0_9;
    dt1_l1_0 = dt1_l1_0 + (8.6936415755189955e-06)*dt1_g0_10;
    dt1_l1_0 = dt1_l1_0 + (4.0928891394287348e-05)*dt1_g0_11;
    dt1_l1_0 = dt1_l1_0 + (-1.9896786398021504e-05)*dt1_g0_12;
    dt1_l1_0 = dt1_l1_0 + (-2.837985084624961e-05)*dt1_g0_13;
    dt1_l1_0 = dt1_l1_0 + (0.3629240095615387)*dt1_g0_14;
    dt1_l1_0 = dt1_l1_0 + (-9.6212206699419767e-06)*dt1_g0_15;
    dt1_l1_0 = dt1_l1_0 + (0.067542426288127899)*dt1_g0_16;
    dt1_l1_0 = dt1_l1_0 + (2.2813670511823148e-05)*dt1_g0_17;
    dt1_l1_0 = dt1_l1_0 + (-3.8062858948251233e-05)*dt1_g0_18;
    dt1_l1_0 = dt1_l1_0 + (0.0051724417135119438)*dt1_g0_19;
    dt1_l1_0 = dt1_l1_0 + (-1.3537222912418656e-05)*dt1_g0_20;
    dt1_l1_0 = dt1_l1_0 + (-0.32233437895774841)*dt1_g0_21;
    dt1_l1_0 = dt1_l1_0 + (-0.039486300200223923)*dt1_g0_22;
    dt1_l1_0 = dt1_l1_0 + (4.4735566916642711e-05)*dt1_g0_23;
    dt1_l1_0 = dt1_l1_0 + (2.3966475055203773e-05)*dt1_g0_24;
    dt1_l1_0 = dt1_l1_0 + (-3.0044160666875541e-05)*dt1_g0_25;
    dt1_l1_0 = dt1_l1_0 + (2.1940304577583447e-05)*dt1_g0_26;
    dt1_l1_0 = dt1_l1_0 + (-3.2977310183923692e-05)*dt1_g0_27;
    dt1_l1_0 = dt1_l1_0 + (1.5462126611964777e-05)*dt1_g0_28;
    dt1_l1_0 = dt1_l1_0 + (2.3663053070777096e-05)*dt1_g0_29;
    dt1_l1_0 = dt1_l1_0 + (3.0054983653826639e-05)*dt1_g0_30;
    dt1_l1_0 = dt1_l1_0 + (0.067137621343135834)*dt1_g0_31;
    dt1_l1_1 = -0.0092202415689826012;
    dt1_l1_1 = dt1_l1_1 + (0.0074171749874949455)*dt1_g0_0;
    dt1_l1_1 = dt1_l1_1 + (-4.7950475163816009e-06)*dt1_g0_1;
    dt1_l1_1 = dt1_l1_1 + (-3.4282065826118924e-06)*dt1_g0_2;
    dt1_l1_1 = dt1_l1_1 + (-1.1316158634144813e-05)*dt1_g0_3;
    dt1_l1_1 = dt1_l1_1 + (-5.4483066378452349e-06)*dt1_g0_4;
    dt1_l1_1 = dt1_l1_1 + (0.0012443787418305874)*dt1_g0_5;
    dt1_l1_1 = dt1_l1_1 + (3.5001457945327275e-06)*dt1_g0_6;
    dt1_l1_1 = dt1_l1_1 + (-7.4570029937603977e-06)*dt1_g0_7;
    dt1_l1_1 = dt1_l1_1 + (-6.29967280474375e-06)*dt1_g0_8;
    dt1_l1_1 = dt1_l1_1 + (7.0403816607722547e-06)*dt1_g0_9;
    dt1_l1_1 = dt1_l1_1 + (-3.6051681036042282e-06)*dt1_g0_10;
    dt1_l1_1 = dt1_l1_1 + (5.5118712225521449e-06)*dt1_g0_11;
    dt1_l1_1 = dt1_l1_1 + (-3.8914945434953552e-06)*dt1_g0_12;
    dt1_l1_1 = dt1_l1_1 + (-5.0223870857735164e-06)*dt1_g0_13;
    dt1_l1_1 = dt1_l1_1 + (0.011062460020184517)*dt1_g0_14;
    dt1_l1_1 = dt1_l1_1 + (-6.3501947806798853e-06)*dt1_g0_15;
    dt1_l1_1 = dt1_l1_1 + (0.0049811596982181072)*dt1_g0_16;
    dt1_l1_1 = dt1_l1_1 + (3.2094264952320373e-06)*dt1_g0_17;
    dt1_l1_1 = dt1_l1_1 + (-5.8456348597246688e-06)*dt1_g0_18;
    dt1_l1_1 = dt1_l1_1 + (-0.0062924828380346298)*dt1_g0_19;
    dt1_l1_1 = dt1_l1_1 + (-2.8774959446309367e-06)*dt1_g0_20;
    dt1_l1_1 = dt1_l1_1 + (-0.0077515658922493458)*dt1_g0_21;
    dt1_l1_1 = dt1_l1_1 + (0.022175149992108345)*dt1_g0_22;
    dt1_l1_1 = dt1_l1_1 + (2.4248131467174971e-06)*dt1_g0_23;
    dt1_l1_1 = dt1_l1_1 + (4.3025020204368047e-06)*dt1_g0_24;
    dt1_l1_1 = dt1_l1_1 + (-4.8939637053990737e-06)*dt1_g0_25;
    dt1_l1_1 = dt1_l1_1 + (3.7552931644313503e-06)*dt1_g0_26;
    dt1_l1_1 = dt1_l1_1 + (-5.4787583394499961e-06)*dt1_g0_27;
    dt1_l1_1 = dt1_l1_1 + (6.0630209191003814e-06)*dt1_g0_28;
    dt1_l1_1 = dt1_l1_1 + (5.0053927225235384e-06)*dt1_g0_29;
    dt1_l1_1 = dt1_l1_1 + (5.9157014220545534e-06)*dt1_g0_30;
    dt1_l1_1 = dt1_l1_1 + (-0.0013698715483769774)*dt1_g0_31;
    dt1_l1_2 = -0.054556742310523987;
    dt1_l1_2 = dt1_l1_2 + (-0.11475023627281189)*dt1_g0_0;
    dt1_l1_2 = dt1_l1_2 + (-2.2050206098356284e-05)*dt1_g0_1;
    dt1_l1_2 = dt1_l1_2 + (-2.3636228434043005e-05)*dt1_g0_2;
    dt1_l1_2 = dt1_l1_2 + (-4.0239618101622909e-05)*dt1_g0_3;
    dt1_l1_2 = dt1_l1_2 + (-2.4587043299106881e-05)*dt1_g0_4;
    dt1_l1_2 = dt1_l1_2 + (-0.081742040812969208)*dt1_g0_5;
    dt1_l1_2 = dt1_l1_2 + (1.778024306986481e-05)*dt1_g0_6;
    dt1_l1_2 = dt1_l1_2 + (-3.4487980883568525e-05)*dt1_g0_7;
    dt1_l1_2 = dt1_l1_2 + (-1.8637536413734779e-05)*dt1_g0_8;
    dt1_l1_2 = dt1_l1_2 + (2.5554181775078177e-05)*dt1_g0_9;
    dt1_l1_2 = dt1_l1_2 + (1.6197418517549522e-05)*dt1_g0_10;
    dt1_l1_2 = dt1_l1_2 + (2.9932547477073967e-05)*dt1_g0_11;
    dt1_l1_2 = dt1_l1_2 + (-1.8899074348155409e-05)*dt1_g0_12;
    dt1_l1_2 = dt1_l1_2 + (-2.3010863515082747e-05)*dt1_g0_13;
    dt1_l1_2 = dt1_l1_2 + (-0.091811060905456543)*dt1_g0_14;
    dt1_l1_2 = dt1_l1_2 + (-1.1534952136571519e-05)*dt1_g0_15;
    dt1_l1_2 = dt1_l1_2 + (-0.14485783874988556)*dt1_g0_16;
    dt1_l1_2 = dt1_l1_2 + (2.2519809135701507e-05)*dt1_g0_17;
    dt1_l1_2 = dt1_l1_2 + (-3.1300496630137786e-05)*dt1_g0_18;
    dt1_l1_2 = dt1_l1_2 + (-0.11977535486221313)*dt1_g0_19;
    dt1_l1_2 = dt1_l1_2 + (-1.1793315934482962e-05)*dt1_g0_20;
    dt1_l1_2 = dt1_l1_2 + (0.25181648135185242)*dt1_g0_21;
    dt1_l1_2 = dt1_l1_2 + (-0.20050008594989777)*dt1_g0_22;
    dt1_l1_2 = dt1_l1_2 + (3.3441781852161512e-05)*dt1_g0_23;
    dt1_l1_2 = dt1_l1_2 + (2.4673528969287872e-05)*dt1_g0_24;
    dt1_l1_2 = dt1_l1_2 + (-2.8681350158876739e-05)*dt1_g0_25;
    dt1_l1_2 = dt1_l1_2 + (1.8679962522583082e-05)*dt1_g0_26;
    dt1_l1_2 = dt1_l1_2 + (-2.4577928343205713e-05)*dt1_g0_27;
    dt1_l1_2 = dt1_l1_2 + (2.2437554889620515e-06)*dt1_g0_28;
    dt1_l1_2 = dt1_l1_2 + (1.5454967069672421e-05)*dt1_g0_29;
    dt1_l1_2 = dt1_l1_2 + (2.1073970856377855e-05)*dt1_g0_30;
    dt1_l1_2 = dt1_l1_2 + (0.28076320886611938)*dt1_g0_31;
    dt1_l1_3 = 0.0069250846281647682;
    dt1_l1_3 = dt1_l1_3 + (-0.20002850890159607)*dt1_g0_0;
    dt1_l1_3 = dt1_l1_3 + (0.00012122812040615827)*dt1_g0_1;
    dt1_l1_3 = dt1_l1_3 + (0.00010440648475196213)*dt1_g0_2;
    dt1_l1_3 = dt1_l1_3 + (0.00020597409456968307)*dt1_g0_3;
    dt1_l1_3 = dt1_l1_3 + (0.0001197444653371349)*dt1_g0_4;
    dt1_l1_3 = dt1_l1_3 + (0.11727102845907211)*dt1_g0_5;
    dt1_l1_3 = dt1_l1_3 + (-0.0001155518984887749)*dt1_g0_6;
    dt1_l1_3 = dt1_l1_3 + (0.00015998477465473115)*dt1_g0_7;
    dt1_l1_3 = dt1_l1_3 + (0.00013909452536609024)*dt1_g0_8;
    dt1_l1_3 = dt1_l1_3 + (-0.00017011263116728514)*dt1_g0_9;
    dt1_l1_3 = dt1_l1_3 + (5.9865098592126742e-05)*dt1_g0_10;
    dt1_l1_3 = dt1_l1_3 + (-0.00015404204896185547)*dt1_g0_11;
    dt1_l1_3 = dt1_l1_3 + (9.32334951357916e-05)*dt1_g0_12;
    dt1_l1_3 = dt1_l1_3 + (0.000120447417430114)*dt1_g0_13;
    dt1_l1_3 = dt1_l1_3 + (-0.083557084202766418)*dt1_g0_14;
    dt1_l1_3 = dt1_l1_3 + (4.2947609472321346e-05)*dt1_g0_15;
    dt1_l1_3 = dt1_l1_3 + (0.093954339623451233)*dt1_g0_16;
    dt1_l1_3 = dt1_l1_3 + (-3.5744946217164397e-05)*dt1_g0_17;
    dt1_l1_3 = dt1_l1_3 + (0.00013965979451313615)*dt1_g0_18;
    dt1_l1_3 = dt1_l1_3 + (0.23021359741687775)*dt1_g0_19;
    dt1_l1_3 = dt1_l1_3 + (7.7469136158470064e-05)*dt1_g0_20;
    dt1_l1_3 = dt1_l1_3 + (0.25050327181816101)*dt1_g0_21;
    dt1_l1_3 = dt1_l1_3 + (0.061861880123615265)*dt1_g0_22;
    dt1_l1_3 = dt1_l1_3 + (-7.4739029514603317e-05)*dt1_g0_23;
    dt1_l1_3 = dt1_l1_3 + (-4.0087521483656019e-05)*dt1_g0_24;
    dt1_l1_3 = dt1_l1_3 + (0.00010163952538277954)*dt1_g0_25;
    dt1_l1_3 = dt1_l1_3 + (-0.00011079228715971112)*dt1_g0_26;
    dt1_l1_3 = dt1_l1_3 + (0.00015467824414372444)*dt1_g0_27;
    dt1_l1_3 = dt1_l1_3 + (-0.00013554334873333573)*dt1_g0_28;
    dt1_l1_3 = dt1_l1_3 + (-0.00012356755905784667)*dt1_g0_29;
    dt1_l1_3 = dt1_l1_3 + (-0.00015409041952807456)*dt1_g0_30;
    dt1_l1_3 = dt1_l1_3 + (-0.16506032645702362)*dt1_g0_31;
    dt1_l1_4 = -0.009220244362950325;
    dt1_l1_4 = dt1_l1_4 + (0.0074171894229948521)*dt1_g0_0;
    dt1_l1_4 = dt1_l1_4 + (-4.7950984480849002e-06)*dt1_g0_1;
    dt1_l1_4 = dt1_l1_4 + (-3.4282509204786038e-06)*dt1_g0_2;
    dt1_l1_4 = dt1_l1_4 + (-1.131618773797527e-05)*dt1_g0_3;
    dt1_l1_4 = dt1_l1_4 + (-5.4483616622746922e-06)*dt1_g0_4;
    dt1_l1_4 = dt1_l1_4 + (0.0012444290332496166)*dt1_g0_5;
    dt1_l1_4 = dt1_l1_4 + (3.5001980904780794e-06)*dt1_g0_6;
    dt1_l1_4 = dt1_l1_4 + (-7.4570571086951531e-06)*dt1_g0_7;
    dt1_l1_4 = dt1_l1_4 + (-6.299732831394067e-06)*dt1_g0_8;
    dt1_l1_4 = dt1_l1_4 + (7.0404253165179398e-06)*dt1_g0_9;
    dt1_l1_4 = dt1_l1_4 + (-3.6051631013833685e-06)*dt1_g0_10;
    dt1_l1_4 = dt1_l1_4 + (5.5119116950663738e-06)*dt1_g0_11;
    dt1_l1_4 = dt1_l1_4 + (-3.8915482036827598e-06)*dt1_g0_12;
    dt1_l1_4 = dt1_l1_4 + (-5.0224366532347631e-06)*dt1_g0_13;
    dt1_l1_4 = dt1_l1_4 + (0.011062382720410824)*dt1_g0_14;
    dt1_l1_4 = dt1_l1_4 + (-6.350232069962658e-06)*dt1_g0_15;
    dt1_l1_4 = dt1_l1_4 + (0.0049811564385890961)*dt1_g0_16;
    dt1_l1_4 = dt1_l1_4 + (3.2094562811835203e-06)*dt1_g0_17;
    dt1_l1_4 = dt1_l1_4 + (-5.845689884154126e-06)*dt1_g0_18;
    dt1_l1_4 = dt1_l1_4 + (-0.006292473990470171)*dt1_g0_19;
    dt1_l1_4 = dt1_l1_4 + (-2.8775357350241393e-06)*dt1_g0_20;
    dt1_l1_4 = dt1_l1_4 + (-0.0077515956945717335)*dt1_g0_21;
    dt1_l1_4 = dt1_l1_4 + (0.022175129503011703)*dt1_g0_22;
    dt1_l1_4 = dt1_l1_4 + (2.4248633962997701e-06)*dt1_g0_23;
    dt1_l1_4 = dt1_l1_4 + (4.3025429476983845e-06)*dt1_g0_24;
    dt1_l1_4 = dt1_l1_4 + (-4.8940241867967416e-06)*dt1_g0_25;
    dt1_l1_4 = dt1_l1_4 + (3.7553436413872987e-06)*dt1_g0_26;
    dt1_l1_4 = dt1_l1_4 + (-5.4788001762062777e-06)*dt1_g0_27;
    dt1_l1_4 = dt1_l1_4 + (6.0630350162682589e-06)*dt1_g0_28;
    dt1_l1_4 = dt1_l1_4 + (5.0054395615006797e-06)*dt1_g0_29;
    dt1_l1_4 = dt1_l1_4 + (5.9157500800210983e-06)*dt1_g0_30;
    dt1_l1_4 = dt1_l1_4 + (-0.0013698672410100698)*dt1_g0_31;
    dt1_l1_5 = -0.010299425572156906;
    dt1_l1_5 = dt1_l1_5 + (-0.019222021102905273)*dt1_g0_0;
    dt1_l1_5 = dt1_l1_5 + (-1.0141934581042733e-05)*dt1_g0_1;
    dt1_l1_5 = dt1_l1_5 + (-3.5136697533744154e-06)*dt1_g0_2;
    dt1_l1_5 = dt1_l1_5 + (3.7071269616717473e-05)*dt1_g0_3;
    dt1_l1_5 = dt1_l1_5 + (-2.195977913288516e-06)*dt1_g0_4;
    dt1_l1_5 = dt1_l1_5 + (-0.0010503833182156086)*dt1_g0_5;
    dt1_l1_5 = dt1_l1_5 + (7.927470505819656e-06)*dt1_g0_6;
    dt1_l1_5 = dt1_l1_5 + (1.3052414942649193e-05)*dt1_g0_7;
    dt1_l1_5 = dt1_l1_5 + (4.0837808228388894e-06)*dt1_g0_8;
    dt1_l1_5 = dt1_l1_5 + (-9.3975322670303285e-06)*dt1_g0_9;
    dt1_l1_5 = dt1_l1_5 + (-3.5394165024627e-05)*dt1_g0_10;
    dt1_l1_5 = dt1_l1_5 + (-1.9062243154621683e-05)*dt1_g0_11;
    dt1_l1_5 = dt1_l1_5 + (-1.4862144780636299e-05)*dt1_g0_12;
    dt1_l1_5 = dt1_l1_5 + (-9.2636173576465808e-06)*dt1_g0_13;
    dt1_l1_5 = dt1_l1_5 + (-0.097159318625926971)*dt1_g0_14;
    dt1_l1_5 = dt1_l1_5 + (2.0512221453827806e-05)*dt1_g0_15;
    dt1_l1_5 = dt1_l1_5 + (0.2089591771364212)*dt1_g0_16;
    dt1_l1_5 = dt1_l1_5 + (-2.2365591121342732e-06)*dt1_g0_17;
    dt1_l1_5 = dt1_l1_5 + (7.9388446465600282e-06)*dt1_g0_18;
    dt1_l1_5 = dt1_l1_5 + (-0.042912889271974564)*dt1_g0_19;
    dt1_l1_5 = dt1_l1_5 + (-2.026791207754286e-06)*dt1_g0_20;
    dt1_l1_5 = dt1_l1_5 + (-0.073992572724819183)*dt1_g0_21;
    dt1_l1_5 = dt1_l1_5 + (0.047116514295339584)*dt1_g0_22;
    dt1_l1_5 = dt1_l1_5 + (-0.00010094667959492654)*dt1_g0_23;
    dt1_l1_5 = dt1_l1_5 + (-4.6528043640137184e-06)*dt1_g0_24;
    dt1_l1_5 = dt1_l1_5 + (-1.2978689483134076e-05)*dt1_g0_25;
    dt1_l1_5 = dt1_l1_5 + (9.7785505204228684e-06)*dt1_g0_26;
    dt1_l1_5 = dt1_l1_5 + (4.0318846004083753e-06)*dt1_g0_27;
    dt1_l1_5 = dt1_l1_5 + (-2.9880278816563077e-05)*dt1_g0_28;
    dt1_l1_5 = dt1_l1_5 + (-8.4235762187745422e-06)*dt1_g0_29;
    dt1_l1_5 = dt1_l1_5 + (-4.9168957048095763e-06)*dt1_g0_30;
    dt1_l1_5 = dt1_l1_5 + (0.14125142991542816)*dt1_g0_31;
    dt1_l1_6 = -0.1312904953956604;
    dt1_l1_6 = dt1_l1_6 + (0.37175250053405762)*dt1_g0_0;
    dt1_l1_6 = dt1_l1_6 + (4.33431523561012e-06)*dt1_g0_1;
    dt1_l1_6 = dt1_l1_6 + (2.5241517960239435e-06)*dt1_g0_2;
    dt1_l1_6 = dt1_l1_6 + (-1.1879010344273411e-05)*dt1_g0_3;
    dt1_l1_6 = dt1_l1_6 + (1.5745153802981804e-07)*dt1_g0_4;
    dt1_l1_6 = dt1_l1_6 + (-0.0010415823198854923)*dt1_g0_5;
    dt1_l1_6 = dt1_l1_6 + (-9.7839092632057145e-06)*dt1_g0_6;
    dt1_l1_6 = dt1_l1_6 + (-2.3084953681973275e-06)*dt1_g0_7;
    dt1_l1_6 = dt1_l1_6 + (7.4807148848776706e-06)*dt1_g0_8;
    dt1_l1_6 = dt1_l1_6 + (-3.9429028220183682e-06)*dt1_g0_9;
    dt1_l1_6 = dt1_l1_6 + (1.4638950233347714e-05)*dt1_g0_10;
    dt1_l1_6 = dt1_l1_6 + (1.5910354704828933e-06)*dt1_g0_11;
    dt1_l1_6 = dt1_l1_6 + (4.8954902922559995e-06)*dt1_g0_12;
    dt1_l1_6 = dt1_l1_6 + (1.329232873104047e-06)*dt1_g0_13;
    dt1_l1_6 = dt1_l1_6 + (0.06737133115530014)*dt1_g0_14;
    dt1_l1_6 = dt1_l1_6 + (4.4838479880127124e-06)*dt1_g0_15;
    dt1_l1_6 = dt1_l1_6 + (0.1200924813747406)*dt1_g0_16;
    dt1_l1_6 = dt1_l1_6 + (1.022621199808782e-05)*dt1_g0_17;
    dt1_l1_6 = dt1_l1_6 + (-6.015204121467832e-07)*dt1_g0_18;
    dt1_l1_6 = dt1_l1_6 + (-0.1717676967382431)*dt1_g0_19;
    dt1_l1_6 = dt1_l1_6 + (5.7488582569931168e-06)*dt1_g0_20;
    dt1_l1_6 = dt1_l1_6 + (-0.51570415496826172)*dt1_g0_21;
    dt1_l1_6 = dt1_l1_6 + (0.25729447603225708)*dt1_g0_22;
    dt1_l1_6 = dt1_l1_6 + (1.7876456695375964e-05)*dt1_g0_23;
    dt1_l1_6 = dt1_l1_6 + (7.6119772529636975e-06)*dt1_g0_24;
    dt1_l1_6 = dt1_l1_6 + (8.7904209067346528e-07)*dt1_g0_25;
    dt1_l1_6 = dt1_l1_6 + (-5.5410837376257405e-06)*dt1_g0_26;
    dt1_l1_6 = dt1_l1_6 + (4.990774868929293e-06)*dt1_g0_27;
    dt1_l1_6 = dt1_l1_6 + (-1.391522164340131e-05)*dt1_g0_28;
    dt1_l1_6 = dt1_l1_6 + (-2.9012385311943945e-06)*dt1_g0_29;
    dt1_l1_6 = dt1_l1_6 + (-6.6828770286520012e-06)*dt1_g0_30;
    dt1_l1_6 = dt1_l1_6 + (-0.1837390661239624)*dt1_g0_31;
    dt1_l1_7 = -0.0092202471569180489;
    dt1_l1_7 = dt1_l1_7 + (0.0074172001332044601)*dt1_g0_0;
    dt1_l1_7 = dt1_l1_7 + (-4.7951166379789356e-06)*dt1_g0_1;
    dt1_l1_7 = dt1_l1_7 + (-3.4282647902728058e-06)*dt1_g0_2;
    dt1_l1_7 = dt1_l1_7 + (-1.1316169548081234e-05)*dt1_g0_3;
    dt1_l1_7 = dt1_l1_7 + (-5.4483793974213768e-06)*dt1_g0_4;
    dt1_l1_7 = dt1_l1_7 + (0.0012444410240277648)*dt1_g0_5;
    dt1_l1_7 = dt1_l1_7 + (3.500225602692808e-06)*dt1_g0_6;
    dt1_l1_7 = dt1_l1_7 + (-7.4570561992004514e-06)*dt1_g0_7;
    dt1_l1_7 = dt1_l1_7 + (-6.299752840277506e-06)*dt1_g0_8;
    dt1_l1_7 = dt1_l1_7 + (7.0404362304543611e-06)*dt1_g0_9;
    dt1_l1_7 = dt1_l1_7 + (-3.6051565075467806e-06)*dt1_g0_10;
    dt1_l1_7 = dt1_l1_7 + (5.511910785571672e-06)*dt1_g0_11;
    dt1_l1_7 = dt1_l1_7 + (-3.8915704863029532e-06)*dt1_g0_12;
    dt1_l1_7 = dt1_l1_7 + (-5.022457116865553e-06)*dt1_g0_13;
    dt1_l1_7 = dt1_l1_7 + (0.011062324047088623)*dt1_g0_14;
    dt1_l1_7 = dt1_l1_7 + (-6.3502366174361669e-06)*dt1_g0_15;
    dt1_l1_7 = dt1_l1_7 + (0.0049811298958957195)*dt1_g0_16;
    dt1_l1_7 = dt1_l1_7 + (3.2094646940095117e-06)*dt1_g0_17;
    dt1_l1_7 = dt1_l1_7 + (-5.8456971601117402e-06)*dt1_g0_18;
    dt1_l1_7 = dt1_l1_7 + (-0.0062924656085669994)*dt1_g0_19;
    dt1_l1_7 = dt1_l1_7 + (-2.8775493774446659e-06)*dt1_g0_20;
    dt1_l1_7 = dt1_l1_7 + (-0.0077516557648777962)*dt1_g0_21;
    dt1_l1_7 = dt1_l1_7 + (0.022175146266818047)*dt1_g0_22;
    dt1_l1_7 = dt1_l1_7 + (2.4248424779216293e-06)*dt1_g0_23;
    dt1_l1_7 = dt1_l1_7 + (4.3025506784033496e-06)*dt1_g0_24;
    dt1_l1_7 = dt1_l1_7 + (-4.8940369197225664e-06)*dt1_g0_25;
    dt1_l1_7 = dt1_l1_7 + (3.7553681977442466e-06)*dt1_g0_26;
    dt1_l1_7 = dt1_l1_7 + (-5.4788124543847516e-06)*dt1_g0_27;
    dt1_l1_7 = dt1_l1_7 + (6.0630140978901181e-06)*dt1_g0_28;
    dt1_l1_7 = dt1_l1_7 + (5.0054572966473643e-06)*dt1_g0_29;
    dt1_l1_7 = dt1_l1_7 + (5.9157628129469231e-06)*dt1_g0_30;
    dt1_l1_7 = dt1_l1_7 + (-0.001369859091937542)*dt1_g0_31;
    dt1_l1_8 = 0.020557314157485962;
    dt1_l1_8 = dt1_l1_8 + (-0.02749934047460556)*dt1_g0_0;
    dt1_l1_8 = dt1_l1_8 + (4.5106888137524948e-05)*dt1_g0_1;
    dt1_l1_8 = dt1_l1_8 + (3.0896659154677764e-05)*dt1_g0_2;
    dt1_l1_8 = dt1_l1_8 + (3.470234150881879e-05)*dt1_g0_3;
    dt1_l1_8 = dt1_l1_8 + (3.6544974136631936e-05)*dt1_g0_4;
    dt1_l1_8 = dt1_l1_8 + (0.036568496376276016)*dt1_g0_5;
    dt1_l1_8 = dt1_l1_8 + (-2.9665154215763323e-05)*dt1_g0_6;
    dt1_l1_8 = dt1_l1_8 + (5.0898033805424348e-05)*dt1_g0_7;
    dt1_l1_8 = dt1_l1_8 + (4.1536517528584227e-05)*dt1_g0_8;
    dt1_l1_8 = dt1_l1_8 + (-3.6097739211982116e-05)*dt1_g0_9;
    dt1_l1_8 = dt1_l1_8 + (6.7573055275715888e-05)*dt1_g0_10;
    dt1_l1_8 = dt1_l1_8 + (-3.7935555155854672e-05)*dt1_g0_11;
    dt1_l1_8 = dt1_l1_8 + (4.3670381273841485e-05)*dt1_g0_12;
    dt1_l1_8 = dt1_l1_8 + (3.9244692743523046e-05)*dt1_g0_13;
    dt1_l1_8 = dt1_l1_8 + (-0.11672371625900269)*dt1_g0_14;
    dt1_l1_8 = dt1_l1_8 + (1.1185228686372284e-05)*dt1_g0_15;
    dt1_l1_8 = dt1_l1_8 + (0.17020195722579956)*dt1_g0_16;
    dt1_l1_8 = dt1_l1_8 + (1.007986611512024e-05)*dt1_g0_17;
    dt1_l1_8 = dt1_l1_8 + (3.2511354220332578e-05)*dt1_g0_18;
    dt1_l1_8 = dt1_l1_8 + (-0.16241995990276337)*dt1_g0_19;
    dt1_l1_8 = dt1_l1_8 + (2.8980930437683128e-05)*dt1_g0_20;
    dt1_l1_8 = dt1_l1_8 + (0.1997077465057373)*dt1_g0_21;
    dt1_l1_8 = dt1_l1_8 + (-0.093216530978679657)*dt1_g0_22;
    dt1_l1_8 = dt1_l1_8 + (4.9495127996124211e-07)*dt1_g0_23;
    dt1_l1_8 = dt1_l1_8 + (8.4393386714509688e-06)*dt1_g0_24;
    dt1_l1_8 = dt1_l1_8 + (3.7210011214483529e-05)*dt1_g0_25;
    dt1_l1_8 = dt1_l1_8 + (-3.6352652386995032e-05)*dt1_g0_26;
    dt1_l1_8 = dt1_l1_8 + (3.4836764825740829e-05)*dt1_g0_27;
    dt1_l1_8 = dt1_l1_8 + (-4.8265545046888292e-05)*dt1_g0_28;
    dt1_l1_8 = dt1_l1_8 + (-3.795682277996093e-05)*dt1_g0_29;
    dt1_l1_8 = dt1_l1_8 + (-4.3928794184466824e-05)*dt1_g0_30;
    dt1_l1_8 = dt1_l1_8 + (-0.12958551943302155)*dt1_g0_31;
    dt1_l1_9 = -0.0092202425003051758;
    dt1_l1_9 = dt1_l1_9 + (0.0074171698652207851)*dt1_g0_0;
    dt1_l1_9 = dt1_l1_9 + (-4.7950575208233204e-06)*dt1_g0_1;
    dt1_l1_9 = dt1_l1_9 + (-3.4282215892744716e-06)*dt1_g0_2;
    dt1_l1_9 = dt1_l1_9 + (-1.1316167729091831e-05)*dt1_g0_3;
    dt1_l1_9 = dt1_l1_9 + (-5.4483211897604633e-06)*dt1_g0_4;
    dt1_l1_9 = dt1_l1_9 + (0.0012443937594071031)*dt1_g0_5;
    dt1_l1_9 = dt1_l1_9 + (3.5001571632164996e-06)*dt1_g0_6;
    dt1_l1_9 = dt1_l1_9 + (-7.4570170909282751e-06)*dt1_g0_7;
    dt1_l1_9 = dt1_l1_9 + (-6.2996896303957328e-06)*dt1_g0_8;
    dt1_l1_9 = dt1_l1_9 + (7.0403862082457636e-06)*dt1_g0_9;
    dt1_l1_9 = dt1_l1_9 + (-3.6051455936103594e-06)*dt1_g0_10;
    dt1_l1_9 = dt1_l1_9 + (5.5118821364885662e-06)*dt1_g0_11;
    dt1_l1_9 = dt1_l1_9 + (-3.8915086406632327e-06)*dt1_g0_12;
    dt1_l1_9 = dt1_l1_9 + (-5.0223939069837797e-06)*dt1_g0_13;
    dt1_l1_9 = dt1_l1_9 + (0.011062433011829853)*dt1_g0_14;
    dt1_l1_9 = dt1_l1_9 + (-6.350199782900745e-06)*dt1_g0_15;
    dt1_l1_9 = dt1_l1_9 + (0.0049811415374279022)*dt1_g0_16;
    dt1_l1_9 = dt1_l1_9 + (3.2094371817947831e-06)*dt1_g0_17;
    dt1_l1_9 = dt1_l1_9 + (-5.8456557781028096e-06)*dt1_g0_18;
    dt1_l1_9 = dt1_l1_9 + (-0.0062924628145992756)*dt1_g0_19;
    dt1_l1_9 = dt1_l1_9 + (-2.8775123155355686e-06)*dt1_g0_20;
    dt1_l1_9 = dt1_l1_9 + (-0.0077515621669590473)*dt1_g0_21;
    dt1_l1_9 = dt1_l1_9 + (0.022175146266818047)*dt1_g0_22;
    dt1_l1_9 = dt1_l1_9 + (2.4248686258943053e-06)*dt1_g0_23;
    dt1_l1_9 = dt1_l1_9 + (4.3025188460887875e-06)*dt1_g0_24;
    dt1_l1_9 = dt1_l1_9 + (-4.8939868975139689e-06)*dt1_g0_25;
    dt1_l1_9 = dt1_l1_9 + (3.7553047604887979e-06)*dt1_g0_26;
    dt1_l1_9 = dt1_l1_9 + (-5.4787642511655577e-06)*dt1_g0_27;
    dt1_l1_9 = dt1_l1_9 + (6.0630191001109779e-06)*dt1_g0_28;
    dt1_l1_9 = dt1_l1_9 + (5.0054045459546614e-06)*dt1_g0_29;
    dt1_l1_9 = dt1_l1_9 + (5.9157059695280623e-06)*dt1_g0_30;
    dt1_l1_9 = dt1_l1_9 + (-0.0013698835391551256)*dt1_g0_31;
    dt1_l1_10 = -0.0092202359810471535;
    dt1_l1_10 = dt1_l1_10 + (0.0074171759188175201)*dt1_g0_0;
    dt1_l1_10 = dt1_l1_10 + (-4.7950411499186885e-06)*dt1_g0_1;
    dt1_l1_10 = dt1_l1_10 + (-3.4281986245332519e-06)*dt1_g0_2;
    dt1_l1_10 = dt1_l1_10 + (-1.1316120435367338e-05)*dt1_g0_3;
    dt1_l1_10 = dt1_l1_10 + (-5.4482907216879539e-06)*dt1_g0_4;
    dt1_l1_10 = dt1_l1_10 + (0.0012443602317944169)*dt1_g0_5;
    dt1_l1_10 = dt1_l1_10 + (3.5001487503905082e-06)*dt1_g0_6;
    dt1_l1_10 = dt1_l1_10 + (-7.4569761636666954e-06)*dt1_g0_7;
    dt1_l1_10 = dt1_l1_10 + (-6.2996518863656092e-06)*dt1_g0_8;
    dt1_l1_10 = dt1_l1_10 + (7.0403648351202719e-06)*dt1_g0_9;
    dt1_l1_10 = dt1_l1_10 + (-3.6051535516889999e-06)*dt1_g0_10;
    dt1_l1_10 = dt1_l1_10 + (5.5118475756898988e-06)*dt1_g0_11;
    dt1_l1_10 = dt1_l1_10 + (-3.8914909055165481e-06)*dt1_g0_12;
    dt1_l1_10 = dt1_l1_10 + (-5.0223793550685514e-06)*dt1_g0_13;
    dt1_l1_10 = dt1_l1_10 + (0.011062489822506905)*dt1_g0_14;
    dt1_l1_10 = dt1_l1_10 + (-6.3502006923954468e-06)*dt1_g0_15;
    dt1_l1_10 = dt1_l1_10 + (0.0049811867065727711)*dt1_g0_16;
    dt1_l1_10 = dt1_l1_10 + (3.209429451089818e-06)*dt1_g0_17;
    dt1_l1_10 = dt1_l1_10 + (-5.8456148508412298e-06)*dt1_g0_18;
    dt1_l1_10 = dt1_l1_10 + (-0.0062924814410507679)*dt1_g0_19;
    dt1_l1_10 = dt1_l1_10 + (-2.8774877591786208e-06)*dt1_g0_20;
    dt1_l1_10 = dt1_l1_10 + (-0.0077515454031527042)*dt1_g0_21;
    dt1_l1_10 = dt1_l1_10 + (0.0221751369535923)*dt1_g0_22;
    dt1_l1_10 = dt1_l1_10 + (2.4247860892501194e-06)*dt1_g0_23;
    dt1_l1_10 = dt1_l1_10 + (4.3025074774050154e-06)*dt1_g0_24;
    dt1_l1_10 = dt1_l1_10 + (-4.8939550651994068e-06)*dt1_g0_25;
    dt1_l1_10 = dt1_l1_10 + (3.7552933918050257e-06)*dt1_g0_26;
    dt1_l1_10 = dt1_l1_10 + (-5.478746970766224e-06)*dt1_g0_27;
    dt1_l1_10 = dt1_l1_10 + (6.0629840845649596e-06)*dt1_g0_28;
    dt1_l1_10 = dt1_l1_10 + (5.0053731683874503e-06)*dt1_g0_29;
    dt1_l1_10 = dt1_l1_10 + (5.9156841416552197e-06)*dt1_g0_30;
    dt1_l1_10 = dt1_l1_10 + (-0.0013698776019737124)*dt1_g0_31;
    dt1_l1_11 = -0.031666874885559082;
    dt1_l1_11 = dt1_l1_11 + (-0.0090516367927193642)*dt1_g0_0;
    dt1_l1_11 = dt1_l1_11 + (-3.6104283935856074e-06)*dt1_g0_1;
    dt1_l1_11 = dt1_l1_11 + (3.3615731354075251e-06)*dt1_g0_2;
    dt1_l1_11 = dt1_l1_11 + (-2.9356197046581656e-05)*dt1_g0_3;
    dt1_l1_11 = dt1_l1_11 + (-4.9025970838556532e-06)*dt1_g0_4;
    dt1_l1_11 = dt1_l1_11 + (0.032653413712978363)*dt1_g0_5;
    dt1_l1_11 = dt1_l1_11 + (-1.1354838534316514e-05)*dt1_g0_6;
    dt1_l1_11 = dt1_l1_11 + (-2.8711381219181931e-06)*dt1_g0_7;
    dt1_l1_11 = dt1_l1_11 + (1.7906284028867958e-06)*dt1_g0_8;
    dt1_l1_11 = dt1_l1_11 + (-2.0090806174266618e-06)*dt1_g0_9;
    dt1_l1_11 = dt1_l1_11 + (-3.0071541914367117e-05)*dt1_g0_10;
    dt1_l1_11 = dt1_l1_11 + (4.3423965507827234e-06)*dt1_g0_11;
    dt1_l1_11 = dt1_l1_11 + (-2.758038135652896e-06)*dt1_g0_12;
    dt1_l1_11 = dt1_l1_11 + (-7.9959409049479291e-06)*dt1_g0_13;
    dt1_l1_11 = dt1_l1_11 + (-0.20774281024932861)*dt1_g0_14;
    dt1_l1_11 = dt1_l1_11 + (2.0053932530572638e-05)*dt1_g0_15;
    dt1_l1_11 = dt1_l1_11 + (-0.52271997928619385)*dt1_g0_16;
    dt1_l1_11 = dt1_l1_11 + (1.244521513399377e-06)*dt1_g0_17;
    dt1_l1_11 = dt1_l1_11 + (6.2670633269590326e-06)*dt1_g0_18;
    dt1_l1_11 = dt1_l1_11 + (-0.14912067353725433)*dt1_g0_19;
    dt1_l1_11 = dt1_l1_11 + (1.7956307374333846e-06)*dt1_g0_20;
    dt1_l1_11 = dt1_l1_11 + (0.013506163842976093)*dt1_g0_21;
    dt1_l1_11 = dt1_l1_11 + (0.22161626815795898)*dt1_g0_22;
    dt1_l1_11 = dt1_l1_11 + (6.394238425855292e-06)*dt1_g0_23;
    dt1_l1_11 = dt1_l1_11 + (-9.9945018519065343e-06)*dt1_g0_24;
    dt1_l1_11 = dt1_l1_11 + (8.6194522737059742e-06)*dt1_g0_25;
    dt1_l1_11 = dt1_l1_11 + (1.6400816775785643e-06)*dt1_g0_26;
    dt1_l1_11 = dt1_l1_11 + (4.8755159696156625e-06)*dt1_g0_27;
    dt1_l1_11 = dt1_l1_11 + (1.2272440471861046e-05)*dt1_g0_28;
    dt1_l1_11 = dt1_l1_11 + (1.5524121408816427e-05)*dt1_g0_29;
    dt1_l1_11 = dt1_l1_11 + (-2.8816376129725541e-07)*dt1_g0_30;
    dt1_l1_11 = dt1_l1_11 + (0.033976655453443527)*dt1_g0_31;
    dt1_l1_12 = -0.0062166904099285603;
    dt1_l1_12 = dt1_l1_12 + (-0.20158196985721588)*dt1_g0_0;
    dt1_l1_12 = dt1_l1_12 + (-2.5460631150053814e-05)*dt1_g0_1;
    dt1_l1_12 = dt1_l1_12 + (-1.2765068277076352e-05)*dt1_g0_2;
    dt1_l1_12 = dt1_l1_12 + (-5.9611073083942756e-05)*dt1_g0_3;
    dt1_l1_12 = dt1_l1_12 + (-2.8436412321752869e-05)*dt1_g0_4;
    dt1_l1_12 = dt1_l1_12 + (-0.070834442973136902)*dt1_g0_5;
    dt1_l1_12 = dt1_l1_12 + (1.9341910956427455e-05)*dt1_g0_6;
    dt1_l1_12 = dt1_l1_12 + (-1.7865977497422136e-05)*dt1_g0_7;
    dt1_l1_12 = dt1_l1_12 + (-3.0507761039189063e-05)*dt1_g0_8;
    dt1_l1_12 = dt1_l1_12 + (3.4206932468805462e-05)*dt1_g0_9;
    dt1_l1_12 = dt1_l1_12 + (-4.9364174628863111e-05)*dt1_g0_10;
    dt1_l1_12 = dt1_l1_12 + (2.2953419829718769e-05)*dt1_g0_11;
    dt1_l1_12 = dt1_l1_12 + (-1.7751313862390816e-05)*dt1_g0_12;
    dt1_l1_12 = dt1_l1_12 + (-3.3157830330310389e-05)*dt1_g0_13;
    dt1_l1_12 = dt1_l1_12 + (0.23380187153816223)*dt1_g0_14;
    dt1_l1_12 = dt1_l1_12 + (8.4281946328701451e-06)*dt1_g0_15;
    dt1_l1_12 = dt1_l1_12 + (-0.033117271959781647)*dt1_g0_16;
    dt1_l1_12 = dt1_l1_12 + (1.6616057109786198e-05)*dt1_g0_17;
    dt1_l1_12 = dt1_l1_12 + (-1.5353301932918839e-05)*dt1_g0_18;
    dt1_l1_12 = dt1_l1_12 + (0.21899636089801788)*dt1_g0_19;
    dt1_l1_12 = dt1_l1_12 + (-1.448372768209083e-05)*dt1_g0_20;
    dt1_l1_12 = dt1_l1_12 + (-0.25044834613800049)*dt1_g0_21;
    dt1_l1_12 = dt1_l1_12 + (-0.082819655537605286)*dt1_g0_22;
    dt1_l1_12 = dt1_l1_12 + (-1.9269737094873562e-05)*dt1_g0_23;
    dt1_l1_12 = dt1_l1_12 + (3.4321240036661038e-06)*dt1_g0_24;
    dt1_l1_12 = dt1_l1_12 + (-3.6190251648804406e-06)*dt1_g0_25;
    dt1_l1_12 = dt1_l1_12 + (2.7439115001470782e-05)*dt1_g0_26;
    dt1_l1_12 = dt1_l1_12 + (-2.7384579880163074e-05)*dt1_g0_27;
    dt1_l1_12 = dt1_l1_12 + (3.4130844142055139e-05)*dt1_g0_28;
    dt1_l1_12 = dt1_l1_12 + (4.4185537262819707e-05)*dt1_g0_29;
    dt1_l1_12 = dt1_l1_12 + (3.1103158107725903e-05)*dt1_g0_30;
    dt1_l1_12 = dt1_l1_12 + (-0.043129730969667435)*dt1_g0_31;
    dt1_l1_13 = 0.025530295446515083;
    dt1_l1_13 = dt1_l1_13 + (0.15520049631595612)*dt1_g0_0;
    dt1_l1_13 = dt1_l1_13 + (-3.6660232581198215e-05)*dt1_g0_1;
    dt1_l1_13 = dt1_l1_13 + (-4.5534681703429669e-05)*dt1_g0_2;
    dt1_l1_13 = dt1_l1_13 + (-1.5075123656060896e-06)*dt1_g0_3;
    dt1_l1_13 = dt1_l1_13 + (-4.3669286242220551e-05)*dt1_g0_4;
    dt1_l1_13 = dt1_l1_13 + (-0.056243117898702621)*dt1_g0_5;
    dt1_l1_13 = dt1_l1_13 + (3.8529615267179906e-05)*dt1_g0_6;
    dt1_l1_13 = dt1_l1_13 + (-3.3103522582678124e-05)*dt1_g0_7;
    dt1_l1_13 = dt1_l1_13 + (-6.0722995840478688e-05)*dt1_g0_8;
    dt1_l1_13 = dt1_l1_13 + (1.8956392523250543e-05)*dt1_g0_9;
    dt1_l1_13 = dt1_l1_13 + (-4.2252195271430537e-05)*dt1_g0_10;
    dt1_l1_13 = dt1_l1_13 + (1.7601305444259197e-05)*dt1_g0_11;
    dt1_l1_13 = dt1_l1_13 + (-4.4738491851603612e-05)*dt1_g0_12;
    dt1_l1_13 = dt1_l1_13 + (-3.2803858630359173e-05)*dt1_g0_13;
    dt1_l1_13 = dt1_l1_13 + (-0.036114614456892014)*dt1_g0_14;
    dt1_l1_13 = dt1_l1_13 + (-2.1566211216850206e-05)*dt1_g0_15;
    dt1_l1_13 = dt1_l1_13 + (-0.046159509569406509)*dt1_g0_16;
    dt1_l1_13 = dt1_l1_13 + (1.0234629371552728e-05)*dt1_g0_17;
    dt1_l1_13 = dt1_l1_13 + (-4.3925567297264934e-05)*dt1_g0_18;
    dt1_l1_13 = dt1_l1_13 + (0.19555991888046265)*dt1_g0_19;
    dt1_l1_13 = dt1_l1_13 + (-5.9092217270517722e-05)*dt1_g0_20;
    dt1_l1_13 = dt1_l1_13 + (0.16028957068920135)*dt1_g0_21;
    dt1_l1_13 = dt1_l1_13 + (0.049317475408315659)*dt1_g0_22;
    dt1_l1_13 = dt1_l1_13 + (-4.824435745831579e-05)*dt1_g0_23;
    dt1_l1_13 = dt1_l1_13 + (1.0115571058122441e-05)*dt1_g0_24;
    dt1_l1_13 = dt1_l1_13 + (-5.9595429775072262e-05)*dt1_g0_25;
    dt1_l1_13 = dt1_l1_13 + (2.9068874937365763e-05)*dt1_g0_26;
    dt1_l1_13 = dt1_l1_13 + (-1.774632437445689e-05)*dt1_g0_27;
    dt1_l1_13 = dt1_l1_13 + (9.8679178336169571e-05)*dt1_g0_28;
    dt1_l1_13 = dt1_l1_13 + (4.5977485569892451e-05)*dt1_g0_29;
    dt1_l1_13 = dt1_l1_13 + (3.5101438697893173e-05)*dt1_g0_30;
    dt1_l1_13 = dt1_l1_13 + (0.06762385368347168)*dt1_g0_31;
    dt1_l1_14 = -0.0092202425003051758;
    dt1_l1_14 = dt1_l1_14 + (0.007417190819978714)*dt1_g0_0;
    dt1_l1_14 = dt1_l1_14 + (-4.7950729822332505e-06)*dt1_g0_1;
    dt1_l1_14 = dt1_l1_14 + (-3.4282297747267876e-06)*dt1_g0_2;
    dt1_l1_14 = dt1_l1_14 + (-1.1316120435367338e-05)*dt1_g0_3;
    dt1_l1_14 = dt1_l1_14 + (-5.4483316489495337e-06)*dt1_g0_4;
    dt1_l1_14 = dt1_l1_14 + (0.001244421349838376)*dt1_g0_5;
    dt1_l1_14 = dt1_l1_14 + (3.5001903597731143e-06)*dt1_g0_6;
    dt1_l1_14 = dt1_l1_14 + (-7.4570052674971521e-06)*dt1_g0_7;
    dt1_l1_14 = dt1_l1_14 + (-6.299705091805663e-06)*dt1_g0_8;
    dt1_l1_14 = dt1_l1_14 + (7.0403930294560269e-06)*dt1_g0_9;
    dt1_l1_14 = dt1_l1_14 + (-3.6051565075467806e-06)*dt1_g0_10;
    dt1_l1_14 = dt1_l1_14 + (5.5118730415415484e-06)*dt1_g0_11;
    dt1_l1_14 = dt1_l1_14 + (-3.8915281947993208e-06)*dt1_g0_12;
    dt1_l1_14 = dt1_l1_14 + (-5.0224139158672187e-06)*dt1_g0_13;
    dt1_l1_14 = dt1_l1_14 + (0.01106240414083004)*dt1_g0_14;
    dt1_l1_14 = dt1_l1_14 + (-6.3502138800686225e-06)*dt1_g0_15;
    dt1_l1_14 = dt1_l1_14 + (0.0049811620265245438)*dt1_g0_16;
    dt1_l1_14 = dt1_l1_14 + (3.2094451398734236e-06)*dt1_g0_17;
    dt1_l1_14 = dt1_l1_14 + (-5.8456530496187042e-06)*dt1_g0_18;
    dt1_l1_14 = dt1_l1_14 + (-0.0062924702651798725)*dt1_g0_19;
    dt1_l1_14 = dt1_l1_14 + (-2.8775179998774547e-06)*dt1_g0_20;
    dt1_l1_14 = dt1_l1_14 + (-0.0077515854500234127)*dt1_g0_21;
    dt1_l1_14 = dt1_l1_14 + (0.022175131365656853)*dt1_g0_22;
    dt1_l1_14 = dt1_l1_14 + (2.4247879082395229e-06)*dt1_g0_23;
    dt1_l1_14 = dt1_l1_14 + (4.3025261220464017e-06)*dt1_g0_24;
    dt1_l1_14 = dt1_l1_14 + (-4.8939937187242322e-06)*dt1_g0_25;
    dt1_l1_14 = dt1_l1_14 + (3.755326360987965e-06)*dt1_g0_26;
    dt1_l1_14 = dt1_l1_14 + (-5.4787733461125754e-06)*dt1_g0_27;
    dt1_l1_14 = dt1_l1_14 + (6.0629909057752229e-06)*dt1_g0_28;
    dt1_l1_14 = dt1_l1_14 + (5.0054122766596265e-06)*dt1_g0_29;
    dt1_l1_14 = dt1_l1_14 + (5.9157187024538871e-06)*dt1_g0_30;
    dt1_l1_14 = dt1_l1_14 + (-0.0013698783004656434)*dt1_g0_31;
    dt1_l1_15 = -0.0092202462255954742;
    dt1_l1_15 = dt1_l1_15 + (0.0074171922169625759)*dt1_g0_0;
    dt1_l1_15 = dt1_l1_15 + (-4.795107088284567e-06)*dt1_g0_1;
    dt1_l1_15 = dt1_l1_15 + (-3.4282566048204899e-06)*dt1_g0_2;
    dt1_l1_15 = dt1_l1_15 + (-1.1316198651911691e-05)*dt1_g0_3;
    dt1_l1_15 = dt1_l1_15 + (-5.4483693929796573e-06)*dt1_g0_4;
    dt1_l1_15 = dt1_l1_15 + (0.0012444109888747334)*dt1_g0_5;
    dt1_l1_15 = dt1_l1_15 + (3.500215825624764e-06)*dt1_g0_6;
    dt1_l1_15 = dt1_l1_15 + (-7.4570530159689952e-06)*dt1_g0_7;
    dt1_l1_15 = dt1_l1_15 + (-6.2997446548251901e-06)*dt1_g0_8;
    dt1_l1_15 = dt1_l1_15 + (7.0404357757070102e-06)*dt1_g0_9;
    dt1_l1_15 = dt1_l1_15 + (-3.6051590086572105e-06)*dt1_g0_10;
    dt1_l1_15 = dt1_l1_15 + (5.5119098760769702e-06)*dt1_g0_11;
    dt1_l1_15 = dt1_l1_15 + (-3.8915586628718302e-06)*dt1_g0_12;
    dt1_l1_15 = dt1_l1_15 + (-5.0224475671711843e-06)*dt1_g0_13;
    dt1_l1_15 = dt1_l1_15 + (0.011062385514378548)*dt1_g0_14;
    dt1_l1_15 = dt1_l1_15 + (-6.3502375269308686e-06)*dt1_g0_15;
    dt1_l1_15 = dt1_l1_15 + (0.0049811168573796749)*dt1_g0_16;
    dt1_l1_15 = dt1_l1_15 + (3.2094642392621608e-06)*dt1_g0_17;
    dt1_l1_15 = dt1_l1_15 + (-5.845693976880284e-06)*dt1_g0_18;
    dt1_l1_15 = dt1_l1_15 + (-0.0062924632802605629)*dt1_g0_19;
    dt1_l1_15 = dt1_l1_15 + (-2.8775432383554289e-06)*dt1_g0_20;
    dt1_l1_15 = dt1_l1_15 + (-0.0077516329474747181)*dt1_g0_21;
    dt1_l1_15 = dt1_l1_15 + (0.022175148129463196)*dt1_g0_22;
    dt1_l1_15 = dt1_l1_15 + (2.4248483896371908e-06)*dt1_g0_23;
    dt1_l1_15 = dt1_l1_15 + (4.3025515878980514e-06)*dt1_g0_24;
    dt1_l1_15 = dt1_l1_15 + (-4.8940296437649522e-06)*dt1_g0_25;
    dt1_l1_15 = dt1_l1_15 + (3.755356601686799e-06)*dt1_g0_26;
    dt1_l1_15 = dt1_l1_15 + (-5.4788088164059445e-06)*dt1_g0_27;
    dt1_l1_15 = dt1_l1_15 + (6.0630241023318376e-06)*dt1_g0_28;
    dt1_l1_15 = dt1_l1_15 + (5.0054468374582939e-06)*dt1_g0_29;
    dt1_l1_15 = dt1_l1_15 + (5.9157559917366598e-06)*dt1_g0_30;
    dt1_l1_15 = dt1_l1_15 + (-0.0013698734110221267)*dt1_g0_31;

    // Device tower token 2
    dt2_l0_0 = (-0.38841116033830092) + (1.2195616960525513)*dev2;
    dt2_l0_1 = (0.03876767767463965) + (0.018948320299386978)*dev2;
    dt2_l0_2 = (0.042276456309877142) + (-0.00044691961375065148)*dev2;
    dt2_l0_3 = (0.036255584126626716) + (0.027163483202457428)*dev2;
    dt2_l0_4 = (0.035035976840259928) + (0.033691637217998505)*dev2;
    dt2_l0_5 = (0.15019964945777042) + (-0.86946827173233032)*dev2;
    dt2_l0_6 = (0.0374653680066959) + (0.020761676132678986)*dev2;
    dt2_l0_7 = (0.03823226390284723) + (0.021645240485668182)*dev2;
    dt2_l0_8 = (0.029304403588169249) + (0.055928267538547516)*dev2;
    dt2_l0_9 = (0.035124547133322956) + (0.035811524838209152)*dev2;
    dt2_l0_10 = (0.040464948167035324) + (0.016222704201936722)*dev2;
    dt2_l0_11 = (0.033851130225150142) + (0.01910720206797123)*dev2;
    dt2_l0_12 = (0.038152373274090219) + (0.022229747846722603)*dev2;
    dt2_l0_13 = (0.035156802227320941) + (0.02716631256043911)*dev2;
    dt2_l0_14 = (-0.25893012823855799) + (0.47177079319953918)*dev2;
    dt2_l0_15 = (0.037103233487003479) + (0.02563852071762085)*dev2;
    dt2_l0_16 = (0.054984265769047191) + (-0.8715357780456543)*dev2;
    dt2_l0_17 = (0.036756974367257104) + (0.019475888460874557)*dev2;
    dt2_l0_18 = (0.037866458149102007) + (0.023528816178441048)*dev2;
    dt2_l0_19 = (-0.31769967926964099) + (0.92190909385681152)*dev2;
    dt2_l0_20 = (0.038452295605569682) + (0.020385686308145523)*dev2;
    dt2_l0_21 = (-0.071508981435061389) + (-1.0305671691894531)*dev2;
    dt2_l0_22 = (0.10580967841128615) + (-1.5255454778671265)*dev2;
    dt2_l0_23 = (0.03586356116599386) + (0.031063420698046684)*dev2;
    dt2_l0_24 = (0.039287422028972063) + (0.018535159528255463)*dev2;
    dt2_l0_25 = (0.037015564455942798) + (0.022205263376235962)*dev2;
    dt2_l0_26 = (0.039587371909460788) + (0.016815893352031708)*dev2;
    dt2_l0_27 = (0.040136989838637394) + (0.01488249097019434)*dev2;
    dt2_l0_28 = (0.038392975970694368) + (0.022590510547161102)*dev2;
    dt2_l0_29 = (0.034286493787878292) + (0.034689158201217651)*dev2;
    dt2_l0_30 = (0.036371889557910105) + (0.029342725872993469)*dev2;
    dt2_l0_31 = (-0.096386289066272113) + (1.0588947534561157)*dev2;
    dt2_mean = (dt2_l0_0 + dt2_l0_1 + dt2_l0_2 + dt2_l0_3 + dt2_l0_4 + dt2_l0_5 + dt2_l0_6 + dt2_l0_7 + dt2_l0_8 + dt2_l0_9 + dt2_l0_10 + dt2_l0_11 + dt2_l0_12 + dt2_l0_13 + dt2_l0_14 + dt2_l0_15 + dt2_l0_16 + dt2_l0_17 + dt2_l0_18 + dt2_l0_19 + dt2_l0_20 + dt2_l0_21 + dt2_l0_22 + dt2_l0_23 + dt2_l0_24 + dt2_l0_25 + dt2_l0_26 + dt2_l0_27 + dt2_l0_28 + dt2_l0_29 + dt2_l0_30 + dt2_l0_31) / 32;
    dt2_var = (((dt2_l0_0) - dt2_mean)*((dt2_l0_0) - dt2_mean) + ((dt2_l0_1) - dt2_mean)*((dt2_l0_1) - dt2_mean) + ((dt2_l0_2) - dt2_mean)*((dt2_l0_2) - dt2_mean) + ((dt2_l0_3) - dt2_mean)*((dt2_l0_3) - dt2_mean) + ((dt2_l0_4) - dt2_mean)*((dt2_l0_4) - dt2_mean) + ((dt2_l0_5) - dt2_mean)*((dt2_l0_5) - dt2_mean) + ((dt2_l0_6) - dt2_mean)*((dt2_l0_6) - dt2_mean) + ((dt2_l0_7) - dt2_mean)*((dt2_l0_7) - dt2_mean) + ((dt2_l0_8) - dt2_mean)*((dt2_l0_8) - dt2_mean) + ((dt2_l0_9) - dt2_mean)*((dt2_l0_9) - dt2_mean) + ((dt2_l0_10) - dt2_mean)*((dt2_l0_10) - dt2_mean) + ((dt2_l0_11) - dt2_mean)*((dt2_l0_11) - dt2_mean) + ((dt2_l0_12) - dt2_mean)*((dt2_l0_12) - dt2_mean) + ((dt2_l0_13) - dt2_mean)*((dt2_l0_13) - dt2_mean) + ((dt2_l0_14) - dt2_mean)*((dt2_l0_14) - dt2_mean) + ((dt2_l0_15) - dt2_mean)*((dt2_l0_15) - dt2_mean) + ((dt2_l0_16) - dt2_mean)*((dt2_l0_16) - dt2_mean) + ((dt2_l0_17) - dt2_mean)*((dt2_l0_17) - dt2_mean) + ((dt2_l0_18) - dt2_mean)*((dt2_l0_18) - dt2_mean) + ((dt2_l0_19) - dt2_mean)*((dt2_l0_19) - dt2_mean) + ((dt2_l0_20) - dt2_mean)*((dt2_l0_20) - dt2_mean) + ((dt2_l0_21) - dt2_mean)*((dt2_l0_21) - dt2_mean) + ((dt2_l0_22) - dt2_mean)*((dt2_l0_22) - dt2_mean) + ((dt2_l0_23) - dt2_mean)*((dt2_l0_23) - dt2_mean) + ((dt2_l0_24) - dt2_mean)*((dt2_l0_24) - dt2_mean) + ((dt2_l0_25) - dt2_mean)*((dt2_l0_25) - dt2_mean) + ((dt2_l0_26) - dt2_mean)*((dt2_l0_26) - dt2_mean) + ((dt2_l0_27) - dt2_mean)*((dt2_l0_27) - dt2_mean) + ((dt2_l0_28) - dt2_mean)*((dt2_l0_28) - dt2_mean) + ((dt2_l0_29) - dt2_mean)*((dt2_l0_29) - dt2_mean) + ((dt2_l0_30) - dt2_mean)*((dt2_l0_30) - dt2_mean) + ((dt2_l0_31) - dt2_mean)*((dt2_l0_31) - dt2_mean)) / 32;
    dt2_n0_0 = (((dt2_l0_0) - dt2_mean) / sqrt(dt2_var + ln_eps)) * (0.843211829662323) + (0.10046378523111343);
    dt2_n0_1 = (((dt2_l0_1) - dt2_mean) / sqrt(dt2_var + ln_eps)) * (2.7206051527173258e-06) + (-1.6632851611575461e-06);
    dt2_n0_2 = (((dt2_l0_2) - dt2_mean) / sqrt(dt2_var + ln_eps)) * (-6.2584508668805938e-06) + (1.0455639767315006e-06);
    dt2_n0_3 = (((dt2_l0_3) - dt2_mean) / sqrt(dt2_var + ln_eps)) * (-6.9736793193442281e-06) + (-1.0999922778864857e-05);
    dt2_n0_4 = (((dt2_l0_4) - dt2_mean) / sqrt(dt2_var + ln_eps)) * (9.8267028079135343e-06) + (-6.5247531892964616e-06);
    dt2_n0_5 = (((dt2_l0_5) - dt2_mean) / sqrt(dt2_var + ln_eps)) * (0.27213570475578308) + (-0.0039989589713513851);
    dt2_n0_6 = (((dt2_l0_6) - dt2_mean) / sqrt(dt2_var + ln_eps)) * (-3.4977392715518363e-06) + (3.6835772210253026e-09);
    dt2_n0_7 = (((dt2_l0_7) - dt2_mean) / sqrt(dt2_var + ln_eps)) * (2.5401395760127343e-06) + (-7.8833654697518796e-06);
    dt2_n0_8 = (((dt2_l0_8) - dt2_mean) / sqrt(dt2_var + ln_eps)) * (4.0655754673935007e-06) + (-3.8788698475400452e-06);
    dt2_n0_9 = (((dt2_l0_9) - dt2_mean) / sqrt(dt2_var + ln_eps)) * (-4.6432196540990844e-06) + (7.3355377026018687e-06);
    dt2_n0_10 = (((dt2_l0_10) - dt2_mean) / sqrt(dt2_var + ln_eps)) * (3.574464471967076e-06) + (-2.2624096800427651e-06);
    dt2_n0_11 = (((dt2_l0_11) - dt2_mean) / sqrt(dt2_var + ln_eps)) * (1.3387105354922824e-05) + (2.8874530926259467e-06);
    dt2_n0_12 = (((dt2_l0_12) - dt2_mean) / sqrt(dt2_var + ln_eps)) * (-1.8776631804939825e-06) + (1.60305955887452e-06);
    dt2_n0_13 = (((dt2_l0_13) - dt2_mean) / sqrt(dt2_var + ln_eps)) * (1.0976241355820093e-06) + (-1.4980198557168478e-06);
    dt2_n0_14 = (((dt2_l0_14) - dt2_mean) / sqrt(dt2_var + ln_eps)) * (0.84664261341094971) + (-0.10655493289232254);
    dt2_n0_15 = (((dt2_l0_15) - dt2_mean) / sqrt(dt2_var + ln_eps)) * (2.9659940992132761e-06) + (1.6667630688971258e-06);
    dt2_n0_16 = (((dt2_l0_16) - dt2_mean) / sqrt(dt2_var + ln_eps)) * (1.0360937118530273) + (0.083679109811782837);
    dt2_n0_17 = (((dt2_l0_17) - dt2_mean) / sqrt(dt2_var + ln_eps)) * (-3.2341320093109971e-06) + (5.0602602641447447e-07);
    dt2_n0_18 = (((dt2_l0_18) - dt2_mean) / sqrt(dt2_var + ln_eps)) * (-6.2578095594290062e-07) + (-2.8663500870607095e-06);
    dt2_n0_19 = (((dt2_l0_19) - dt2_mean) / sqrt(dt2_var + ln_eps)) * (0.78893840312957764) + (-0.077350124716758728);
    dt2_n0_20 = (((dt2_l0_20) - dt2_mean) / sqrt(dt2_var + ln_eps)) * (4.0180102587328292e-06) + (-4.8921708639682038e-07);
    dt2_n0_21 = (((dt2_l0_21) - dt2_mean) / sqrt(dt2_var + ln_eps)) * (0.85818284749984741) + (-0.028547178953886032);
    dt2_n0_22 = (((dt2_l0_22) - dt2_mean) / sqrt(dt2_var + ln_eps)) * (0.83205467462539673) + (0.17346389591693878);
    dt2_n0_23 = (((dt2_l0_23) - dt2_mean) / sqrt(dt2_var + ln_eps)) * (1.504554438724881e-05) + (9.2961727204965428e-06);
    dt2_n0_24 = (((dt2_l0_24) - dt2_mean) / sqrt(dt2_var + ln_eps)) * (-1.26005252241157e-05) + (3.5688885873241816e-06);
    dt2_n0_25 = (((dt2_l0_25) - dt2_mean) / sqrt(dt2_var + ln_eps)) * (1.1577288205444347e-05) + (-4.1063835851673502e-06);
    dt2_n0_26 = (((dt2_l0_26) - dt2_mean) / sqrt(dt2_var + ln_eps)) * (-1.030867042572936e-05) + (3.3574026474525454e-06);
    dt2_n0_27 = (((dt2_l0_27) - dt2_mean) / sqrt(dt2_var + ln_eps)) * (8.7807520685601048e-06) + (-6.0104152908024844e-06);
    dt2_n0_28 = (((dt2_l0_28) - dt2_mean) / sqrt(dt2_var + ln_eps)) * (1.1751266356441192e-05) + (3.8589575979131041e-07);
    dt2_n0_29 = (((dt2_l0_29) - dt2_mean) / sqrt(dt2_var + ln_eps)) * (-1.6195903072002693e-06) + (3.1835461413720623e-06);
    dt2_n0_30 = (((dt2_l0_30) - dt2_mean) / sqrt(dt2_var + ln_eps)) * (-4.8718366087996401e-06) + (5.3302196647564415e-06);
    dt2_n0_31 = (((dt2_l0_31) - dt2_mean) / sqrt(dt2_var + ln_eps)) * (0.53329497575759888) + (-0.060209508985280991);
    dt2_g0_0 = gelu_approx(dt2_n0_0);
    dt2_g0_1 = gelu_approx(dt2_n0_1);
    dt2_g0_2 = gelu_approx(dt2_n0_2);
    dt2_g0_3 = gelu_approx(dt2_n0_3);
    dt2_g0_4 = gelu_approx(dt2_n0_4);
    dt2_g0_5 = gelu_approx(dt2_n0_5);
    dt2_g0_6 = gelu_approx(dt2_n0_6);
    dt2_g0_7 = gelu_approx(dt2_n0_7);
    dt2_g0_8 = gelu_approx(dt2_n0_8);
    dt2_g0_9 = gelu_approx(dt2_n0_9);
    dt2_g0_10 = gelu_approx(dt2_n0_10);
    dt2_g0_11 = gelu_approx(dt2_n0_11);
    dt2_g0_12 = gelu_approx(dt2_n0_12);
    dt2_g0_13 = gelu_approx(dt2_n0_13);
    dt2_g0_14 = gelu_approx(dt2_n0_14);
    dt2_g0_15 = gelu_approx(dt2_n0_15);
    dt2_g0_16 = gelu_approx(dt2_n0_16);
    dt2_g0_17 = gelu_approx(dt2_n0_17);
    dt2_g0_18 = gelu_approx(dt2_n0_18);
    dt2_g0_19 = gelu_approx(dt2_n0_19);
    dt2_g0_20 = gelu_approx(dt2_n0_20);
    dt2_g0_21 = gelu_approx(dt2_n0_21);
    dt2_g0_22 = gelu_approx(dt2_n0_22);
    dt2_g0_23 = gelu_approx(dt2_n0_23);
    dt2_g0_24 = gelu_approx(dt2_n0_24);
    dt2_g0_25 = gelu_approx(dt2_n0_25);
    dt2_g0_26 = gelu_approx(dt2_n0_26);
    dt2_g0_27 = gelu_approx(dt2_n0_27);
    dt2_g0_28 = gelu_approx(dt2_n0_28);
    dt2_g0_29 = gelu_approx(dt2_n0_29);
    dt2_g0_30 = gelu_approx(dt2_n0_30);
    dt2_g0_31 = gelu_approx(dt2_n0_31);
    dt2_l1_0 = 0.07863936573266983;
    dt2_l1_0 = dt2_l1_0 + (0.09521186351776123)*dt2_g0_0;
    dt2_l1_0 = dt2_l1_0 + (-2.6276595235685818e-05)*dt2_g0_1;
    dt2_l1_0 = dt2_l1_0 + (-2.5888028176268563e-05)*dt2_g0_2;
    dt2_l1_0 = dt2_l1_0 + (-5.9903377405134961e-05)*dt2_g0_3;
    dt2_l1_0 = dt2_l1_0 + (-3.0735114705748856e-05)*dt2_g0_4;
    dt2_l1_0 = dt2_l1_0 + (0.20419855415821075)*dt2_g0_5;
    dt2_l1_0 = dt2_l1_0 + (1.9859808162436821e-05)*dt2_g0_6;
    dt2_l1_0 = dt2_l1_0 + (-4.5337787014432251e-05)*dt2_g0_7;
    dt2_l1_0 = dt2_l1_0 + (-2.5618910513003357e-05)*dt2_g0_8;
    dt2_l1_0 = dt2_l1_0 + (3.65683481504675e-05)*dt2_g0_9;
    dt2_l1_0 = dt2_l1_0 + (8.6936415755189955e-06)*dt2_g0_10;
    dt2_l1_0 = dt2_l1_0 + (4.0928891394287348e-05)*dt2_g0_11;
    dt2_l1_0 = dt2_l1_0 + (-1.9896786398021504e-05)*dt2_g0_12;
    dt2_l1_0 = dt2_l1_0 + (-2.837985084624961e-05)*dt2_g0_13;
    dt2_l1_0 = dt2_l1_0 + (0.3629240095615387)*dt2_g0_14;
    dt2_l1_0 = dt2_l1_0 + (-9.6212206699419767e-06)*dt2_g0_15;
    dt2_l1_0 = dt2_l1_0 + (0.067542426288127899)*dt2_g0_16;
    dt2_l1_0 = dt2_l1_0 + (2.2813670511823148e-05)*dt2_g0_17;
    dt2_l1_0 = dt2_l1_0 + (-3.8062858948251233e-05)*dt2_g0_18;
    dt2_l1_0 = dt2_l1_0 + (0.0051724417135119438)*dt2_g0_19;
    dt2_l1_0 = dt2_l1_0 + (-1.3537222912418656e-05)*dt2_g0_20;
    dt2_l1_0 = dt2_l1_0 + (-0.32233437895774841)*dt2_g0_21;
    dt2_l1_0 = dt2_l1_0 + (-0.039486300200223923)*dt2_g0_22;
    dt2_l1_0 = dt2_l1_0 + (4.4735566916642711e-05)*dt2_g0_23;
    dt2_l1_0 = dt2_l1_0 + (2.3966475055203773e-05)*dt2_g0_24;
    dt2_l1_0 = dt2_l1_0 + (-3.0044160666875541e-05)*dt2_g0_25;
    dt2_l1_0 = dt2_l1_0 + (2.1940304577583447e-05)*dt2_g0_26;
    dt2_l1_0 = dt2_l1_0 + (-3.2977310183923692e-05)*dt2_g0_27;
    dt2_l1_0 = dt2_l1_0 + (1.5462126611964777e-05)*dt2_g0_28;
    dt2_l1_0 = dt2_l1_0 + (2.3663053070777096e-05)*dt2_g0_29;
    dt2_l1_0 = dt2_l1_0 + (3.0054983653826639e-05)*dt2_g0_30;
    dt2_l1_0 = dt2_l1_0 + (0.067137621343135834)*dt2_g0_31;
    dt2_l1_1 = -0.0092202415689826012;
    dt2_l1_1 = dt2_l1_1 + (0.0074171749874949455)*dt2_g0_0;
    dt2_l1_1 = dt2_l1_1 + (-4.7950475163816009e-06)*dt2_g0_1;
    dt2_l1_1 = dt2_l1_1 + (-3.4282065826118924e-06)*dt2_g0_2;
    dt2_l1_1 = dt2_l1_1 + (-1.1316158634144813e-05)*dt2_g0_3;
    dt2_l1_1 = dt2_l1_1 + (-5.4483066378452349e-06)*dt2_g0_4;
    dt2_l1_1 = dt2_l1_1 + (0.0012443787418305874)*dt2_g0_5;
    dt2_l1_1 = dt2_l1_1 + (3.5001457945327275e-06)*dt2_g0_6;
    dt2_l1_1 = dt2_l1_1 + (-7.4570029937603977e-06)*dt2_g0_7;
    dt2_l1_1 = dt2_l1_1 + (-6.29967280474375e-06)*dt2_g0_8;
    dt2_l1_1 = dt2_l1_1 + (7.0403816607722547e-06)*dt2_g0_9;
    dt2_l1_1 = dt2_l1_1 + (-3.6051681036042282e-06)*dt2_g0_10;
    dt2_l1_1 = dt2_l1_1 + (5.5118712225521449e-06)*dt2_g0_11;
    dt2_l1_1 = dt2_l1_1 + (-3.8914945434953552e-06)*dt2_g0_12;
    dt2_l1_1 = dt2_l1_1 + (-5.0223870857735164e-06)*dt2_g0_13;
    dt2_l1_1 = dt2_l1_1 + (0.011062460020184517)*dt2_g0_14;
    dt2_l1_1 = dt2_l1_1 + (-6.3501947806798853e-06)*dt2_g0_15;
    dt2_l1_1 = dt2_l1_1 + (0.0049811596982181072)*dt2_g0_16;
    dt2_l1_1 = dt2_l1_1 + (3.2094264952320373e-06)*dt2_g0_17;
    dt2_l1_1 = dt2_l1_1 + (-5.8456348597246688e-06)*dt2_g0_18;
    dt2_l1_1 = dt2_l1_1 + (-0.0062924828380346298)*dt2_g0_19;
    dt2_l1_1 = dt2_l1_1 + (-2.8774959446309367e-06)*dt2_g0_20;
    dt2_l1_1 = dt2_l1_1 + (-0.0077515658922493458)*dt2_g0_21;
    dt2_l1_1 = dt2_l1_1 + (0.022175149992108345)*dt2_g0_22;
    dt2_l1_1 = dt2_l1_1 + (2.4248131467174971e-06)*dt2_g0_23;
    dt2_l1_1 = dt2_l1_1 + (4.3025020204368047e-06)*dt2_g0_24;
    dt2_l1_1 = dt2_l1_1 + (-4.8939637053990737e-06)*dt2_g0_25;
    dt2_l1_1 = dt2_l1_1 + (3.7552931644313503e-06)*dt2_g0_26;
    dt2_l1_1 = dt2_l1_1 + (-5.4787583394499961e-06)*dt2_g0_27;
    dt2_l1_1 = dt2_l1_1 + (6.0630209191003814e-06)*dt2_g0_28;
    dt2_l1_1 = dt2_l1_1 + (5.0053927225235384e-06)*dt2_g0_29;
    dt2_l1_1 = dt2_l1_1 + (5.9157014220545534e-06)*dt2_g0_30;
    dt2_l1_1 = dt2_l1_1 + (-0.0013698715483769774)*dt2_g0_31;
    dt2_l1_2 = -0.054556742310523987;
    dt2_l1_2 = dt2_l1_2 + (-0.11475023627281189)*dt2_g0_0;
    dt2_l1_2 = dt2_l1_2 + (-2.2050206098356284e-05)*dt2_g0_1;
    dt2_l1_2 = dt2_l1_2 + (-2.3636228434043005e-05)*dt2_g0_2;
    dt2_l1_2 = dt2_l1_2 + (-4.0239618101622909e-05)*dt2_g0_3;
    dt2_l1_2 = dt2_l1_2 + (-2.4587043299106881e-05)*dt2_g0_4;
    dt2_l1_2 = dt2_l1_2 + (-0.081742040812969208)*dt2_g0_5;
    dt2_l1_2 = dt2_l1_2 + (1.778024306986481e-05)*dt2_g0_6;
    dt2_l1_2 = dt2_l1_2 + (-3.4487980883568525e-05)*dt2_g0_7;
    dt2_l1_2 = dt2_l1_2 + (-1.8637536413734779e-05)*dt2_g0_8;
    dt2_l1_2 = dt2_l1_2 + (2.5554181775078177e-05)*dt2_g0_9;
    dt2_l1_2 = dt2_l1_2 + (1.6197418517549522e-05)*dt2_g0_10;
    dt2_l1_2 = dt2_l1_2 + (2.9932547477073967e-05)*dt2_g0_11;
    dt2_l1_2 = dt2_l1_2 + (-1.8899074348155409e-05)*dt2_g0_12;
    dt2_l1_2 = dt2_l1_2 + (-2.3010863515082747e-05)*dt2_g0_13;
    dt2_l1_2 = dt2_l1_2 + (-0.091811060905456543)*dt2_g0_14;
    dt2_l1_2 = dt2_l1_2 + (-1.1534952136571519e-05)*dt2_g0_15;
    dt2_l1_2 = dt2_l1_2 + (-0.14485783874988556)*dt2_g0_16;
    dt2_l1_2 = dt2_l1_2 + (2.2519809135701507e-05)*dt2_g0_17;
    dt2_l1_2 = dt2_l1_2 + (-3.1300496630137786e-05)*dt2_g0_18;
    dt2_l1_2 = dt2_l1_2 + (-0.11977535486221313)*dt2_g0_19;
    dt2_l1_2 = dt2_l1_2 + (-1.1793315934482962e-05)*dt2_g0_20;
    dt2_l1_2 = dt2_l1_2 + (0.25181648135185242)*dt2_g0_21;
    dt2_l1_2 = dt2_l1_2 + (-0.20050008594989777)*dt2_g0_22;
    dt2_l1_2 = dt2_l1_2 + (3.3441781852161512e-05)*dt2_g0_23;
    dt2_l1_2 = dt2_l1_2 + (2.4673528969287872e-05)*dt2_g0_24;
    dt2_l1_2 = dt2_l1_2 + (-2.8681350158876739e-05)*dt2_g0_25;
    dt2_l1_2 = dt2_l1_2 + (1.8679962522583082e-05)*dt2_g0_26;
    dt2_l1_2 = dt2_l1_2 + (-2.4577928343205713e-05)*dt2_g0_27;
    dt2_l1_2 = dt2_l1_2 + (2.2437554889620515e-06)*dt2_g0_28;
    dt2_l1_2 = dt2_l1_2 + (1.5454967069672421e-05)*dt2_g0_29;
    dt2_l1_2 = dt2_l1_2 + (2.1073970856377855e-05)*dt2_g0_30;
    dt2_l1_2 = dt2_l1_2 + (0.28076320886611938)*dt2_g0_31;
    dt2_l1_3 = 0.0069250846281647682;
    dt2_l1_3 = dt2_l1_3 + (-0.20002850890159607)*dt2_g0_0;
    dt2_l1_3 = dt2_l1_3 + (0.00012122812040615827)*dt2_g0_1;
    dt2_l1_3 = dt2_l1_3 + (0.00010440648475196213)*dt2_g0_2;
    dt2_l1_3 = dt2_l1_3 + (0.00020597409456968307)*dt2_g0_3;
    dt2_l1_3 = dt2_l1_3 + (0.0001197444653371349)*dt2_g0_4;
    dt2_l1_3 = dt2_l1_3 + (0.11727102845907211)*dt2_g0_5;
    dt2_l1_3 = dt2_l1_3 + (-0.0001155518984887749)*dt2_g0_6;
    dt2_l1_3 = dt2_l1_3 + (0.00015998477465473115)*dt2_g0_7;
    dt2_l1_3 = dt2_l1_3 + (0.00013909452536609024)*dt2_g0_8;
    dt2_l1_3 = dt2_l1_3 + (-0.00017011263116728514)*dt2_g0_9;
    dt2_l1_3 = dt2_l1_3 + (5.9865098592126742e-05)*dt2_g0_10;
    dt2_l1_3 = dt2_l1_3 + (-0.00015404204896185547)*dt2_g0_11;
    dt2_l1_3 = dt2_l1_3 + (9.32334951357916e-05)*dt2_g0_12;
    dt2_l1_3 = dt2_l1_3 + (0.000120447417430114)*dt2_g0_13;
    dt2_l1_3 = dt2_l1_3 + (-0.083557084202766418)*dt2_g0_14;
    dt2_l1_3 = dt2_l1_3 + (4.2947609472321346e-05)*dt2_g0_15;
    dt2_l1_3 = dt2_l1_3 + (0.093954339623451233)*dt2_g0_16;
    dt2_l1_3 = dt2_l1_3 + (-3.5744946217164397e-05)*dt2_g0_17;
    dt2_l1_3 = dt2_l1_3 + (0.00013965979451313615)*dt2_g0_18;
    dt2_l1_3 = dt2_l1_3 + (0.23021359741687775)*dt2_g0_19;
    dt2_l1_3 = dt2_l1_3 + (7.7469136158470064e-05)*dt2_g0_20;
    dt2_l1_3 = dt2_l1_3 + (0.25050327181816101)*dt2_g0_21;
    dt2_l1_3 = dt2_l1_3 + (0.061861880123615265)*dt2_g0_22;
    dt2_l1_3 = dt2_l1_3 + (-7.4739029514603317e-05)*dt2_g0_23;
    dt2_l1_3 = dt2_l1_3 + (-4.0087521483656019e-05)*dt2_g0_24;
    dt2_l1_3 = dt2_l1_3 + (0.00010163952538277954)*dt2_g0_25;
    dt2_l1_3 = dt2_l1_3 + (-0.00011079228715971112)*dt2_g0_26;
    dt2_l1_3 = dt2_l1_3 + (0.00015467824414372444)*dt2_g0_27;
    dt2_l1_3 = dt2_l1_3 + (-0.00013554334873333573)*dt2_g0_28;
    dt2_l1_3 = dt2_l1_3 + (-0.00012356755905784667)*dt2_g0_29;
    dt2_l1_3 = dt2_l1_3 + (-0.00015409041952807456)*dt2_g0_30;
    dt2_l1_3 = dt2_l1_3 + (-0.16506032645702362)*dt2_g0_31;
    dt2_l1_4 = -0.009220244362950325;
    dt2_l1_4 = dt2_l1_4 + (0.0074171894229948521)*dt2_g0_0;
    dt2_l1_4 = dt2_l1_4 + (-4.7950984480849002e-06)*dt2_g0_1;
    dt2_l1_4 = dt2_l1_4 + (-3.4282509204786038e-06)*dt2_g0_2;
    dt2_l1_4 = dt2_l1_4 + (-1.131618773797527e-05)*dt2_g0_3;
    dt2_l1_4 = dt2_l1_4 + (-5.4483616622746922e-06)*dt2_g0_4;
    dt2_l1_4 = dt2_l1_4 + (0.0012444290332496166)*dt2_g0_5;
    dt2_l1_4 = dt2_l1_4 + (3.5001980904780794e-06)*dt2_g0_6;
    dt2_l1_4 = dt2_l1_4 + (-7.4570571086951531e-06)*dt2_g0_7;
    dt2_l1_4 = dt2_l1_4 + (-6.299732831394067e-06)*dt2_g0_8;
    dt2_l1_4 = dt2_l1_4 + (7.0404253165179398e-06)*dt2_g0_9;
    dt2_l1_4 = dt2_l1_4 + (-3.6051631013833685e-06)*dt2_g0_10;
    dt2_l1_4 = dt2_l1_4 + (5.5119116950663738e-06)*dt2_g0_11;
    dt2_l1_4 = dt2_l1_4 + (-3.8915482036827598e-06)*dt2_g0_12;
    dt2_l1_4 = dt2_l1_4 + (-5.0224366532347631e-06)*dt2_g0_13;
    dt2_l1_4 = dt2_l1_4 + (0.011062382720410824)*dt2_g0_14;
    dt2_l1_4 = dt2_l1_4 + (-6.350232069962658e-06)*dt2_g0_15;
    dt2_l1_4 = dt2_l1_4 + (0.0049811564385890961)*dt2_g0_16;
    dt2_l1_4 = dt2_l1_4 + (3.2094562811835203e-06)*dt2_g0_17;
    dt2_l1_4 = dt2_l1_4 + (-5.845689884154126e-06)*dt2_g0_18;
    dt2_l1_4 = dt2_l1_4 + (-0.006292473990470171)*dt2_g0_19;
    dt2_l1_4 = dt2_l1_4 + (-2.8775357350241393e-06)*dt2_g0_20;
    dt2_l1_4 = dt2_l1_4 + (-0.0077515956945717335)*dt2_g0_21;
    dt2_l1_4 = dt2_l1_4 + (0.022175129503011703)*dt2_g0_22;
    dt2_l1_4 = dt2_l1_4 + (2.4248633962997701e-06)*dt2_g0_23;
    dt2_l1_4 = dt2_l1_4 + (4.3025429476983845e-06)*dt2_g0_24;
    dt2_l1_4 = dt2_l1_4 + (-4.8940241867967416e-06)*dt2_g0_25;
    dt2_l1_4 = dt2_l1_4 + (3.7553436413872987e-06)*dt2_g0_26;
    dt2_l1_4 = dt2_l1_4 + (-5.4788001762062777e-06)*dt2_g0_27;
    dt2_l1_4 = dt2_l1_4 + (6.0630350162682589e-06)*dt2_g0_28;
    dt2_l1_4 = dt2_l1_4 + (5.0054395615006797e-06)*dt2_g0_29;
    dt2_l1_4 = dt2_l1_4 + (5.9157500800210983e-06)*dt2_g0_30;
    dt2_l1_4 = dt2_l1_4 + (-0.0013698672410100698)*dt2_g0_31;
    dt2_l1_5 = -0.010299425572156906;
    dt2_l1_5 = dt2_l1_5 + (-0.019222021102905273)*dt2_g0_0;
    dt2_l1_5 = dt2_l1_5 + (-1.0141934581042733e-05)*dt2_g0_1;
    dt2_l1_5 = dt2_l1_5 + (-3.5136697533744154e-06)*dt2_g0_2;
    dt2_l1_5 = dt2_l1_5 + (3.7071269616717473e-05)*dt2_g0_3;
    dt2_l1_5 = dt2_l1_5 + (-2.195977913288516e-06)*dt2_g0_4;
    dt2_l1_5 = dt2_l1_5 + (-0.0010503833182156086)*dt2_g0_5;
    dt2_l1_5 = dt2_l1_5 + (7.927470505819656e-06)*dt2_g0_6;
    dt2_l1_5 = dt2_l1_5 + (1.3052414942649193e-05)*dt2_g0_7;
    dt2_l1_5 = dt2_l1_5 + (4.0837808228388894e-06)*dt2_g0_8;
    dt2_l1_5 = dt2_l1_5 + (-9.3975322670303285e-06)*dt2_g0_9;
    dt2_l1_5 = dt2_l1_5 + (-3.5394165024627e-05)*dt2_g0_10;
    dt2_l1_5 = dt2_l1_5 + (-1.9062243154621683e-05)*dt2_g0_11;
    dt2_l1_5 = dt2_l1_5 + (-1.4862144780636299e-05)*dt2_g0_12;
    dt2_l1_5 = dt2_l1_5 + (-9.2636173576465808e-06)*dt2_g0_13;
    dt2_l1_5 = dt2_l1_5 + (-0.097159318625926971)*dt2_g0_14;
    dt2_l1_5 = dt2_l1_5 + (2.0512221453827806e-05)*dt2_g0_15;
    dt2_l1_5 = dt2_l1_5 + (0.2089591771364212)*dt2_g0_16;
    dt2_l1_5 = dt2_l1_5 + (-2.2365591121342732e-06)*dt2_g0_17;
    dt2_l1_5 = dt2_l1_5 + (7.9388446465600282e-06)*dt2_g0_18;
    dt2_l1_5 = dt2_l1_5 + (-0.042912889271974564)*dt2_g0_19;
    dt2_l1_5 = dt2_l1_5 + (-2.026791207754286e-06)*dt2_g0_20;
    dt2_l1_5 = dt2_l1_5 + (-0.073992572724819183)*dt2_g0_21;
    dt2_l1_5 = dt2_l1_5 + (0.047116514295339584)*dt2_g0_22;
    dt2_l1_5 = dt2_l1_5 + (-0.00010094667959492654)*dt2_g0_23;
    dt2_l1_5 = dt2_l1_5 + (-4.6528043640137184e-06)*dt2_g0_24;
    dt2_l1_5 = dt2_l1_5 + (-1.2978689483134076e-05)*dt2_g0_25;
    dt2_l1_5 = dt2_l1_5 + (9.7785505204228684e-06)*dt2_g0_26;
    dt2_l1_5 = dt2_l1_5 + (4.0318846004083753e-06)*dt2_g0_27;
    dt2_l1_5 = dt2_l1_5 + (-2.9880278816563077e-05)*dt2_g0_28;
    dt2_l1_5 = dt2_l1_5 + (-8.4235762187745422e-06)*dt2_g0_29;
    dt2_l1_5 = dt2_l1_5 + (-4.9168957048095763e-06)*dt2_g0_30;
    dt2_l1_5 = dt2_l1_5 + (0.14125142991542816)*dt2_g0_31;
    dt2_l1_6 = -0.1312904953956604;
    dt2_l1_6 = dt2_l1_6 + (0.37175250053405762)*dt2_g0_0;
    dt2_l1_6 = dt2_l1_6 + (4.33431523561012e-06)*dt2_g0_1;
    dt2_l1_6 = dt2_l1_6 + (2.5241517960239435e-06)*dt2_g0_2;
    dt2_l1_6 = dt2_l1_6 + (-1.1879010344273411e-05)*dt2_g0_3;
    dt2_l1_6 = dt2_l1_6 + (1.5745153802981804e-07)*dt2_g0_4;
    dt2_l1_6 = dt2_l1_6 + (-0.0010415823198854923)*dt2_g0_5;
    dt2_l1_6 = dt2_l1_6 + (-9.7839092632057145e-06)*dt2_g0_6;
    dt2_l1_6 = dt2_l1_6 + (-2.3084953681973275e-06)*dt2_g0_7;
    dt2_l1_6 = dt2_l1_6 + (7.4807148848776706e-06)*dt2_g0_8;
    dt2_l1_6 = dt2_l1_6 + (-3.9429028220183682e-06)*dt2_g0_9;
    dt2_l1_6 = dt2_l1_6 + (1.4638950233347714e-05)*dt2_g0_10;
    dt2_l1_6 = dt2_l1_6 + (1.5910354704828933e-06)*dt2_g0_11;
    dt2_l1_6 = dt2_l1_6 + (4.8954902922559995e-06)*dt2_g0_12;
    dt2_l1_6 = dt2_l1_6 + (1.329232873104047e-06)*dt2_g0_13;
    dt2_l1_6 = dt2_l1_6 + (0.06737133115530014)*dt2_g0_14;
    dt2_l1_6 = dt2_l1_6 + (4.4838479880127124e-06)*dt2_g0_15;
    dt2_l1_6 = dt2_l1_6 + (0.1200924813747406)*dt2_g0_16;
    dt2_l1_6 = dt2_l1_6 + (1.022621199808782e-05)*dt2_g0_17;
    dt2_l1_6 = dt2_l1_6 + (-6.015204121467832e-07)*dt2_g0_18;
    dt2_l1_6 = dt2_l1_6 + (-0.1717676967382431)*dt2_g0_19;
    dt2_l1_6 = dt2_l1_6 + (5.7488582569931168e-06)*dt2_g0_20;
    dt2_l1_6 = dt2_l1_6 + (-0.51570415496826172)*dt2_g0_21;
    dt2_l1_6 = dt2_l1_6 + (0.25729447603225708)*dt2_g0_22;
    dt2_l1_6 = dt2_l1_6 + (1.7876456695375964e-05)*dt2_g0_23;
    dt2_l1_6 = dt2_l1_6 + (7.6119772529636975e-06)*dt2_g0_24;
    dt2_l1_6 = dt2_l1_6 + (8.7904209067346528e-07)*dt2_g0_25;
    dt2_l1_6 = dt2_l1_6 + (-5.5410837376257405e-06)*dt2_g0_26;
    dt2_l1_6 = dt2_l1_6 + (4.990774868929293e-06)*dt2_g0_27;
    dt2_l1_6 = dt2_l1_6 + (-1.391522164340131e-05)*dt2_g0_28;
    dt2_l1_6 = dt2_l1_6 + (-2.9012385311943945e-06)*dt2_g0_29;
    dt2_l1_6 = dt2_l1_6 + (-6.6828770286520012e-06)*dt2_g0_30;
    dt2_l1_6 = dt2_l1_6 + (-0.1837390661239624)*dt2_g0_31;
    dt2_l1_7 = -0.0092202471569180489;
    dt2_l1_7 = dt2_l1_7 + (0.0074172001332044601)*dt2_g0_0;
    dt2_l1_7 = dt2_l1_7 + (-4.7951166379789356e-06)*dt2_g0_1;
    dt2_l1_7 = dt2_l1_7 + (-3.4282647902728058e-06)*dt2_g0_2;
    dt2_l1_7 = dt2_l1_7 + (-1.1316169548081234e-05)*dt2_g0_3;
    dt2_l1_7 = dt2_l1_7 + (-5.4483793974213768e-06)*dt2_g0_4;
    dt2_l1_7 = dt2_l1_7 + (0.0012444410240277648)*dt2_g0_5;
    dt2_l1_7 = dt2_l1_7 + (3.500225602692808e-06)*dt2_g0_6;
    dt2_l1_7 = dt2_l1_7 + (-7.4570561992004514e-06)*dt2_g0_7;
    dt2_l1_7 = dt2_l1_7 + (-6.299752840277506e-06)*dt2_g0_8;
    dt2_l1_7 = dt2_l1_7 + (7.0404362304543611e-06)*dt2_g0_9;
    dt2_l1_7 = dt2_l1_7 + (-3.6051565075467806e-06)*dt2_g0_10;
    dt2_l1_7 = dt2_l1_7 + (5.511910785571672e-06)*dt2_g0_11;
    dt2_l1_7 = dt2_l1_7 + (-3.8915704863029532e-06)*dt2_g0_12;
    dt2_l1_7 = dt2_l1_7 + (-5.022457116865553e-06)*dt2_g0_13;
    dt2_l1_7 = dt2_l1_7 + (0.011062324047088623)*dt2_g0_14;
    dt2_l1_7 = dt2_l1_7 + (-6.3502366174361669e-06)*dt2_g0_15;
    dt2_l1_7 = dt2_l1_7 + (0.0049811298958957195)*dt2_g0_16;
    dt2_l1_7 = dt2_l1_7 + (3.2094646940095117e-06)*dt2_g0_17;
    dt2_l1_7 = dt2_l1_7 + (-5.8456971601117402e-06)*dt2_g0_18;
    dt2_l1_7 = dt2_l1_7 + (-0.0062924656085669994)*dt2_g0_19;
    dt2_l1_7 = dt2_l1_7 + (-2.8775493774446659e-06)*dt2_g0_20;
    dt2_l1_7 = dt2_l1_7 + (-0.0077516557648777962)*dt2_g0_21;
    dt2_l1_7 = dt2_l1_7 + (0.022175146266818047)*dt2_g0_22;
    dt2_l1_7 = dt2_l1_7 + (2.4248424779216293e-06)*dt2_g0_23;
    dt2_l1_7 = dt2_l1_7 + (4.3025506784033496e-06)*dt2_g0_24;
    dt2_l1_7 = dt2_l1_7 + (-4.8940369197225664e-06)*dt2_g0_25;
    dt2_l1_7 = dt2_l1_7 + (3.7553681977442466e-06)*dt2_g0_26;
    dt2_l1_7 = dt2_l1_7 + (-5.4788124543847516e-06)*dt2_g0_27;
    dt2_l1_7 = dt2_l1_7 + (6.0630140978901181e-06)*dt2_g0_28;
    dt2_l1_7 = dt2_l1_7 + (5.0054572966473643e-06)*dt2_g0_29;
    dt2_l1_7 = dt2_l1_7 + (5.9157628129469231e-06)*dt2_g0_30;
    dt2_l1_7 = dt2_l1_7 + (-0.001369859091937542)*dt2_g0_31;
    dt2_l1_8 = 0.020557314157485962;
    dt2_l1_8 = dt2_l1_8 + (-0.02749934047460556)*dt2_g0_0;
    dt2_l1_8 = dt2_l1_8 + (4.5106888137524948e-05)*dt2_g0_1;
    dt2_l1_8 = dt2_l1_8 + (3.0896659154677764e-05)*dt2_g0_2;
    dt2_l1_8 = dt2_l1_8 + (3.470234150881879e-05)*dt2_g0_3;
    dt2_l1_8 = dt2_l1_8 + (3.6544974136631936e-05)*dt2_g0_4;
    dt2_l1_8 = dt2_l1_8 + (0.036568496376276016)*dt2_g0_5;
    dt2_l1_8 = dt2_l1_8 + (-2.9665154215763323e-05)*dt2_g0_6;
    dt2_l1_8 = dt2_l1_8 + (5.0898033805424348e-05)*dt2_g0_7;
    dt2_l1_8 = dt2_l1_8 + (4.1536517528584227e-05)*dt2_g0_8;
    dt2_l1_8 = dt2_l1_8 + (-3.6097739211982116e-05)*dt2_g0_9;
    dt2_l1_8 = dt2_l1_8 + (6.7573055275715888e-05)*dt2_g0_10;
    dt2_l1_8 = dt2_l1_8 + (-3.7935555155854672e-05)*dt2_g0_11;
    dt2_l1_8 = dt2_l1_8 + (4.3670381273841485e-05)*dt2_g0_12;
    dt2_l1_8 = dt2_l1_8 + (3.9244692743523046e-05)*dt2_g0_13;
    dt2_l1_8 = dt2_l1_8 + (-0.11672371625900269)*dt2_g0_14;
    dt2_l1_8 = dt2_l1_8 + (1.1185228686372284e-05)*dt2_g0_15;
    dt2_l1_8 = dt2_l1_8 + (0.17020195722579956)*dt2_g0_16;
    dt2_l1_8 = dt2_l1_8 + (1.007986611512024e-05)*dt2_g0_17;
    dt2_l1_8 = dt2_l1_8 + (3.2511354220332578e-05)*dt2_g0_18;
    dt2_l1_8 = dt2_l1_8 + (-0.16241995990276337)*dt2_g0_19;
    dt2_l1_8 = dt2_l1_8 + (2.8980930437683128e-05)*dt2_g0_20;
    dt2_l1_8 = dt2_l1_8 + (0.1997077465057373)*dt2_g0_21;
    dt2_l1_8 = dt2_l1_8 + (-0.093216530978679657)*dt2_g0_22;
    dt2_l1_8 = dt2_l1_8 + (4.9495127996124211e-07)*dt2_g0_23;
    dt2_l1_8 = dt2_l1_8 + (8.4393386714509688e-06)*dt2_g0_24;
    dt2_l1_8 = dt2_l1_8 + (3.7210011214483529e-05)*dt2_g0_25;
    dt2_l1_8 = dt2_l1_8 + (-3.6352652386995032e-05)*dt2_g0_26;
    dt2_l1_8 = dt2_l1_8 + (3.4836764825740829e-05)*dt2_g0_27;
    dt2_l1_8 = dt2_l1_8 + (-4.8265545046888292e-05)*dt2_g0_28;
    dt2_l1_8 = dt2_l1_8 + (-3.795682277996093e-05)*dt2_g0_29;
    dt2_l1_8 = dt2_l1_8 + (-4.3928794184466824e-05)*dt2_g0_30;
    dt2_l1_8 = dt2_l1_8 + (-0.12958551943302155)*dt2_g0_31;
    dt2_l1_9 = -0.0092202425003051758;
    dt2_l1_9 = dt2_l1_9 + (0.0074171698652207851)*dt2_g0_0;
    dt2_l1_9 = dt2_l1_9 + (-4.7950575208233204e-06)*dt2_g0_1;
    dt2_l1_9 = dt2_l1_9 + (-3.4282215892744716e-06)*dt2_g0_2;
    dt2_l1_9 = dt2_l1_9 + (-1.1316167729091831e-05)*dt2_g0_3;
    dt2_l1_9 = dt2_l1_9 + (-5.4483211897604633e-06)*dt2_g0_4;
    dt2_l1_9 = dt2_l1_9 + (0.0012443937594071031)*dt2_g0_5;
    dt2_l1_9 = dt2_l1_9 + (3.5001571632164996e-06)*dt2_g0_6;
    dt2_l1_9 = dt2_l1_9 + (-7.4570170909282751e-06)*dt2_g0_7;
    dt2_l1_9 = dt2_l1_9 + (-6.2996896303957328e-06)*dt2_g0_8;
    dt2_l1_9 = dt2_l1_9 + (7.0403862082457636e-06)*dt2_g0_9;
    dt2_l1_9 = dt2_l1_9 + (-3.6051455936103594e-06)*dt2_g0_10;
    dt2_l1_9 = dt2_l1_9 + (5.5118821364885662e-06)*dt2_g0_11;
    dt2_l1_9 = dt2_l1_9 + (-3.8915086406632327e-06)*dt2_g0_12;
    dt2_l1_9 = dt2_l1_9 + (-5.0223939069837797e-06)*dt2_g0_13;
    dt2_l1_9 = dt2_l1_9 + (0.011062433011829853)*dt2_g0_14;
    dt2_l1_9 = dt2_l1_9 + (-6.350199782900745e-06)*dt2_g0_15;
    dt2_l1_9 = dt2_l1_9 + (0.0049811415374279022)*dt2_g0_16;
    dt2_l1_9 = dt2_l1_9 + (3.2094371817947831e-06)*dt2_g0_17;
    dt2_l1_9 = dt2_l1_9 + (-5.8456557781028096e-06)*dt2_g0_18;
    dt2_l1_9 = dt2_l1_9 + (-0.0062924628145992756)*dt2_g0_19;
    dt2_l1_9 = dt2_l1_9 + (-2.8775123155355686e-06)*dt2_g0_20;
    dt2_l1_9 = dt2_l1_9 + (-0.0077515621669590473)*dt2_g0_21;
    dt2_l1_9 = dt2_l1_9 + (0.022175146266818047)*dt2_g0_22;
    dt2_l1_9 = dt2_l1_9 + (2.4248686258943053e-06)*dt2_g0_23;
    dt2_l1_9 = dt2_l1_9 + (4.3025188460887875e-06)*dt2_g0_24;
    dt2_l1_9 = dt2_l1_9 + (-4.8939868975139689e-06)*dt2_g0_25;
    dt2_l1_9 = dt2_l1_9 + (3.7553047604887979e-06)*dt2_g0_26;
    dt2_l1_9 = dt2_l1_9 + (-5.4787642511655577e-06)*dt2_g0_27;
    dt2_l1_9 = dt2_l1_9 + (6.0630191001109779e-06)*dt2_g0_28;
    dt2_l1_9 = dt2_l1_9 + (5.0054045459546614e-06)*dt2_g0_29;
    dt2_l1_9 = dt2_l1_9 + (5.9157059695280623e-06)*dt2_g0_30;
    dt2_l1_9 = dt2_l1_9 + (-0.0013698835391551256)*dt2_g0_31;
    dt2_l1_10 = -0.0092202359810471535;
    dt2_l1_10 = dt2_l1_10 + (0.0074171759188175201)*dt2_g0_0;
    dt2_l1_10 = dt2_l1_10 + (-4.7950411499186885e-06)*dt2_g0_1;
    dt2_l1_10 = dt2_l1_10 + (-3.4281986245332519e-06)*dt2_g0_2;
    dt2_l1_10 = dt2_l1_10 + (-1.1316120435367338e-05)*dt2_g0_3;
    dt2_l1_10 = dt2_l1_10 + (-5.4482907216879539e-06)*dt2_g0_4;
    dt2_l1_10 = dt2_l1_10 + (0.0012443602317944169)*dt2_g0_5;
    dt2_l1_10 = dt2_l1_10 + (3.5001487503905082e-06)*dt2_g0_6;
    dt2_l1_10 = dt2_l1_10 + (-7.4569761636666954e-06)*dt2_g0_7;
    dt2_l1_10 = dt2_l1_10 + (-6.2996518863656092e-06)*dt2_g0_8;
    dt2_l1_10 = dt2_l1_10 + (7.0403648351202719e-06)*dt2_g0_9;
    dt2_l1_10 = dt2_l1_10 + (-3.6051535516889999e-06)*dt2_g0_10;
    dt2_l1_10 = dt2_l1_10 + (5.5118475756898988e-06)*dt2_g0_11;
    dt2_l1_10 = dt2_l1_10 + (-3.8914909055165481e-06)*dt2_g0_12;
    dt2_l1_10 = dt2_l1_10 + (-5.0223793550685514e-06)*dt2_g0_13;
    dt2_l1_10 = dt2_l1_10 + (0.011062489822506905)*dt2_g0_14;
    dt2_l1_10 = dt2_l1_10 + (-6.3502006923954468e-06)*dt2_g0_15;
    dt2_l1_10 = dt2_l1_10 + (0.0049811867065727711)*dt2_g0_16;
    dt2_l1_10 = dt2_l1_10 + (3.209429451089818e-06)*dt2_g0_17;
    dt2_l1_10 = dt2_l1_10 + (-5.8456148508412298e-06)*dt2_g0_18;
    dt2_l1_10 = dt2_l1_10 + (-0.0062924814410507679)*dt2_g0_19;
    dt2_l1_10 = dt2_l1_10 + (-2.8774877591786208e-06)*dt2_g0_20;
    dt2_l1_10 = dt2_l1_10 + (-0.0077515454031527042)*dt2_g0_21;
    dt2_l1_10 = dt2_l1_10 + (0.0221751369535923)*dt2_g0_22;
    dt2_l1_10 = dt2_l1_10 + (2.4247860892501194e-06)*dt2_g0_23;
    dt2_l1_10 = dt2_l1_10 + (4.3025074774050154e-06)*dt2_g0_24;
    dt2_l1_10 = dt2_l1_10 + (-4.8939550651994068e-06)*dt2_g0_25;
    dt2_l1_10 = dt2_l1_10 + (3.7552933918050257e-06)*dt2_g0_26;
    dt2_l1_10 = dt2_l1_10 + (-5.478746970766224e-06)*dt2_g0_27;
    dt2_l1_10 = dt2_l1_10 + (6.0629840845649596e-06)*dt2_g0_28;
    dt2_l1_10 = dt2_l1_10 + (5.0053731683874503e-06)*dt2_g0_29;
    dt2_l1_10 = dt2_l1_10 + (5.9156841416552197e-06)*dt2_g0_30;
    dt2_l1_10 = dt2_l1_10 + (-0.0013698776019737124)*dt2_g0_31;
    dt2_l1_11 = -0.031666874885559082;
    dt2_l1_11 = dt2_l1_11 + (-0.0090516367927193642)*dt2_g0_0;
    dt2_l1_11 = dt2_l1_11 + (-3.6104283935856074e-06)*dt2_g0_1;
    dt2_l1_11 = dt2_l1_11 + (3.3615731354075251e-06)*dt2_g0_2;
    dt2_l1_11 = dt2_l1_11 + (-2.9356197046581656e-05)*dt2_g0_3;
    dt2_l1_11 = dt2_l1_11 + (-4.9025970838556532e-06)*dt2_g0_4;
    dt2_l1_11 = dt2_l1_11 + (0.032653413712978363)*dt2_g0_5;
    dt2_l1_11 = dt2_l1_11 + (-1.1354838534316514e-05)*dt2_g0_6;
    dt2_l1_11 = dt2_l1_11 + (-2.8711381219181931e-06)*dt2_g0_7;
    dt2_l1_11 = dt2_l1_11 + (1.7906284028867958e-06)*dt2_g0_8;
    dt2_l1_11 = dt2_l1_11 + (-2.0090806174266618e-06)*dt2_g0_9;
    dt2_l1_11 = dt2_l1_11 + (-3.0071541914367117e-05)*dt2_g0_10;
    dt2_l1_11 = dt2_l1_11 + (4.3423965507827234e-06)*dt2_g0_11;
    dt2_l1_11 = dt2_l1_11 + (-2.758038135652896e-06)*dt2_g0_12;
    dt2_l1_11 = dt2_l1_11 + (-7.9959409049479291e-06)*dt2_g0_13;
    dt2_l1_11 = dt2_l1_11 + (-0.20774281024932861)*dt2_g0_14;
    dt2_l1_11 = dt2_l1_11 + (2.0053932530572638e-05)*dt2_g0_15;
    dt2_l1_11 = dt2_l1_11 + (-0.52271997928619385)*dt2_g0_16;
    dt2_l1_11 = dt2_l1_11 + (1.244521513399377e-06)*dt2_g0_17;
    dt2_l1_11 = dt2_l1_11 + (6.2670633269590326e-06)*dt2_g0_18;
    dt2_l1_11 = dt2_l1_11 + (-0.14912067353725433)*dt2_g0_19;
    dt2_l1_11 = dt2_l1_11 + (1.7956307374333846e-06)*dt2_g0_20;
    dt2_l1_11 = dt2_l1_11 + (0.013506163842976093)*dt2_g0_21;
    dt2_l1_11 = dt2_l1_11 + (0.22161626815795898)*dt2_g0_22;
    dt2_l1_11 = dt2_l1_11 + (6.394238425855292e-06)*dt2_g0_23;
    dt2_l1_11 = dt2_l1_11 + (-9.9945018519065343e-06)*dt2_g0_24;
    dt2_l1_11 = dt2_l1_11 + (8.6194522737059742e-06)*dt2_g0_25;
    dt2_l1_11 = dt2_l1_11 + (1.6400816775785643e-06)*dt2_g0_26;
    dt2_l1_11 = dt2_l1_11 + (4.8755159696156625e-06)*dt2_g0_27;
    dt2_l1_11 = dt2_l1_11 + (1.2272440471861046e-05)*dt2_g0_28;
    dt2_l1_11 = dt2_l1_11 + (1.5524121408816427e-05)*dt2_g0_29;
    dt2_l1_11 = dt2_l1_11 + (-2.8816376129725541e-07)*dt2_g0_30;
    dt2_l1_11 = dt2_l1_11 + (0.033976655453443527)*dt2_g0_31;
    dt2_l1_12 = -0.0062166904099285603;
    dt2_l1_12 = dt2_l1_12 + (-0.20158196985721588)*dt2_g0_0;
    dt2_l1_12 = dt2_l1_12 + (-2.5460631150053814e-05)*dt2_g0_1;
    dt2_l1_12 = dt2_l1_12 + (-1.2765068277076352e-05)*dt2_g0_2;
    dt2_l1_12 = dt2_l1_12 + (-5.9611073083942756e-05)*dt2_g0_3;
    dt2_l1_12 = dt2_l1_12 + (-2.8436412321752869e-05)*dt2_g0_4;
    dt2_l1_12 = dt2_l1_12 + (-0.070834442973136902)*dt2_g0_5;
    dt2_l1_12 = dt2_l1_12 + (1.9341910956427455e-05)*dt2_g0_6;
    dt2_l1_12 = dt2_l1_12 + (-1.7865977497422136e-05)*dt2_g0_7;
    dt2_l1_12 = dt2_l1_12 + (-3.0507761039189063e-05)*dt2_g0_8;
    dt2_l1_12 = dt2_l1_12 + (3.4206932468805462e-05)*dt2_g0_9;
    dt2_l1_12 = dt2_l1_12 + (-4.9364174628863111e-05)*dt2_g0_10;
    dt2_l1_12 = dt2_l1_12 + (2.2953419829718769e-05)*dt2_g0_11;
    dt2_l1_12 = dt2_l1_12 + (-1.7751313862390816e-05)*dt2_g0_12;
    dt2_l1_12 = dt2_l1_12 + (-3.3157830330310389e-05)*dt2_g0_13;
    dt2_l1_12 = dt2_l1_12 + (0.23380187153816223)*dt2_g0_14;
    dt2_l1_12 = dt2_l1_12 + (8.4281946328701451e-06)*dt2_g0_15;
    dt2_l1_12 = dt2_l1_12 + (-0.033117271959781647)*dt2_g0_16;
    dt2_l1_12 = dt2_l1_12 + (1.6616057109786198e-05)*dt2_g0_17;
    dt2_l1_12 = dt2_l1_12 + (-1.5353301932918839e-05)*dt2_g0_18;
    dt2_l1_12 = dt2_l1_12 + (0.21899636089801788)*dt2_g0_19;
    dt2_l1_12 = dt2_l1_12 + (-1.448372768209083e-05)*dt2_g0_20;
    dt2_l1_12 = dt2_l1_12 + (-0.25044834613800049)*dt2_g0_21;
    dt2_l1_12 = dt2_l1_12 + (-0.082819655537605286)*dt2_g0_22;
    dt2_l1_12 = dt2_l1_12 + (-1.9269737094873562e-05)*dt2_g0_23;
    dt2_l1_12 = dt2_l1_12 + (3.4321240036661038e-06)*dt2_g0_24;
    dt2_l1_12 = dt2_l1_12 + (-3.6190251648804406e-06)*dt2_g0_25;
    dt2_l1_12 = dt2_l1_12 + (2.7439115001470782e-05)*dt2_g0_26;
    dt2_l1_12 = dt2_l1_12 + (-2.7384579880163074e-05)*dt2_g0_27;
    dt2_l1_12 = dt2_l1_12 + (3.4130844142055139e-05)*dt2_g0_28;
    dt2_l1_12 = dt2_l1_12 + (4.4185537262819707e-05)*dt2_g0_29;
    dt2_l1_12 = dt2_l1_12 + (3.1103158107725903e-05)*dt2_g0_30;
    dt2_l1_12 = dt2_l1_12 + (-0.043129730969667435)*dt2_g0_31;
    dt2_l1_13 = 0.025530295446515083;
    dt2_l1_13 = dt2_l1_13 + (0.15520049631595612)*dt2_g0_0;
    dt2_l1_13 = dt2_l1_13 + (-3.6660232581198215e-05)*dt2_g0_1;
    dt2_l1_13 = dt2_l1_13 + (-4.5534681703429669e-05)*dt2_g0_2;
    dt2_l1_13 = dt2_l1_13 + (-1.5075123656060896e-06)*dt2_g0_3;
    dt2_l1_13 = dt2_l1_13 + (-4.3669286242220551e-05)*dt2_g0_4;
    dt2_l1_13 = dt2_l1_13 + (-0.056243117898702621)*dt2_g0_5;
    dt2_l1_13 = dt2_l1_13 + (3.8529615267179906e-05)*dt2_g0_6;
    dt2_l1_13 = dt2_l1_13 + (-3.3103522582678124e-05)*dt2_g0_7;
    dt2_l1_13 = dt2_l1_13 + (-6.0722995840478688e-05)*dt2_g0_8;
    dt2_l1_13 = dt2_l1_13 + (1.8956392523250543e-05)*dt2_g0_9;
    dt2_l1_13 = dt2_l1_13 + (-4.2252195271430537e-05)*dt2_g0_10;
    dt2_l1_13 = dt2_l1_13 + (1.7601305444259197e-05)*dt2_g0_11;
    dt2_l1_13 = dt2_l1_13 + (-4.4738491851603612e-05)*dt2_g0_12;
    dt2_l1_13 = dt2_l1_13 + (-3.2803858630359173e-05)*dt2_g0_13;
    dt2_l1_13 = dt2_l1_13 + (-0.036114614456892014)*dt2_g0_14;
    dt2_l1_13 = dt2_l1_13 + (-2.1566211216850206e-05)*dt2_g0_15;
    dt2_l1_13 = dt2_l1_13 + (-0.046159509569406509)*dt2_g0_16;
    dt2_l1_13 = dt2_l1_13 + (1.0234629371552728e-05)*dt2_g0_17;
    dt2_l1_13 = dt2_l1_13 + (-4.3925567297264934e-05)*dt2_g0_18;
    dt2_l1_13 = dt2_l1_13 + (0.19555991888046265)*dt2_g0_19;
    dt2_l1_13 = dt2_l1_13 + (-5.9092217270517722e-05)*dt2_g0_20;
    dt2_l1_13 = dt2_l1_13 + (0.16028957068920135)*dt2_g0_21;
    dt2_l1_13 = dt2_l1_13 + (0.049317475408315659)*dt2_g0_22;
    dt2_l1_13 = dt2_l1_13 + (-4.824435745831579e-05)*dt2_g0_23;
    dt2_l1_13 = dt2_l1_13 + (1.0115571058122441e-05)*dt2_g0_24;
    dt2_l1_13 = dt2_l1_13 + (-5.9595429775072262e-05)*dt2_g0_25;
    dt2_l1_13 = dt2_l1_13 + (2.9068874937365763e-05)*dt2_g0_26;
    dt2_l1_13 = dt2_l1_13 + (-1.774632437445689e-05)*dt2_g0_27;
    dt2_l1_13 = dt2_l1_13 + (9.8679178336169571e-05)*dt2_g0_28;
    dt2_l1_13 = dt2_l1_13 + (4.5977485569892451e-05)*dt2_g0_29;
    dt2_l1_13 = dt2_l1_13 + (3.5101438697893173e-05)*dt2_g0_30;
    dt2_l1_13 = dt2_l1_13 + (0.06762385368347168)*dt2_g0_31;
    dt2_l1_14 = -0.0092202425003051758;
    dt2_l1_14 = dt2_l1_14 + (0.007417190819978714)*dt2_g0_0;
    dt2_l1_14 = dt2_l1_14 + (-4.7950729822332505e-06)*dt2_g0_1;
    dt2_l1_14 = dt2_l1_14 + (-3.4282297747267876e-06)*dt2_g0_2;
    dt2_l1_14 = dt2_l1_14 + (-1.1316120435367338e-05)*dt2_g0_3;
    dt2_l1_14 = dt2_l1_14 + (-5.4483316489495337e-06)*dt2_g0_4;
    dt2_l1_14 = dt2_l1_14 + (0.001244421349838376)*dt2_g0_5;
    dt2_l1_14 = dt2_l1_14 + (3.5001903597731143e-06)*dt2_g0_6;
    dt2_l1_14 = dt2_l1_14 + (-7.4570052674971521e-06)*dt2_g0_7;
    dt2_l1_14 = dt2_l1_14 + (-6.299705091805663e-06)*dt2_g0_8;
    dt2_l1_14 = dt2_l1_14 + (7.0403930294560269e-06)*dt2_g0_9;
    dt2_l1_14 = dt2_l1_14 + (-3.6051565075467806e-06)*dt2_g0_10;
    dt2_l1_14 = dt2_l1_14 + (5.5118730415415484e-06)*dt2_g0_11;
    dt2_l1_14 = dt2_l1_14 + (-3.8915281947993208e-06)*dt2_g0_12;
    dt2_l1_14 = dt2_l1_14 + (-5.0224139158672187e-06)*dt2_g0_13;
    dt2_l1_14 = dt2_l1_14 + (0.01106240414083004)*dt2_g0_14;
    dt2_l1_14 = dt2_l1_14 + (-6.3502138800686225e-06)*dt2_g0_15;
    dt2_l1_14 = dt2_l1_14 + (0.0049811620265245438)*dt2_g0_16;
    dt2_l1_14 = dt2_l1_14 + (3.2094451398734236e-06)*dt2_g0_17;
    dt2_l1_14 = dt2_l1_14 + (-5.8456530496187042e-06)*dt2_g0_18;
    dt2_l1_14 = dt2_l1_14 + (-0.0062924702651798725)*dt2_g0_19;
    dt2_l1_14 = dt2_l1_14 + (-2.8775179998774547e-06)*dt2_g0_20;
    dt2_l1_14 = dt2_l1_14 + (-0.0077515854500234127)*dt2_g0_21;
    dt2_l1_14 = dt2_l1_14 + (0.022175131365656853)*dt2_g0_22;
    dt2_l1_14 = dt2_l1_14 + (2.4247879082395229e-06)*dt2_g0_23;
    dt2_l1_14 = dt2_l1_14 + (4.3025261220464017e-06)*dt2_g0_24;
    dt2_l1_14 = dt2_l1_14 + (-4.8939937187242322e-06)*dt2_g0_25;
    dt2_l1_14 = dt2_l1_14 + (3.755326360987965e-06)*dt2_g0_26;
    dt2_l1_14 = dt2_l1_14 + (-5.4787733461125754e-06)*dt2_g0_27;
    dt2_l1_14 = dt2_l1_14 + (6.0629909057752229e-06)*dt2_g0_28;
    dt2_l1_14 = dt2_l1_14 + (5.0054122766596265e-06)*dt2_g0_29;
    dt2_l1_14 = dt2_l1_14 + (5.9157187024538871e-06)*dt2_g0_30;
    dt2_l1_14 = dt2_l1_14 + (-0.0013698783004656434)*dt2_g0_31;
    dt2_l1_15 = -0.0092202462255954742;
    dt2_l1_15 = dt2_l1_15 + (0.0074171922169625759)*dt2_g0_0;
    dt2_l1_15 = dt2_l1_15 + (-4.795107088284567e-06)*dt2_g0_1;
    dt2_l1_15 = dt2_l1_15 + (-3.4282566048204899e-06)*dt2_g0_2;
    dt2_l1_15 = dt2_l1_15 + (-1.1316198651911691e-05)*dt2_g0_3;
    dt2_l1_15 = dt2_l1_15 + (-5.4483693929796573e-06)*dt2_g0_4;
    dt2_l1_15 = dt2_l1_15 + (0.0012444109888747334)*dt2_g0_5;
    dt2_l1_15 = dt2_l1_15 + (3.500215825624764e-06)*dt2_g0_6;
    dt2_l1_15 = dt2_l1_15 + (-7.4570530159689952e-06)*dt2_g0_7;
    dt2_l1_15 = dt2_l1_15 + (-6.2997446548251901e-06)*dt2_g0_8;
    dt2_l1_15 = dt2_l1_15 + (7.0404357757070102e-06)*dt2_g0_9;
    dt2_l1_15 = dt2_l1_15 + (-3.6051590086572105e-06)*dt2_g0_10;
    dt2_l1_15 = dt2_l1_15 + (5.5119098760769702e-06)*dt2_g0_11;
    dt2_l1_15 = dt2_l1_15 + (-3.8915586628718302e-06)*dt2_g0_12;
    dt2_l1_15 = dt2_l1_15 + (-5.0224475671711843e-06)*dt2_g0_13;
    dt2_l1_15 = dt2_l1_15 + (0.011062385514378548)*dt2_g0_14;
    dt2_l1_15 = dt2_l1_15 + (-6.3502375269308686e-06)*dt2_g0_15;
    dt2_l1_15 = dt2_l1_15 + (0.0049811168573796749)*dt2_g0_16;
    dt2_l1_15 = dt2_l1_15 + (3.2094642392621608e-06)*dt2_g0_17;
    dt2_l1_15 = dt2_l1_15 + (-5.845693976880284e-06)*dt2_g0_18;
    dt2_l1_15 = dt2_l1_15 + (-0.0062924632802605629)*dt2_g0_19;
    dt2_l1_15 = dt2_l1_15 + (-2.8775432383554289e-06)*dt2_g0_20;
    dt2_l1_15 = dt2_l1_15 + (-0.0077516329474747181)*dt2_g0_21;
    dt2_l1_15 = dt2_l1_15 + (0.022175148129463196)*dt2_g0_22;
    dt2_l1_15 = dt2_l1_15 + (2.4248483896371908e-06)*dt2_g0_23;
    dt2_l1_15 = dt2_l1_15 + (4.3025515878980514e-06)*dt2_g0_24;
    dt2_l1_15 = dt2_l1_15 + (-4.8940296437649522e-06)*dt2_g0_25;
    dt2_l1_15 = dt2_l1_15 + (3.755356601686799e-06)*dt2_g0_26;
    dt2_l1_15 = dt2_l1_15 + (-5.4788088164059445e-06)*dt2_g0_27;
    dt2_l1_15 = dt2_l1_15 + (6.0630241023318376e-06)*dt2_g0_28;
    dt2_l1_15 = dt2_l1_15 + (5.0054468374582939e-06)*dt2_g0_29;
    dt2_l1_15 = dt2_l1_15 + (5.9157559917366598e-06)*dt2_g0_30;
    dt2_l1_15 = dt2_l1_15 + (-0.0013698734110221267)*dt2_g0_31;

    // Device token pooling
    hp_0 = (dt0_l1_0 + dt1_l1_0 + dt2_l1_0) / 3.0;
    hp_1 = (dt0_l1_1 + dt1_l1_1 + dt2_l1_1) / 3.0;
    hp_2 = (dt0_l1_2 + dt1_l1_2 + dt2_l1_2) / 3.0;
    hp_3 = (dt0_l1_3 + dt1_l1_3 + dt2_l1_3) / 3.0;
    hp_4 = (dt0_l1_4 + dt1_l1_4 + dt2_l1_4) / 3.0;
    hp_5 = (dt0_l1_5 + dt1_l1_5 + dt2_l1_5) / 3.0;
    hp_6 = (dt0_l1_6 + dt1_l1_6 + dt2_l1_6) / 3.0;
    hp_7 = (dt0_l1_7 + dt1_l1_7 + dt2_l1_7) / 3.0;
    hp_8 = (dt0_l1_8 + dt1_l1_8 + dt2_l1_8) / 3.0;
    hp_9 = (dt0_l1_9 + dt1_l1_9 + dt2_l1_9) / 3.0;
    hp_10 = (dt0_l1_10 + dt1_l1_10 + dt2_l1_10) / 3.0;
    hp_11 = (dt0_l1_11 + dt1_l1_11 + dt2_l1_11) / 3.0;
    hp_12 = (dt0_l1_12 + dt1_l1_12 + dt2_l1_12) / 3.0;
    hp_13 = (dt0_l1_13 + dt1_l1_13 + dt2_l1_13) / 3.0;
    hp_14 = (dt0_l1_14 + dt1_l1_14 + dt2_l1_14) / 3.0;
    hp_15 = (dt0_l1_15 + dt1_l1_15 + dt2_l1_15) / 3.0;
    hp_mean = (hp_0 + hp_1 + hp_2 + hp_3 + hp_4 + hp_5 + hp_6 + hp_7 + hp_8 + hp_9 + hp_10 + hp_11 + hp_12 + hp_13 + hp_14 + hp_15) / 16;
    hp_var = (((hp_0) - hp_mean)*((hp_0) - hp_mean) + ((hp_1) - hp_mean)*((hp_1) - hp_mean) + ((hp_2) - hp_mean)*((hp_2) - hp_mean) + ((hp_3) - hp_mean)*((hp_3) - hp_mean) + ((hp_4) - hp_mean)*((hp_4) - hp_mean) + ((hp_5) - hp_mean)*((hp_5) - hp_mean) + ((hp_6) - hp_mean)*((hp_6) - hp_mean) + ((hp_7) - hp_mean)*((hp_7) - hp_mean) + ((hp_8) - hp_mean)*((hp_8) - hp_mean) + ((hp_9) - hp_mean)*((hp_9) - hp_mean) + ((hp_10) - hp_mean)*((hp_10) - hp_mean) + ((hp_11) - hp_mean)*((hp_11) - hp_mean) + ((hp_12) - hp_mean)*((hp_12) - hp_mean) + ((hp_13) - hp_mean)*((hp_13) - hp_mean) + ((hp_14) - hp_mean)*((hp_14) - hp_mean) + ((hp_15) - hp_mean)*((hp_15) - hp_mean)) / 16;
    hpn_0 = ((hp_0) - hp_mean) / sqrt(hp_var + ln_eps);
    hpn_1 = ((hp_1) - hp_mean) / sqrt(hp_var + ln_eps);
    hpn_2 = ((hp_2) - hp_mean) / sqrt(hp_var + ln_eps);
    hpn_3 = ((hp_3) - hp_mean) / sqrt(hp_var + ln_eps);
    hpn_4 = ((hp_4) - hp_mean) / sqrt(hp_var + ln_eps);
    hpn_5 = ((hp_5) - hp_mean) / sqrt(hp_var + ln_eps);
    hpn_6 = ((hp_6) - hp_mean) / sqrt(hp_var + ln_eps);
    hpn_7 = ((hp_7) - hp_mean) / sqrt(hp_var + ln_eps);
    hpn_8 = ((hp_8) - hp_mean) / sqrt(hp_var + ln_eps);
    hpn_9 = ((hp_9) - hp_mean) / sqrt(hp_var + ln_eps);
    hpn_10 = ((hp_10) - hp_mean) / sqrt(hp_var + ln_eps);
    hpn_11 = ((hp_11) - hp_mean) / sqrt(hp_var + ln_eps);
    hpn_12 = ((hp_12) - hp_mean) / sqrt(hp_var + ln_eps);
    hpn_13 = ((hp_13) - hp_mean) / sqrt(hp_var + ln_eps);
    hpn_14 = ((hp_14) - hp_mean) / sqrt(hp_var + ln_eps);
    hpn_15 = ((hp_15) - hp_mean) / sqrt(hp_var + ln_eps);

    // Bias tower
    bt_l0_0 = 0.030651586130261421;
    bt_l0_0 = bt_l0_0 + (0.003914764616638422)*vgs_shift;
    bt_l0_0 = bt_l0_0 + (0.017389727756381035)*vds_pos;
    bt_l0_1 = 0.030651664361357689;
    bt_l0_1 = bt_l0_1 + (0.0039147604256868362)*vgs_shift;
    bt_l0_1 = bt_l0_1 + (0.017389824613928795)*vds_pos;
    bt_l0_2 = 0.15463119745254517;
    bt_l0_2 = bt_l0_2 + (-0.41564756631851196)*vgs_shift;
    bt_l0_2 = bt_l0_2 + (-0.15132145583629608)*vds_pos;
    bt_l0_3 = 0.03065161406993866;
    bt_l0_3 = bt_l0_3 + (0.0039147203788161278)*vgs_shift;
    bt_l0_3 = bt_l0_3 + (0.017389712855219841)*vds_pos;
    bt_l0_4 = 0.030651655048131943;
    bt_l0_4 = bt_l0_4 + (0.0039147939532995224)*vgs_shift;
    bt_l0_4 = bt_l0_4 + (0.017389753833413124)*vds_pos;
    bt_l0_5 = 0.030651656910777092;
    bt_l0_5 = bt_l0_5 + (0.0039147953502833843)*vgs_shift;
    bt_l0_5 = bt_l0_5 + (0.017389772459864616)*vds_pos;
    bt_l0_6 = 0.030651643872261047;
    bt_l0_6 = bt_l0_6 + (0.0039147878997027874)*vgs_shift;
    bt_l0_6 = bt_l0_6 + (0.017389660701155663)*vds_pos;
    bt_l0_7 = 0.03065168671309948;
    bt_l0_7 = bt_l0_7 + (0.0039146523922681808)*vgs_shift;
    bt_l0_7 = bt_l0_7 + (0.017389768734574318)*vds_pos;
    bt_l0_8 = 0.041013486683368683;
    bt_l0_8 = bt_l0_8 + (-0.00041139556560665369)*vgs_shift;
    bt_l0_8 = bt_l0_8 + (-0.39931574463844299)*vds_pos;
    bt_l0_9 = 0.030651653185486794;
    bt_l0_9 = bt_l0_9 + (0.0039147557690739632)*vgs_shift;
    bt_l0_9 = bt_l0_9 + (0.017389712855219841)*vds_pos;
    bt_l0_10 = 0.069313332438468933;
    bt_l0_10 = bt_l0_10 + (-0.012548787519335747)*vgs_shift;
    bt_l0_10 = bt_l0_10 + (-0.019634610041975975)*vds_pos;
    bt_l0_11 = 0.030651617795228958;
    bt_l0_11 = bt_l0_11 + (0.0039147105999290943)*vgs_shift;
    bt_l0_11 = bt_l0_11 + (0.017389655113220215)*vds_pos;
    bt_l0_12 = 0.03065163642168045;
    bt_l0_12 = bt_l0_12 + (0.003914770670235157)*vgs_shift;
    bt_l0_12 = bt_l0_12 + (0.017389785498380661)*vds_pos;
    bt_l0_13 = 0.15103925764560699;
    bt_l0_13 = bt_l0_13 + (0.044329982250928879)*vgs_shift;
    bt_l0_13 = bt_l0_13 + (-0.27264660596847534)*vds_pos;
    bt_l0_14 = 0.030651628971099854;
    bt_l0_14 = bt_l0_14 + (0.0039147823117673397)*vgs_shift;
    bt_l0_14 = bt_l0_14 + (0.017389848828315735)*vds_pos;
    bt_l0_15 = 0.030651664361357689;
    bt_l0_15 = bt_l0_15 + (0.0039147795177996159)*vgs_shift;
    bt_l0_15 = bt_l0_15 + (0.017389779910445213)*vds_pos;
    bt_l0_16 = 0.13345363736152649;
    bt_l0_16 = bt_l0_16 + (-0.20988427102565765)*vgs_shift;
    bt_l0_16 = bt_l0_16 + (0.23492158949375153)*vds_pos;
    bt_l0_17 = -0.091561935842037201;
    bt_l0_17 = bt_l0_17 + (0.45630854368209839)*vgs_shift;
    bt_l0_17 = bt_l0_17 + (0.16855688393115997)*vds_pos;
    bt_l0_18 = 0.030651634559035301;
    bt_l0_18 = bt_l0_18 + (0.0039147874340415001)*vgs_shift;
    bt_l0_18 = bt_l0_18 + (0.017389807850122452)*vds_pos;
    bt_l0_19 = 0.030651653185486794;
    bt_l0_19 = bt_l0_19 + (0.0039147823117673397)*vgs_shift;
    bt_l0_19 = bt_l0_19 + (0.017389742657542229)*vds_pos;
    bt_l0_20 = 0.030651731416583061;
    bt_l0_20 = bt_l0_20 + (0.0039146225899457932)*vgs_shift;
    bt_l0_20 = bt_l0_20 + (0.017389744520187378)*vds_pos;
    bt_l0_21 = 0.030651619657874107;
    bt_l0_21 = bt_l0_21 + (0.0039147385396063328)*vgs_shift;
    bt_l0_21 = bt_l0_21 + (0.017389804124832153)*vds_pos;
    bt_l0_22 = 0.068312428891658783;
    bt_l0_22 = bt_l0_22 + (-0.22618147730827332)*vgs_shift;
    bt_l0_22 = bt_l0_22 + (-0.27362009882926941)*vds_pos;
    bt_l0_23 = 0.030651761218905449;
    bt_l0_23 = bt_l0_23 + (0.0039146733470261097)*vgs_shift;
    bt_l0_23 = bt_l0_23 + (0.017389697954058647)*vds_pos;
    bt_l0_24 = 0.030651574954390526;
    bt_l0_24 = bt_l0_24 + (0.0039147967472672462)*vgs_shift;
    bt_l0_24 = bt_l0_24 + (0.017389751970767975)*vds_pos;
    bt_l0_25 = 0.030651720240712166;
    bt_l0_25 = bt_l0_25 + (0.0039148358628153801)*vgs_shift;
    bt_l0_25 = bt_l0_25 + (0.017389615997672081)*vds_pos;
    bt_l0_26 = 0.030651703476905823;
    bt_l0_26 = bt_l0_26 + (0.0039147473871707916)*vgs_shift;
    bt_l0_26 = bt_l0_26 + (0.017389865592122078)*vds_pos;
    bt_l0_27 = -0.022531446069478989;
    bt_l0_27 = bt_l0_27 + (0.28000009059906006)*vgs_shift;
    bt_l0_27 = bt_l0_27 + (-0.39433661103248596)*vds_pos;
    bt_l0_28 = 0.030651632696390152;
    bt_l0_28 = bt_l0_28 + (0.0039148018695414066)*vgs_shift;
    bt_l0_28 = bt_l0_28 + (0.017389645799994469)*vds_pos;
    bt_l0_29 = 0.030651839450001717;
    bt_l0_29 = bt_l0_29 + (0.0039147175848484039)*vgs_shift;
    bt_l0_29 = bt_l0_29 + (0.01738973893225193)*vds_pos;
    bt_l0_30 = 0.030651677399873734;
    bt_l0_30 = bt_l0_30 + (0.003914728295058012)*vgs_shift;
    bt_l0_30 = bt_l0_30 + (0.017389649525284767)*vds_pos;
    bt_l0_31 = 0.030651681125164032;
    bt_l0_31 = bt_l0_31 + (0.0039147371426224709)*vgs_shift;
    bt_l0_31 = bt_l0_31 + (0.017389805987477303)*vds_pos;
    bt_l0_32 = 0.030651647597551346;
    bt_l0_32 = bt_l0_32 + (0.003914740402251482)*vgs_shift;
    bt_l0_32 = bt_l0_32 + (0.017389701679348946)*vds_pos;
    bt_l0_33 = 0.030651681125164032;
    bt_l0_33 = bt_l0_33 + (0.0039147594943642616)*vgs_shift;
    bt_l0_33 = bt_l0_33 + (0.017389815300703049)*vds_pos;
    bt_l0_34 = 0.03065170906484127;
    bt_l0_34 = bt_l0_34 + (0.0039146486669778824)*vgs_shift;
    bt_l0_34 = bt_l0_34 + (0.017389731481671333)*vds_pos;
    bt_l0_35 = 0.030651677399873734;
    bt_l0_35 = bt_l0_35 + (0.0039147045463323593)*vgs_shift;
    bt_l0_35 = bt_l0_35 + (0.017389848828315735)*vds_pos;
    bt_l0_36 = 0.030651669949293137;
    bt_l0_36 = bt_l0_36 + (0.0039147851057350636)*vgs_shift;
    bt_l0_36 = bt_l0_36 + (0.017389614135026932)*vds_pos;
    bt_l0_37 = 0.030651666224002838;
    bt_l0_37 = bt_l0_37 + (0.0039147376082837582)*vgs_shift;
    bt_l0_37 = bt_l0_37 + (0.017389794811606407)*vds_pos;
    bt_l0_38 = 0.030651617795228958;
    bt_l0_38 = bt_l0_38 + (0.0039147930219769478)*vgs_shift;
    bt_l0_38 = bt_l0_38 + (0.01738973893225193)*vds_pos;
    bt_l0_39 = 0.030651627108454704;
    bt_l0_39 = bt_l0_39 + (0.0039149369113147259)*vgs_shift;
    bt_l0_39 = bt_l0_39 + (0.017389861866831779)*vds_pos;
    bt_l0_40 = 0.030651664361357689;
    bt_l0_40 = bt_l0_40 + (0.0039147450588643551)*vgs_shift;
    bt_l0_40 = bt_l0_40 + (0.017389660701155663)*vds_pos;
    bt_l0_41 = 0.030651681125164032;
    bt_l0_41 = bt_l0_41 + (0.0039146877825260162)*vgs_shift;
    bt_l0_41 = bt_l0_41 + (0.017389757558703423)*vds_pos;
    bt_l0_42 = 0.030651593580842018;
    bt_l0_42 = bt_l0_42 + (0.0039147613570094109)*vgs_shift;
    bt_l0_42 = bt_l0_42 + (0.017389759421348572)*vds_pos;
    bt_l0_43 = 0.03065175749361515;
    bt_l0_43 = bt_l0_43 + (0.0039146612398326397)*vgs_shift;
    bt_l0_43 = bt_l0_43 + (0.017389770597219467)*vds_pos;
    bt_l0_44 = 0.030651677399873734;
    bt_l0_44 = bt_l0_44 + (0.0039147329516708851)*vgs_shift;
    bt_l0_44 = bt_l0_44 + (0.017389746382832527)*vds_pos;
    bt_l0_45 = 0.030651893466711044;
    bt_l0_45 = bt_l0_45 + (0.0039145727641880512)*vgs_shift;
    bt_l0_45 = bt_l0_45 + (0.01738978736102581)*vds_pos;
    bt_l0_46 = 0.030651666224002838;
    bt_l0_46 = bt_l0_46 + (0.0039148088544607162)*vgs_shift;
    bt_l0_46 = bt_l0_46 + (0.017389882355928421)*vds_pos;
    bt_l0_47 = 0.030651820823550224;
    bt_l0_47 = bt_l0_47 + (0.0039145960472524166)*vgs_shift;
    bt_l0_47 = bt_l0_47 + (0.017389709129929543)*vds_pos;
    bt_l0_48 = 0.030651642009615898;
    bt_l0_48 = bt_l0_48 + (0.0039148358628153801)*vgs_shift;
    bt_l0_48 = bt_l0_48 + (0.01738973893225193)*vds_pos;
    bt_l0_49 = 0.030651696026325226;
    bt_l0_49 = bt_l0_49 + (0.0039147837087512016)*vgs_shift;
    bt_l0_49 = bt_l0_49 + (0.017389817163348198)*vds_pos;
    bt_l0_50 = 0.030651664361357689;
    bt_l0_50 = bt_l0_50 + (0.0039147553034126759)*vgs_shift;
    bt_l0_50 = bt_l0_50 + (0.017389720305800438)*vds_pos;
    bt_l0_51 = 0.030651617795228958;
    bt_l0_51 = bt_l0_51 + (0.0039148088544607162)*vgs_shift;
    bt_l0_51 = bt_l0_51 + (0.01738981157541275)*vds_pos;
    bt_l0_52 = 0.030651690438389778;
    bt_l0_52 = bt_l0_52 + (0.0039148377254605293)*vgs_shift;
    bt_l0_52 = bt_l0_52 + (0.017389845103025436)*vds_pos;
    bt_l0_53 = 0.030651643872261047;
    bt_l0_53 = bt_l0_53 + (0.0039147562347352505)*vgs_shift;
    bt_l0_53 = bt_l0_53 + (0.01738995686173439)*vds_pos;
    bt_l0_54 = 0.030651699751615524;
    bt_l0_54 = bt_l0_54 + (0.0039147711358964443)*vgs_shift;
    bt_l0_54 = bt_l0_54 + (0.017389833927154541)*vds_pos;
    bt_l0_55 = 0.030651645734906197;
    bt_l0_55 = bt_l0_55 + (0.0039145904593169689)*vgs_shift;
    bt_l0_55 = bt_l0_55 + (0.017389724031090736)*vds_pos;
    bt_l0_56 = 0.03065158799290657;
    bt_l0_56 = bt_l0_56 + (0.0039147562347352505)*vgs_shift;
    bt_l0_56 = bt_l0_56 + (0.017389848828315735)*vds_pos;
    bt_l0_57 = 0.030651621520519257;
    bt_l0_57 = bt_l0_57 + (0.0039148260839283466)*vgs_shift;
    bt_l0_57 = bt_l0_57 + (0.017389673739671707)*vds_pos;
    bt_l0_58 = -0.056662667542695999;
    bt_l0_58 = bt_l0_58 + (-0.11044526845216751)*vgs_shift;
    bt_l0_58 = bt_l0_58 + (0.28749924898147583)*vds_pos;
    bt_l0_59 = 0.030651766806840897;
    bt_l0_59 = bt_l0_59 + (0.0039147334173321724)*vgs_shift;
    bt_l0_59 = bt_l0_59 + (0.017389591783285141)*vds_pos;
    bt_l0_60 = 0.030651630833745003;
    bt_l0_60 = bt_l0_60 + (0.0039147501811385155)*vgs_shift;
    bt_l0_60 = bt_l0_60 + (0.017389655113220215)*vds_pos;
    bt_l0_61 = 0.03065163642168045;
    bt_l0_61 = bt_l0_61 + (0.0039147469215095043)*vgs_shift;
    bt_l0_61 = bt_l0_61 + (0.017389571294188499)*vds_pos;
    bt_l0_62 = 0.03065170906484127;
    bt_l0_62 = bt_l0_62 + (0.003914722241461277)*vgs_shift;
    bt_l0_62 = bt_l0_62 + (0.017389910295605659)*vds_pos;
    bt_l0_63 = -0.15312927961349487;
    bt_l0_63 = bt_l0_63 + (0.38682469725608826)*vgs_shift;
    bt_l0_63 = bt_l0_63 + (0.031900808215141296)*vds_pos;
    bt0_mean = (bt_l0_0 + bt_l0_1 + bt_l0_2 + bt_l0_3 + bt_l0_4 + bt_l0_5 + bt_l0_6 + bt_l0_7 + bt_l0_8 + bt_l0_9 + bt_l0_10 + bt_l0_11 + bt_l0_12 + bt_l0_13 + bt_l0_14 + bt_l0_15 + bt_l0_16 + bt_l0_17 + bt_l0_18 + bt_l0_19 + bt_l0_20 + bt_l0_21 + bt_l0_22 + bt_l0_23 + bt_l0_24 + bt_l0_25 + bt_l0_26 + bt_l0_27 + bt_l0_28 + bt_l0_29 + bt_l0_30 + bt_l0_31 + bt_l0_32 + bt_l0_33 + bt_l0_34 + bt_l0_35 + bt_l0_36 + bt_l0_37 + bt_l0_38 + bt_l0_39 + bt_l0_40 + bt_l0_41 + bt_l0_42 + bt_l0_43 + bt_l0_44 + bt_l0_45 + bt_l0_46 + bt_l0_47 + bt_l0_48 + bt_l0_49 + bt_l0_50 + bt_l0_51 + bt_l0_52 + bt_l0_53 + bt_l0_54 + bt_l0_55 + bt_l0_56 + bt_l0_57 + bt_l0_58 + bt_l0_59 + bt_l0_60 + bt_l0_61 + bt_l0_62 + bt_l0_63) / 64;
    bt0_var = (((bt_l0_0) - bt0_mean)*((bt_l0_0) - bt0_mean) + ((bt_l0_1) - bt0_mean)*((bt_l0_1) - bt0_mean) + ((bt_l0_2) - bt0_mean)*((bt_l0_2) - bt0_mean) + ((bt_l0_3) - bt0_mean)*((bt_l0_3) - bt0_mean) + ((bt_l0_4) - bt0_mean)*((bt_l0_4) - bt0_mean) + ((bt_l0_5) - bt0_mean)*((bt_l0_5) - bt0_mean) + ((bt_l0_6) - bt0_mean)*((bt_l0_6) - bt0_mean) + ((bt_l0_7) - bt0_mean)*((bt_l0_7) - bt0_mean) + ((bt_l0_8) - bt0_mean)*((bt_l0_8) - bt0_mean) + ((bt_l0_9) - bt0_mean)*((bt_l0_9) - bt0_mean) + ((bt_l0_10) - bt0_mean)*((bt_l0_10) - bt0_mean) + ((bt_l0_11) - bt0_mean)*((bt_l0_11) - bt0_mean) + ((bt_l0_12) - bt0_mean)*((bt_l0_12) - bt0_mean) + ((bt_l0_13) - bt0_mean)*((bt_l0_13) - bt0_mean) + ((bt_l0_14) - bt0_mean)*((bt_l0_14) - bt0_mean) + ((bt_l0_15) - bt0_mean)*((bt_l0_15) - bt0_mean) + ((bt_l0_16) - bt0_mean)*((bt_l0_16) - bt0_mean) + ((bt_l0_17) - bt0_mean)*((bt_l0_17) - bt0_mean) + ((bt_l0_18) - bt0_mean)*((bt_l0_18) - bt0_mean) + ((bt_l0_19) - bt0_mean)*((bt_l0_19) - bt0_mean) + ((bt_l0_20) - bt0_mean)*((bt_l0_20) - bt0_mean) + ((bt_l0_21) - bt0_mean)*((bt_l0_21) - bt0_mean) + ((bt_l0_22) - bt0_mean)*((bt_l0_22) - bt0_mean) + ((bt_l0_23) - bt0_mean)*((bt_l0_23) - bt0_mean) + ((bt_l0_24) - bt0_mean)*((bt_l0_24) - bt0_mean) + ((bt_l0_25) - bt0_mean)*((bt_l0_25) - bt0_mean) + ((bt_l0_26) - bt0_mean)*((bt_l0_26) - bt0_mean) + ((bt_l0_27) - bt0_mean)*((bt_l0_27) - bt0_mean) + ((bt_l0_28) - bt0_mean)*((bt_l0_28) - bt0_mean) + ((bt_l0_29) - bt0_mean)*((bt_l0_29) - bt0_mean) + ((bt_l0_30) - bt0_mean)*((bt_l0_30) - bt0_mean) + ((bt_l0_31) - bt0_mean)*((bt_l0_31) - bt0_mean) + ((bt_l0_32) - bt0_mean)*((bt_l0_32) - bt0_mean) + ((bt_l0_33) - bt0_mean)*((bt_l0_33) - bt0_mean) + ((bt_l0_34) - bt0_mean)*((bt_l0_34) - bt0_mean) + ((bt_l0_35) - bt0_mean)*((bt_l0_35) - bt0_mean) + ((bt_l0_36) - bt0_mean)*((bt_l0_36) - bt0_mean) + ((bt_l0_37) - bt0_mean)*((bt_l0_37) - bt0_mean) + ((bt_l0_38) - bt0_mean)*((bt_l0_38) - bt0_mean) + ((bt_l0_39) - bt0_mean)*((bt_l0_39) - bt0_mean) + ((bt_l0_40) - bt0_mean)*((bt_l0_40) - bt0_mean) + ((bt_l0_41) - bt0_mean)*((bt_l0_41) - bt0_mean) + ((bt_l0_42) - bt0_mean)*((bt_l0_42) - bt0_mean) + ((bt_l0_43) - bt0_mean)*((bt_l0_43) - bt0_mean) + ((bt_l0_44) - bt0_mean)*((bt_l0_44) - bt0_mean) + ((bt_l0_45) - bt0_mean)*((bt_l0_45) - bt0_mean) + ((bt_l0_46) - bt0_mean)*((bt_l0_46) - bt0_mean) + ((bt_l0_47) - bt0_mean)*((bt_l0_47) - bt0_mean) + ((bt_l0_48) - bt0_mean)*((bt_l0_48) - bt0_mean) + ((bt_l0_49) - bt0_mean)*((bt_l0_49) - bt0_mean) + ((bt_l0_50) - bt0_mean)*((bt_l0_50) - bt0_mean) + ((bt_l0_51) - bt0_mean)*((bt_l0_51) - bt0_mean) + ((bt_l0_52) - bt0_mean)*((bt_l0_52) - bt0_mean) + ((bt_l0_53) - bt0_mean)*((bt_l0_53) - bt0_mean) + ((bt_l0_54) - bt0_mean)*((bt_l0_54) - bt0_mean) + ((bt_l0_55) - bt0_mean)*((bt_l0_55) - bt0_mean) + ((bt_l0_56) - bt0_mean)*((bt_l0_56) - bt0_mean) + ((bt_l0_57) - bt0_mean)*((bt_l0_57) - bt0_mean) + ((bt_l0_58) - bt0_mean)*((bt_l0_58) - bt0_mean) + ((bt_l0_59) - bt0_mean)*((bt_l0_59) - bt0_mean) + ((bt_l0_60) - bt0_mean)*((bt_l0_60) - bt0_mean) + ((bt_l0_61) - bt0_mean)*((bt_l0_61) - bt0_mean) + ((bt_l0_62) - bt0_mean)*((bt_l0_62) - bt0_mean) + ((bt_l0_63) - bt0_mean)*((bt_l0_63) - bt0_mean)) / 64;
    bt_n0_0 = (((bt_l0_0) - bt0_mean) / sqrt(bt0_var + ln_eps)) * (-1.1599415756791132e-06) + (4.7728253349532679e-08);
    bt_n0_1 = (((bt_l0_1) - bt0_mean) / sqrt(bt0_var + ln_eps)) * (5.1052774097115616e-07) + (-2.0868797889761481e-07);
    bt_n0_2 = (((bt_l0_2) - bt0_mean) / sqrt(bt0_var + ln_eps)) * (0.28061515092849731) + (-0.0043619163334369659);
    bt_n0_3 = (((bt_l0_3) - bt0_mean) / sqrt(bt0_var + ln_eps)) * (4.0021308223003871e-07) + (4.2206568195979344e-07);
    bt_n0_4 = (((bt_l0_4) - bt0_mean) / sqrt(bt0_var + ln_eps)) * (1.4106071830610745e-06) + (1.1547620033525163e-06);
    bt_n0_5 = (((bt_l0_5) - bt0_mean) / sqrt(bt0_var + ln_eps)) * (2.3056637132867763e-07) + (4.7105650935463927e-08);
    bt_n0_6 = (((bt_l0_6) - bt0_mean) / sqrt(bt0_var + ln_eps)) * (-1.084014868979466e-07) + (-1.1667647470403608e-07);
    bt_n0_7 = (((bt_l0_7) - bt0_mean) / sqrt(bt0_var + ln_eps)) * (-8.6249521302761423e-08) + (-1.0387743287765261e-07);
    bt_n0_8 = (((bt_l0_8) - bt0_mean) / sqrt(bt0_var + ln_eps)) * (0.42276033759117126) + (-0.044782698154449463);
    bt_n0_9 = (((bt_l0_9) - bt0_mean) / sqrt(bt0_var + ln_eps)) * (3.1306328196478717e-07) + (3.4479853638913482e-07);
    bt_n0_10 = (((bt_l0_10) - bt0_mean) / sqrt(bt0_var + ln_eps)) * (0.12162677198648453) + (-0.10609477013349533);
    bt_n0_11 = (((bt_l0_11) - bt0_mean) / sqrt(bt0_var + ln_eps)) * (-5.3704357014794368e-06) + (1.671287009230582e-06);
    bt_n0_12 = (((bt_l0_12) - bt0_mean) / sqrt(bt0_var + ln_eps)) * (-7.9129506502795266e-07) + (4.6663748776154534e-07);
    bt_n0_13 = (((bt_l0_13) - bt0_mean) / sqrt(bt0_var + ln_eps)) * (0.21965198218822479) + (-0.033372808247804642);
    bt_n0_14 = (((bt_l0_14) - bt0_mean) / sqrt(bt0_var + ln_eps)) * (1.0570352060312871e-06) + (-5.8336913077994268e-09);
    bt_n0_15 = (((bt_l0_15) - bt0_mean) / sqrt(bt0_var + ln_eps)) * (-2.7261171453574207e-07) + (-7.6799636872237897e-08);
    bt_n0_16 = (((bt_l0_16) - bt0_mean) / sqrt(bt0_var + ln_eps)) * (0.2770821750164032) + (-0.15124852955341339);
    bt_n0_17 = (((bt_l0_17) - bt0_mean) / sqrt(bt0_var + ln_eps)) * (0.25034841895103455) + (0.058246463537216187);
    bt_n0_18 = (((bt_l0_18) - bt0_mean) / sqrt(bt0_var + ln_eps)) * (-2.2984427232586313e-06) + (-1.3129808849043911e-06);
    bt_n0_19 = (((bt_l0_19) - bt0_mean) / sqrt(bt0_var + ln_eps)) * (-2.818831035256153e-07) + (-5.2870109357172623e-07);
    bt_n0_20 = (((bt_l0_20) - bt0_mean) / sqrt(bt0_var + ln_eps)) * (-5.1076259666160695e-08) + (-2.1641049841036875e-07);
    bt_n0_21 = (((bt_l0_21) - bt0_mean) / sqrt(bt0_var + ln_eps)) * (-3.4201423204649473e-07) + (-1.4445872942303595e-08);
    bt_n0_22 = (((bt_l0_22) - bt0_mean) / sqrt(bt0_var + ln_eps)) * (0.41166719794273376) + (-0.035201821476221085);
    bt_n0_23 = (((bt_l0_23) - bt0_mean) / sqrt(bt0_var + ln_eps)) * (1.0064948128274409e-06) + (6.9751166620335425e-07);
    bt_n0_24 = (((bt_l0_24) - bt0_mean) / sqrt(bt0_var + ln_eps)) * (-1.6919474887799879e-07) + (3.0700417141815706e-07);
    bt_n0_25 = (((bt_l0_25) - bt0_mean) / sqrt(bt0_var + ln_eps)) * (-1.6840058947309444e-07) + (-4.9440762950325734e-07);
    bt_n0_26 = (((bt_l0_26) - bt0_mean) / sqrt(bt0_var + ln_eps)) * (7.7702161433990113e-06) + (5.7264778661192395e-06);
    bt_n0_27 = (((bt_l0_27) - bt0_mean) / sqrt(bt0_var + ln_eps)) * (0.40431231260299683) + (0.062081418931484222);
    bt_n0_28 = (((bt_l0_28) - bt0_mean) / sqrt(bt0_var + ln_eps)) * (-5.9669980601029238e-07) + (-5.0840111498473561e-07);
    bt_n0_29 = (((bt_l0_29) - bt0_mean) / sqrt(bt0_var + ln_eps)) * (2.6467063435120508e-05) + (2.2166090275277384e-05);
    bt_n0_30 = (((bt_l0_30) - bt0_mean) / sqrt(bt0_var + ln_eps)) * (-3.1974258263289812e-07) + (1.1624168649859712e-07);
    bt_n0_31 = (((bt_l0_31) - bt0_mean) / sqrt(bt0_var + ln_eps)) * (-1.8908603749423492e-07) + (-4.0863042727323773e-07);
    bt_n0_32 = (((bt_l0_32) - bt0_mean) / sqrt(bt0_var + ln_eps)) * (3.6379097423377971e-07) + (-1.916018561587407e-07);
    bt_n0_33 = (((bt_l0_33) - bt0_mean) / sqrt(bt0_var + ln_eps)) * (-1.43263268910232e-05) + (-1.2780606994056143e-05);
    bt_n0_34 = (((bt_l0_34) - bt0_mean) / sqrt(bt0_var + ln_eps)) * (-1.08419055777631e-06) + (-1.9931120220917364e-07);
    bt_n0_35 = (((bt_l0_35) - bt0_mean) / sqrt(bt0_var + ln_eps)) * (-2.0473883921567904e-07) + (-1.0122178650817659e-07);
    bt_n0_36 = (((bt_l0_36) - bt0_mean) / sqrt(bt0_var + ln_eps)) * (8.2675609291982255e-07) + (3.1844443526551913e-08);
    bt_n0_37 = (((bt_l0_37) - bt0_mean) / sqrt(bt0_var + ln_eps)) * (-1.5449282955160015e-06) + (-8.619752520644397e-07);
    bt_n0_38 = (((bt_l0_38) - bt0_mean) / sqrt(bt0_var + ln_eps)) * (5.074112436886935e-07) + (6.9824004356178193e-08);
    bt_n0_39 = (((bt_l0_39) - bt0_mean) / sqrt(bt0_var + ln_eps)) * (1.2687183925663703e-06) + (7.2563608455311623e-07);
    bt_n0_40 = (((bt_l0_40) - bt0_mean) / sqrt(bt0_var + ln_eps)) * (-2.0478627504871838e-07) + (-3.2916113923420198e-07);
    bt_n0_41 = (((bt_l0_41) - bt0_mean) / sqrt(bt0_var + ln_eps)) * (1.4765986122711183e-07) + (-1.2787754855025923e-08);
    bt_n0_42 = (((bt_l0_42) - bt0_mean) / sqrt(bt0_var + ln_eps)) * (-1.4333298281599127e-07) + (-3.6597467101273651e-07);
    bt_n0_43 = (((bt_l0_43) - bt0_mean) / sqrt(bt0_var + ln_eps)) * (-1.1976602820595872e-07) + (-3.5894100847144728e-07);
    bt_n0_44 = (((bt_l0_44) - bt0_mean) / sqrt(bt0_var + ln_eps)) * (-2.5672926540210028e-07) + (-3.1429132718585606e-07);
    bt_n0_45 = (((bt_l0_45) - bt0_mean) / sqrt(bt0_var + ln_eps)) * (4.3593882992354338e-07) + (5.275112471281318e-07);
    bt_n0_46 = (((bt_l0_46) - bt0_mean) / sqrt(bt0_var + ln_eps)) * (-2.501896005924209e-07) + (8.8119143981657544e-08);
    bt_n0_47 = (((bt_l0_47) - bt0_mean) / sqrt(bt0_var + ln_eps)) * (-2.7336750640927221e-09) + (2.092799746833407e-07);
    bt_n0_48 = (((bt_l0_48) - bt0_mean) / sqrt(bt0_var + ln_eps)) * (1.4415145699331333e-07) + (2.6845731326829991e-07);
    bt_n0_49 = (((bt_l0_49) - bt0_mean) / sqrt(bt0_var + ln_eps)) * (-1.4518775515171001e-06) + (-1.0742600125013269e-06);
    bt_n0_50 = (((bt_l0_50) - bt0_mean) / sqrt(bt0_var + ln_eps)) * (-3.7456633435795084e-05) + (-2.9544109565904364e-05);
    bt_n0_51 = (((bt_l0_51) - bt0_mean) / sqrt(bt0_var + ln_eps)) * (8.0714897876532632e-07) + (-6.6154166233900469e-07);
    bt_n0_52 = (((bt_l0_52) - bt0_mean) / sqrt(bt0_var + ln_eps)) * (-5.8551091797198751e-07) + (-4.5365536038843857e-07);
    bt_n0_53 = (((bt_l0_53) - bt0_mean) / sqrt(bt0_var + ln_eps)) * (-8.0300139870814746e-07) + (-3.2173517183764488e-09);
    bt_n0_54 = (((bt_l0_54) - bt0_mean) / sqrt(bt0_var + ln_eps)) * (1.4090753097661946e-07) + (5.3576678737954353e-07);
    bt_n0_55 = (((bt_l0_55) - bt0_mean) / sqrt(bt0_var + ln_eps)) * (2.4884531057978165e-07) + (1.8136454116302048e-07);
    bt_n0_56 = (((bt_l0_56) - bt0_mean) / sqrt(bt0_var + ln_eps)) * (-1.314246901529259e-06) + (-5.0321943945164094e-07);
    bt_n0_57 = (((bt_l0_57) - bt0_mean) / sqrt(bt0_var + ln_eps)) * (-2.0539077922876459e-06) + (1.7686522824078565e-06);
    bt_n0_58 = (((bt_l0_58) - bt0_mean) / sqrt(bt0_var + ln_eps)) * (0.26847928762435913) + (0.081100143492221832);
    bt_n0_59 = (((bt_l0_59) - bt0_mean) / sqrt(bt0_var + ln_eps)) * (-5.6184916275014984e-07) + (-1.2380776581721875e-07);
    bt_n0_60 = (((bt_l0_60) - bt0_mean) / sqrt(bt0_var + ln_eps)) * (2.5510321393085178e-06) + (1.3726223642152036e-06);
    bt_n0_61 = (((bt_l0_61) - bt0_mean) / sqrt(bt0_var + ln_eps)) * (-3.4782092939167342e-07) + (-2.2045769298983942e-07);
    bt_n0_62 = (((bt_l0_62) - bt0_mean) / sqrt(bt0_var + ln_eps)) * (-3.5657396324495494e-07) + (-1.3240964769067887e-08);
    bt_n0_63 = (((bt_l0_63) - bt0_mean) / sqrt(bt0_var + ln_eps)) * (0.38779368996620178) + (-0.009575466625392437);
    bt_g0_0 = gelu_approx(bt_n0_0);
    bt_g0_1 = gelu_approx(bt_n0_1);
    bt_g0_2 = gelu_approx(bt_n0_2);
    bt_g0_3 = gelu_approx(bt_n0_3);
    bt_g0_4 = gelu_approx(bt_n0_4);
    bt_g0_5 = gelu_approx(bt_n0_5);
    bt_g0_6 = gelu_approx(bt_n0_6);
    bt_g0_7 = gelu_approx(bt_n0_7);
    bt_g0_8 = gelu_approx(bt_n0_8);
    bt_g0_9 = gelu_approx(bt_n0_9);
    bt_g0_10 = gelu_approx(bt_n0_10);
    bt_g0_11 = gelu_approx(bt_n0_11);
    bt_g0_12 = gelu_approx(bt_n0_12);
    bt_g0_13 = gelu_approx(bt_n0_13);
    bt_g0_14 = gelu_approx(bt_n0_14);
    bt_g0_15 = gelu_approx(bt_n0_15);
    bt_g0_16 = gelu_approx(bt_n0_16);
    bt_g0_17 = gelu_approx(bt_n0_17);
    bt_g0_18 = gelu_approx(bt_n0_18);
    bt_g0_19 = gelu_approx(bt_n0_19);
    bt_g0_20 = gelu_approx(bt_n0_20);
    bt_g0_21 = gelu_approx(bt_n0_21);
    bt_g0_22 = gelu_approx(bt_n0_22);
    bt_g0_23 = gelu_approx(bt_n0_23);
    bt_g0_24 = gelu_approx(bt_n0_24);
    bt_g0_25 = gelu_approx(bt_n0_25);
    bt_g0_26 = gelu_approx(bt_n0_26);
    bt_g0_27 = gelu_approx(bt_n0_27);
    bt_g0_28 = gelu_approx(bt_n0_28);
    bt_g0_29 = gelu_approx(bt_n0_29);
    bt_g0_30 = gelu_approx(bt_n0_30);
    bt_g0_31 = gelu_approx(bt_n0_31);
    bt_g0_32 = gelu_approx(bt_n0_32);
    bt_g0_33 = gelu_approx(bt_n0_33);
    bt_g0_34 = gelu_approx(bt_n0_34);
    bt_g0_35 = gelu_approx(bt_n0_35);
    bt_g0_36 = gelu_approx(bt_n0_36);
    bt_g0_37 = gelu_approx(bt_n0_37);
    bt_g0_38 = gelu_approx(bt_n0_38);
    bt_g0_39 = gelu_approx(bt_n0_39);
    bt_g0_40 = gelu_approx(bt_n0_40);
    bt_g0_41 = gelu_approx(bt_n0_41);
    bt_g0_42 = gelu_approx(bt_n0_42);
    bt_g0_43 = gelu_approx(bt_n0_43);
    bt_g0_44 = gelu_approx(bt_n0_44);
    bt_g0_45 = gelu_approx(bt_n0_45);
    bt_g0_46 = gelu_approx(bt_n0_46);
    bt_g0_47 = gelu_approx(bt_n0_47);
    bt_g0_48 = gelu_approx(bt_n0_48);
    bt_g0_49 = gelu_approx(bt_n0_49);
    bt_g0_50 = gelu_approx(bt_n0_50);
    bt_g0_51 = gelu_approx(bt_n0_51);
    bt_g0_52 = gelu_approx(bt_n0_52);
    bt_g0_53 = gelu_approx(bt_n0_53);
    bt_g0_54 = gelu_approx(bt_n0_54);
    bt_g0_55 = gelu_approx(bt_n0_55);
    bt_g0_56 = gelu_approx(bt_n0_56);
    bt_g0_57 = gelu_approx(bt_n0_57);
    bt_g0_58 = gelu_approx(bt_n0_58);
    bt_g0_59 = gelu_approx(bt_n0_59);
    bt_g0_60 = gelu_approx(bt_n0_60);
    bt_g0_61 = gelu_approx(bt_n0_61);
    bt_g0_62 = gelu_approx(bt_n0_62);
    bt_g0_63 = gelu_approx(bt_n0_63);
    bt_l1_0 = 0.075349971652030945;
    bt_l1_0 = bt_l1_0 + (2.7569292342377594e-06)*bt_g0_0;
    bt_l1_0 = bt_l1_0 + (1.2637143527172157e-06)*bt_g0_1;
    bt_l1_0 = bt_l1_0 + (0.035211015492677689)*bt_g0_2;
    bt_l1_0 = bt_l1_0 + (-1.4212611176844803e-06)*bt_g0_3;
    bt_l1_0 = bt_l1_0 + (-3.4041192975564627e-06)*bt_g0_4;
    bt_l1_0 = bt_l1_0 + (2.6003594939538743e-06)*bt_g0_5;
    bt_l1_0 = bt_l1_0 + (3.8425073398684617e-06)*bt_g0_6;
    bt_l1_0 = bt_l1_0 + (3.8176472116902005e-06)*bt_g0_7;
    bt_l1_0 = bt_l1_0 + (0.0098289158195257187)*bt_g0_8;
    bt_l1_0 = bt_l1_0 + (-4.2298829612263944e-06)*bt_g0_9;
    bt_l1_0 = bt_l1_0 + (0.067811332643032074)*bt_g0_10;
    bt_l1_0 = bt_l1_0 + (-3.0893625080352649e-06)*bt_g0_11;
    bt_l1_0 = bt_l1_0 + (1.4776243233427522e-06)*bt_g0_12;
    bt_l1_0 = bt_l1_0 + (0.15856364369392395)*bt_g0_13;
    bt_l1_0 = bt_l1_0 + (-3.0218018309824402e-06)*bt_g0_14;
    bt_l1_0 = bt_l1_0 + (-2.0060897440998815e-06)*bt_g0_15;
    bt_l1_0 = bt_l1_0 + (-0.15439185500144958)*bt_g0_16;
    bt_l1_0 = bt_l1_0 + (-0.035995103418827057)*bt_g0_17;
    bt_l1_0 = bt_l1_0 + (1.6879347413123469e-06)*bt_g0_18;
    bt_l1_0 = bt_l1_0 + (3.8421749195549637e-06)*bt_g0_19;
    bt_l1_0 = bt_l1_0 + (3.9507731344201602e-06)*bt_g0_20;
    bt_l1_0 = bt_l1_0 + (-2.2807412278780248e-06)*bt_g0_21;
    bt_l1_0 = bt_l1_0 + (0.0074361925944685936)*bt_g0_22;
    bt_l1_0 = bt_l1_0 + (-2.1797998215333791e-06)*bt_g0_23;
    bt_l1_0 = bt_l1_0 + (-4.3736317820730619e-06)*bt_g0_24;
    bt_l1_0 = bt_l1_0 + (6.3207983203028562e-07)*bt_g0_25;
    bt_l1_0 = bt_l1_0 + (-4.3397849367465824e-06)*bt_g0_26;
    bt_l1_0 = bt_l1_0 + (0.15337049961090088)*bt_g0_27;
    bt_l1_0 = bt_l1_0 + (3.3149158298328985e-06)*bt_g0_28;
    bt_l1_0 = bt_l1_0 + (-1.3522796507459134e-05)*bt_g0_29;
    bt_l1_0 = bt_l1_0 + (2.9266504952829564e-06)*bt_g0_30;
    bt_l1_0 = bt_l1_0 + (4.4219330419537073e-08)*bt_g0_31;
    bt_l1_0 = bt_l1_0 + (3.6685098621092038e-06)*bt_g0_32;
    bt_l1_0 = bt_l1_0 + (6.9630677899112925e-06)*bt_g0_33;
    bt_l1_0 = bt_l1_0 + (2.1643211312039057e-06)*bt_g0_34;
    bt_l1_0 = bt_l1_0 + (-2.4126238713506609e-06)*bt_g0_35;
    bt_l1_0 = bt_l1_0 + (-3.3620890462771058e-06)*bt_g0_36;
    bt_l1_0 = bt_l1_0 + (2.7132041395816486e-06)*bt_g0_37;
    bt_l1_0 = bt_l1_0 + (-3.770256398638594e-06)*bt_g0_38;
    bt_l1_0 = bt_l1_0 + (8.33848474712795e-08)*bt_g0_39;
    bt_l1_0 = bt_l1_0 + (4.2792516978806816e-06)*bt_g0_40;
    bt_l1_0 = bt_l1_0 + (3.1609883990313392e-06)*bt_g0_41;
    bt_l1_0 = bt_l1_0 + (4.411694135342259e-06)*bt_g0_42;
    bt_l1_0 = bt_l1_0 + (4.3509407987585291e-06)*bt_g0_43;
    bt_l1_0 = bt_l1_0 + (-4.5411121618599282e-07)*bt_g0_44;
    bt_l1_0 = bt_l1_0 + (-2.4963185296655865e-06)*bt_g0_45;
    bt_l1_0 = bt_l1_0 + (-3.3091430395870702e-06)*bt_g0_46;
    bt_l1_0 = bt_l1_0 + (-4.0279437598655932e-06)*bt_g0_47;
    bt_l1_0 = bt_l1_0 + (-4.1523385334585328e-06)*bt_g0_48;
    bt_l1_0 = bt_l1_0 + (2.6002931008406449e-06)*bt_g0_49;
    bt_l1_0 = bt_l1_0 + (1.9567689378163777e-05)*bt_g0_50;
    bt_l1_0 = bt_l1_0 + (4.3013960748794489e-06)*bt_g0_51;
    bt_l1_0 = bt_l1_0 + (2.4431060410279315e-06)*bt_g0_52;
    bt_l1_0 = bt_l1_0 + (1.0146227396035101e-06)*bt_g0_53;
    bt_l1_0 = bt_l1_0 + (-9.6760356882441556e-07)*bt_g0_54;
    bt_l1_0 = bt_l1_0 + (1.6509466149727814e-06)*bt_g0_55;
    bt_l1_0 = bt_l1_0 + (1.5483794868487166e-06)*bt_g0_56;
    bt_l1_0 = bt_l1_0 + (-1.3599176327261375e-06)*bt_g0_57;
    bt_l1_0 = bt_l1_0 + (-0.011726586148142815)*bt_g0_58;
    bt_l1_0 = bt_l1_0 + (-3.8964336113167519e-07)*bt_g0_59;
    bt_l1_0 = bt_l1_0 + (-1.6466343595311628e-06)*bt_g0_60;
    bt_l1_0 = bt_l1_0 + (3.9499232116213534e-06)*bt_g0_61;
    bt_l1_0 = bt_l1_0 + (-2.2223275664146058e-06)*bt_g0_62;
    bt_l1_0 = bt_l1_0 + (-0.019763022661209106)*bt_g0_63;
    bt_l1_1 = 0.0070155649445950985;
    bt_l1_1 = bt_l1_1 + (4.1091965385930962e-07)*bt_g0_0;
    bt_l1_1 = bt_l1_1 + (8.3301131326152245e-07)*bt_g0_1;
    bt_l1_1 = bt_l1_1 + (-0.002448175335302949)*bt_g0_2;
    bt_l1_1 = bt_l1_1 + (-6.1839465104185365e-08)*bt_g0_3;
    bt_l1_1 = bt_l1_1 + (-1.7735466428803193e-07)*bt_g0_4;
    bt_l1_1 = bt_l1_1 + (4.5252718905430811e-07)*bt_g0_5;
    bt_l1_1 = bt_l1_1 + (5.7209672377211973e-07)*bt_g0_6;
    bt_l1_1 = bt_l1_1 + (5.7345368986716494e-07)*bt_g0_7;
    bt_l1_1 = bt_l1_1 + (0.0060920082032680511)*bt_g0_8;
    bt_l1_1 = bt_l1_1 + (-5.6733910014372668e-07)*bt_g0_9;
    bt_l1_1 = bt_l1_1 + (-0.00032119487877935171)*bt_g0_10;
    bt_l1_1 = bt_l1_1 + (-1.0482543757461826e-06)*bt_g0_11;
    bt_l1_1 = bt_l1_1 + (3.5985161161988799e-07)*bt_g0_12;
    bt_l1_1 = bt_l1_1 + (-0.0028173539321869612)*bt_g0_13;
    bt_l1_1 = bt_l1_1 + (-4.3657999526658386e-07)*bt_g0_14;
    bt_l1_1 = bt_l1_1 + (-3.8004301927685447e-07)*bt_g0_15;
    bt_l1_1 = bt_l1_1 + (0.00097835948690772057)*bt_g0_16;
    bt_l1_1 = bt_l1_1 + (0.0014903479022905231)*bt_g0_17;
    bt_l1_1 = bt_l1_1 + (-2.2134336177259684e-06)*bt_g0_18;
    bt_l1_1 = bt_l1_1 + (5.4755258815930574e-07)*bt_g0_19;
    bt_l1_1 = bt_l1_1 + (5.6338802778554964e-07)*bt_g0_20;
    bt_l1_1 = bt_l1_1 + (-4.0161825154427788e-07)*bt_g0_21;
    bt_l1_1 = bt_l1_1 + (0.0015062958700582385)*bt_g0_22;
    bt_l1_1 = bt_l1_1 + (-9.665879474596295e-08)*bt_g0_23;
    bt_l1_1 = bt_l1_1 + (-6.2711563941775239e-07)*bt_g0_24;
    bt_l1_1 = bt_l1_1 + (-8.1023010523040284e-08)*bt_g0_25;
    bt_l1_1 = bt_l1_1 + (-7.7196170877869008e-07)*bt_g0_26;
    bt_l1_1 = bt_l1_1 + (0.00053395552095025778)*bt_g0_27;
    bt_l1_1 = bt_l1_1 + (4.0172898252421874e-07)*bt_g0_28;
    bt_l1_1 = bt_l1_1 + (-3.0904636787454365e-06)*bt_g0_29;
    bt_l1_1 = bt_l1_1 + (4.8898709792410955e-07)*bt_g0_30;
    bt_l1_1 = bt_l1_1 + (-1.5051747936922766e-07)*bt_g0_31;
    bt_l1_1 = bt_l1_1 + (5.7894067140296102e-07)*bt_g0_32;
    bt_l1_1 = bt_l1_1 + (1.6688585446900106e-06)*bt_g0_33;
    bt_l1_1 = bt_l1_1 + (4.9144256308863987e-07)*bt_g0_34;
    bt_l1_1 = bt_l1_1 + (-4.4127477849542629e-07)*bt_g0_35;
    bt_l1_1 = bt_l1_1 + (-4.8526777618462802e-07)*bt_g0_36;
    bt_l1_1 = bt_l1_1 + (9.7579679447790113e-08)*bt_g0_37;
    bt_l1_1 = bt_l1_1 + (-5.6200957487817504e-07)*bt_g0_38;
    bt_l1_1 = bt_l1_1 + (-1.0825850722540054e-06)*bt_g0_39;
    bt_l1_1 = bt_l1_1 + (5.8719058415590553e-07)*bt_g0_40;
    bt_l1_1 = bt_l1_1 + (5.1439712933643023e-07)*bt_g0_41;
    bt_l1_1 = bt_l1_1 + (6.0628366327364347e-07)*bt_g0_42;
    bt_l1_1 = bt_l1_1 + (5.9926247786279419e-07)*bt_g0_43;
    bt_l1_1 = bt_l1_1 + (-2.1731322874529724e-07)*bt_g0_44;
    bt_l1_1 = bt_l1_1 + (-2.2657056319985713e-07)*bt_g0_45;
    bt_l1_1 = bt_l1_1 + (-5.3124688292882638e-07)*bt_g0_46;
    bt_l1_1 = bt_l1_1 + (-5.843871804245282e-07)*bt_g0_47;
    bt_l1_1 = bt_l1_1 + (-5.8633150956666213e-07)*bt_g0_48;
    bt_l1_1 = bt_l1_1 + (3.2941349559223454e-07)*bt_g0_49;
    bt_l1_1 = bt_l1_1 + (3.8288699215627275e-06)*bt_g0_50;
    bt_l1_1 = bt_l1_1 + (5.7805834785540355e-07)*bt_g0_51;
    bt_l1_1 = bt_l1_1 + (2.5169021000692737e-07)*bt_g0_52;
    bt_l1_1 = bt_l1_1 + (1.2184148090454983e-07)*bt_g0_53;
    bt_l1_1 = bt_l1_1 + (3.1933161892538919e-08)*bt_g0_54;
    bt_l1_1 = bt_l1_1 + (3.5448840662866132e-07)*bt_g0_55;
    bt_l1_1 = bt_l1_1 + (-3.6428968996915501e-07)*bt_g0_56;
    bt_l1_1 = bt_l1_1 + (-5.3611734074365813e-07)*bt_g0_57;
    bt_l1_1 = bt_l1_1 + (-0.0024407696910202503)*bt_g0_58;
    bt_l1_1 = bt_l1_1 + (-1.7394226858868933e-07)*bt_g0_59;
    bt_l1_1 = bt_l1_1 + (2.1694777387892827e-06)*bt_g0_60;
    bt_l1_1 = bt_l1_1 + (5.5550822253280785e-07)*bt_g0_61;
    bt_l1_1 = bt_l1_1 + (-3.9691417441645171e-07)*bt_g0_62;
    bt_l1_1 = bt_l1_1 + (0.0014183046296238899)*bt_g0_63;
    bt_l1_2 = 0.00701562175527215;
    bt_l1_2 = bt_l1_2 + (4.1091857383435126e-07)*bt_g0_0;
    bt_l1_2 = bt_l1_2 + (8.3301296172066941e-07)*bt_g0_1;
    bt_l1_2 = bt_l1_2 + (-0.0024481937289237976)*bt_g0_2;
    bt_l1_2 = bt_l1_2 + (-6.1840211174057913e-08)*bt_g0_3;
    bt_l1_2 = bt_l1_2 + (-1.7735368373905658e-07)*bt_g0_4;
    bt_l1_2 = bt_l1_2 + (4.5252573954712716e-07)*bt_g0_5;
    bt_l1_2 = bt_l1_2 + (5.7209535953006707e-07)*bt_g0_6;
    bt_l1_2 = bt_l1_2 + (5.7345232562511228e-07)*bt_g0_7;
    bt_l1_2 = bt_l1_2 + (0.0060919551178812981)*bt_g0_8;
    bt_l1_2 = bt_l1_2 + (-5.6733807696218719e-07)*bt_g0_9;
    bt_l1_2 = bt_l1_2 + (-0.00032119115348905325)*bt_g0_10;
    bt_l1_2 = bt_l1_2 + (-1.0482566494829371e-06)*bt_g0_11;
    bt_l1_2 = bt_l1_2 + (3.5984999158245046e-07)*bt_g0_12;
    bt_l1_2 = bt_l1_2 + (-0.0028173283208161592)*bt_g0_13;
    bt_l1_2 = bt_l1_2 + (-4.3657880155478779e-07)*bt_g0_14;
    bt_l1_2 = bt_l1_2 + (-3.8004154134796408e-07)*bt_g0_15;
    bt_l1_2 = bt_l1_2 + (0.00097824714612215757)*bt_g0_16;
    bt_l1_2 = bt_l1_2 + (0.0014903120463714004)*bt_g0_17;
    bt_l1_2 = bt_l1_2 + (-2.2134236132842489e-06)*bt_g0_18;
    bt_l1_2 = bt_l1_2 + (5.4755122391725308e-07)*bt_g0_19;
    bt_l1_2 = bt_l1_2 + (5.633864930132404e-07)*bt_g0_20;
    bt_l1_2 = bt_l1_2 + (-4.0161697256735351e-07)*bt_g0_21;
    bt_l1_2 = bt_l1_2 + (0.0015062801539897919)*bt_g0_22;
    bt_l1_2 = bt_l1_2 + (-9.6658375525748852e-08)*bt_g0_23;
    bt_l1_2 = bt_l1_2 + (-6.2711393411518657e-07)*bt_g0_24;
    bt_l1_2 = bt_l1_2 + (-8.1021745756970631e-08)*bt_g0_25;
    bt_l1_2 = bt_l1_2 + (-7.7195596759338514e-07)*bt_g0_26;
    bt_l1_2 = bt_l1_2 + (0.00053391262190416455)*bt_g0_27;
    bt_l1_2 = bt_l1_2 + (4.0172878357225272e-07)*bt_g0_28;
    bt_l1_2 = bt_l1_2 + (-3.0904409413778922e-06)*bt_g0_29;
    bt_l1_2 = bt_l1_2 + (4.8898539262154372e-07)*bt_g0_30;
    bt_l1_2 = bt_l1_2 + (-1.5051602986204671e-07)*bt_g0_31;
    bt_l1_2 = bt_l1_2 + (5.7893913663065177e-07)*bt_g0_32;
    bt_l1_2 = bt_l1_2 + (1.6688442201484577e-06)*bt_g0_33;
    bt_l1_2 = bt_l1_2 + (4.9144023250846658e-07)*bt_g0_34;
    bt_l1_2 = bt_l1_2 + (-4.4127327214482648e-07)*bt_g0_35;
    bt_l1_2 = bt_l1_2 + (-4.8526675300308852e-07)*bt_g0_36;
    bt_l1_2 = bt_l1_2 + (9.7578585211977042e-08)*bt_g0_37;
    bt_l1_2 = bt_l1_2 + (-5.6200849485321669e-07)*bt_g0_38;
    bt_l1_2 = bt_l1_2 + (-1.0825780236700666e-06)*bt_g0_39;
    bt_l1_2 = bt_l1_2 + (5.8718927675727173e-07)*bt_g0_40;
    bt_l1_2 = bt_l1_2 + (5.1439559456412098e-07)*bt_g0_41;
    bt_l1_2 = bt_l1_2 + (6.0628252640526625e-07)*bt_g0_42;
    bt_l1_2 = bt_l1_2 + (5.9926117046416039e-07)*bt_g0_43;
    bt_l1_2 = bt_l1_2 + (-2.1731189292495401e-07)*bt_g0_44;
    bt_l1_2 = bt_l1_2 + (-2.2657098952549859e-07)*bt_g0_45;
    bt_l1_2 = bt_l1_2 + (-5.3124534815651714e-07)*bt_g0_46;
    bt_l1_2 = bt_l1_2 + (-5.8438553196538123e-07)*bt_g0_47;
    bt_l1_2 = bt_l1_2 + (-5.8633031585486606e-07)*bt_g0_48;
    bt_l1_2 = bt_l1_2 + (3.2941153449428384e-07)*bt_g0_49;
    bt_l1_2 = bt_l1_2 + (3.8288408177322708e-06)*bt_g0_50;
    bt_l1_2 = bt_l1_2 + (5.7805749520412064e-07)*bt_g0_51;
    bt_l1_2 = bt_l1_2 + (2.5169026685034623e-07)*bt_g0_52;
    bt_l1_2 = bt_l1_2 + (1.2184072772924992e-07)*bt_g0_53;
    bt_l1_2 = bt_l1_2 + (3.1932056998584812e-08)*bt_g0_54;
    bt_l1_2 = bt_l1_2 + (3.5448690027806151e-07)*bt_g0_55;
    bt_l1_2 = bt_l1_2 + (-3.6428775729291374e-07)*bt_g0_56;
    bt_l1_2 = bt_l1_2 + (-5.3612126293955953e-07)*bt_g0_57;
    bt_l1_2 = bt_l1_2 + (-0.0024407906457781792)*bt_g0_58;
    bt_l1_2 = bt_l1_2 + (-1.7394124540714984e-07)*bt_g0_59;
    bt_l1_2 = bt_l1_2 + (2.1694693259632913e-06)*bt_g0_60;
    bt_l1_2 = bt_l1_2 + (5.5550685829075519e-07)*bt_g0_61;
    bt_l1_2 = bt_l1_2 + (-3.969126680658519e-07)*bt_g0_62;
    bt_l1_2 = bt_l1_2 + (0.0014182653976604342)*bt_g0_63;
    bt_l1_3 = 0.0070156059227883816;
    bt_l1_3 = bt_l1_3 + (4.1091931279879645e-07)*bt_g0_0;
    bt_l1_3 = bt_l1_3 + (8.3301029007998295e-07)*bt_g0_1;
    bt_l1_3 = bt_l1_3 + (-0.0024481997825205326)*bt_g0_2;
    bt_l1_3 = bt_l1_3 + (-6.1839493525894795e-08)*bt_g0_3;
    bt_l1_3 = bt_l1_3 + (-1.773549200834168e-07)*bt_g0_4;
    bt_l1_3 = bt_l1_3 + (4.5252690483721381e-07)*bt_g0_5;
    bt_l1_3 = bt_l1_3 + (5.7209626902476884e-07)*bt_g0_6;
    bt_l1_3 = bt_l1_3 + (5.7345334880665177e-07)*bt_g0_7;
    bt_l1_3 = bt_l1_3 + (0.0060919919051229954)*bt_g0_8;
    bt_l1_3 = bt_l1_3 + (-5.6733858855295694e-07)*bt_g0_9;
    bt_l1_3 = bt_l1_3 + (-0.00032119284151121974)*bt_g0_10;
    bt_l1_3 = bt_l1_3 + (-1.0482523293831036e-06)*bt_g0_11;
    bt_l1_3 = bt_l1_3 + (3.5985104318569938e-07)*bt_g0_12;
    bt_l1_3 = bt_l1_3 + (-0.0028173518367111683)*bt_g0_13;
    bt_l1_3 = bt_l1_3 + (-4.3657942683239526e-07)*bt_g0_14;
    bt_l1_3 = bt_l1_3 + (-3.800426782163413e-07)*bt_g0_15;
    bt_l1_3 = bt_l1_3 + (0.00097830535378307104)*bt_g0_16;
    bt_l1_3 = bt_l1_3 + (0.001490310300141573)*bt_g0_17;
    bt_l1_3 = bt_l1_3 + (-2.2134290702524595e-06)*bt_g0_18;
    bt_l1_3 = bt_l1_3 + (5.4755179235144169e-07)*bt_g0_19;
    bt_l1_3 = bt_l1_3 + (5.6338751619477989e-07)*bt_g0_20;
    bt_l1_3 = bt_l1_3 + (-4.0161793890547415e-07)*bt_g0_21;
    bt_l1_3 = bt_l1_3 + (0.0015062827151268721)*bt_g0_22;
    bt_l1_3 = bt_l1_3 + (-9.6659157122758188e-08)*bt_g0_23;
    bt_l1_3 = bt_l1_3 + (-6.2711495729672606e-07)*bt_g0_24;
    bt_l1_3 = bt_l1_3 + (-8.1022847098211059e-08)*bt_g0_25;
    bt_l1_3 = bt_l1_3 + (-7.7196114034450147e-07)*bt_g0_26;
    bt_l1_3 = bt_l1_3 + (0.00053393421694636345)*bt_g0_27;
    bt_l1_3 = bt_l1_3 + (4.0172869830712443e-07)*bt_g0_28;
    bt_l1_3 = bt_l1_3 + (-3.0904600407666294e-06)*bt_g0_29;
    bt_l1_3 = bt_l1_3 + (4.8898647264650208e-07)*bt_g0_30;
    bt_l1_3 = bt_l1_3 + (-1.5051692514589377e-07)*bt_g0_31;
    bt_l1_3 = bt_l1_3 + (5.7894027349902899e-07)*bt_g0_32;
    bt_l1_3 = bt_l1_3 + (1.6688555888322298e-06)*bt_g0_33;
    bt_l1_3 = bt_l1_3 + (4.9144176728077582e-07)*bt_g0_34;
    bt_l1_3 = bt_l1_3 + (-4.4127449427833199e-07)*bt_g0_35;
    bt_l1_3 = bt_l1_3 + (-4.8526720775043941e-07)*bt_g0_36;
    bt_l1_3 = bt_l1_3 + (9.757980734548255e-08)*bt_g0_37;
    bt_l1_3 = bt_l1_3 + (-5.6200929066108074e-07)*bt_g0_38;
    bt_l1_3 = bt_l1_3 + (-1.0825829122040886e-06)*bt_g0_39;
    bt_l1_3 = bt_l1_3 + (5.8718995887829806e-07)*bt_g0_40;
    bt_l1_3 = bt_l1_3 + (5.143964472154039e-07)*bt_g0_41;
    bt_l1_3 = bt_l1_3 + (6.0628309483945486e-07)*bt_g0_42;
    bt_l1_3 = bt_l1_3 + (5.9926196627202444e-07)*bt_g0_43;
    bt_l1_3 = bt_l1_3 + (-2.1731302979333122e-07)*bt_g0_44;
    bt_l1_3 = bt_l1_3 + (-2.2657044951301941e-07)*bt_g0_45;
    bt_l1_3 = bt_l1_3 + (-5.3124614396438119e-07)*bt_g0_46;
    bt_l1_3 = bt_l1_3 + (-5.8438649830350187e-07)*bt_g0_47;
    bt_l1_3 = bt_l1_3 + (-5.8633099797589239e-07)*bt_g0_48;
    bt_l1_3 = bt_l1_3 + (3.2941301242317422e-07)*bt_g0_49;
    bt_l1_3 = bt_l1_3 + (3.828864009847166e-06)*bt_g0_50;
    bt_l1_3 = bt_l1_3 + (5.7805800679489039e-07)*bt_g0_51;
    bt_l1_3 = bt_l1_3 + (2.5169006789838022e-07)*bt_g0_52;
    bt_l1_3 = bt_l1_3 + (1.2184123932001967e-07)*bt_g0_53;
    bt_l1_3 = bt_l1_3 + (3.1932902544440367e-08)*bt_g0_54;
    bt_l1_3 = bt_l1_3 + (3.5448798030301987e-07)*bt_g0_55;
    bt_l1_3 = bt_l1_3 + (-3.6428909311325697e-07)*bt_g0_56;
    bt_l1_3 = bt_l1_3 + (-5.3611597650160547e-07)*bt_g0_57;
    bt_l1_3 = bt_l1_3 + (-0.0024407908786088228)*bt_g0_58;
    bt_l1_3 = bt_l1_3 + (-1.7394192752817617e-07)*bt_g0_59;
    bt_l1_3 = bt_l1_3 + (2.1694738734368002e-06)*bt_g0_60;
    bt_l1_3 = bt_l1_3 + (5.5550776778545696e-07)*bt_g0_61;
    bt_l1_3 = bt_l1_3 + (-3.9691380493422912e-07)*bt_g0_62;
    bt_l1_3 = bt_l1_3 + (0.0014182716840878129)*bt_g0_63;
    bt_l1_4 = 0.007015653420239687;
    bt_l1_4 = bt_l1_4 + (4.1091928437708702e-07)*bt_g0_0;
    bt_l1_4 = bt_l1_4 + (8.3301296172066941e-07)*bt_g0_1;
    bt_l1_4 = bt_l1_4 + (-0.0024482191074639559)*bt_g0_2;
    bt_l1_4 = bt_l1_4 + (-6.1839372733629716e-08)*bt_g0_3;
    bt_l1_4 = bt_l1_4 + (-1.7735395374529617e-07)*bt_g0_4;
    bt_l1_4 = bt_l1_4 + (4.5252713221088925e-07)*bt_g0_5;
    bt_l1_4 = bt_l1_4 + (5.7209649639844429e-07)*bt_g0_6;
    bt_l1_4 = bt_l1_4 + (5.7345363302374608e-07)*bt_g0_7;
    bt_l1_4 = bt_l1_4 + (0.00609201705083251)*bt_g0_8;
    bt_l1_4 = bt_l1_4 + (-5.6733847486611921e-07)*bt_g0_9;
    bt_l1_4 = bt_l1_4 + (-0.00032118996023200452)*bt_g0_10;
    bt_l1_4 = bt_l1_4 + (-1.0482552852408844e-06)*bt_g0_11;
    bt_l1_4 = bt_l1_4 + (3.5985158319817856e-07)*bt_g0_12;
    bt_l1_4 = bt_l1_4 + (-0.0028174100443720818)*bt_g0_13;
    bt_l1_4 = bt_l1_4 + (-4.3657945525410469e-07)*bt_g0_14;
    bt_l1_4 = bt_l1_4 + (-3.800426782163413e-07)*bt_g0_15;
    bt_l1_4 = bt_l1_4 + (0.00097827066201716661)*bt_g0_16;
    bt_l1_4 = bt_l1_4 + (0.0014902636175975204)*bt_g0_17;
    bt_l1_4 = bt_l1_4 + (-2.2134363462100737e-06)*bt_g0_18;
    bt_l1_4 = bt_l1_4 + (5.4755201972511713e-07)*bt_g0_19;
    bt_l1_4 = bt_l1_4 + (5.6338774356845533e-07)*bt_g0_20;
    bt_l1_4 = bt_l1_4 + (-4.0161819470085902e-07)*bt_g0_21;
    bt_l1_4 = bt_l1_4 + (0.0015062908641993999)*bt_g0_22;
    bt_l1_4 = bt_l1_4 + (-9.6658638426561083e-08)*bt_g0_23;
    bt_l1_4 = bt_l1_4 + (-6.2711501414014492e-07)*bt_g0_24;
    bt_l1_4 = bt_l1_4 + (-8.1023038944749715e-08)*bt_g0_25;
    bt_l1_4 = bt_l1_4 + (-7.7196239089971641e-07)*bt_g0_26;
    bt_l1_4 = bt_l1_4 + (0.00053393782582134008)*bt_g0_27;
    bt_l1_4 = bt_l1_4 + (4.0172878357225272e-07)*bt_g0_28;
    bt_l1_4 = bt_l1_4 + (-3.0904636787454365e-06)*bt_g0_29;
    bt_l1_4 = bt_l1_4 + (4.8898675686359638e-07)*bt_g0_30;
    bt_l1_4 = bt_l1_4 + (-1.5051726620640693e-07)*bt_g0_31;
    bt_l1_4 = bt_l1_4 + (5.7894055771612329e-07)*bt_g0_32;
    bt_l1_4 = bt_l1_4 + (1.6688568393874448e-06)*bt_g0_33;
    bt_l1_4 = bt_l1_4 + (4.9144233571496443e-07)*bt_g0_34;
    bt_l1_4 = bt_l1_4 + (-4.4127480691713572e-07)*bt_g0_35;
    bt_l1_4 = bt_l1_4 + (-4.8526754881095258e-07)*bt_g0_36;
    bt_l1_4 = bt_l1_4 + (9.7579111013601505e-08)*bt_g0_37;
    bt_l1_4 = bt_l1_4 + (-5.620093475044996e-07)*bt_g0_38;
    bt_l1_4 = bt_l1_4 + (-1.0825859817487071e-06)*bt_g0_39;
    bt_l1_4 = bt_l1_4 + (5.8719001572171692e-07)*bt_g0_40;
    bt_l1_4 = bt_l1_4 + (5.1439661774566048e-07)*bt_g0_41;
    bt_l1_4 = bt_l1_4 + (6.062833222131303e-07)*bt_g0_42;
    bt_l1_4 = bt_l1_4 + (5.9926168205493013e-07)*bt_g0_43;
    bt_l1_4 = bt_l1_4 + (-2.1731321453444252e-07)*bt_g0_44;
    bt_l1_4 = bt_l1_4 + (-2.2657035003703641e-07)*bt_g0_45;
    bt_l1_4 = bt_l1_4 + (-5.3124637133805663e-07)*bt_g0_46;
    bt_l1_4 = bt_l1_4 + (-5.8438655514692073e-07)*bt_g0_47;
    bt_l1_4 = bt_l1_4 + (-5.8633122534956783e-07)*bt_g0_48;
    bt_l1_4 = bt_l1_4 + (3.2941318295343081e-07)*bt_g0_49;
    bt_l1_4 = bt_l1_4 + (3.8288694668153767e-06)*bt_g0_50;
    bt_l1_4 = bt_l1_4 + (5.7805806363830925e-07)*bt_g0_51;
    bt_l1_4 = bt_l1_4 + (2.5168989736812364e-07)*bt_g0_52;
    bt_l1_4 = bt_l1_4 + (1.2184121089831024e-07)*bt_g0_53;
    bt_l1_4 = bt_l1_4 + (3.1933225841385138e-08)*bt_g0_54;
    bt_l1_4 = bt_l1_4 + (3.5448832136353303e-07)*bt_g0_55;
    bt_l1_4 = bt_l1_4 + (-3.6429054262043792e-07)*bt_g0_56;
    bt_l1_4 = bt_l1_4 + (-5.3611773864759016e-07)*bt_g0_57;
    bt_l1_4 = bt_l1_4 + (-0.0024408246390521526)*bt_g0_58;
    bt_l1_4 = bt_l1_4 + (-1.7394212648014218e-07)*bt_g0_59;
    bt_l1_4 = bt_l1_4 + (2.1694781935366336e-06)*bt_g0_60;
    bt_l1_4 = bt_l1_4 + (5.5550788147229468e-07)*bt_g0_61;
    bt_l1_4 = bt_l1_4 + (-3.9691389019935741e-07)*bt_g0_62;
    bt_l1_4 = bt_l1_4 + (0.0014182844897732139)*bt_g0_63;
    bt_l1_5 = 0.0070156287401914597;
    bt_l1_5 = bt_l1_5 + (4.1091936964221532e-07)*bt_g0_0;
    bt_l1_5 = bt_l1_5 + (8.3300983533263206e-07)*bt_g0_1;
    bt_l1_5 = bt_l1_5 + (-0.0024482079315930605)*bt_g0_2;
    bt_l1_5 = bt_l1_5 + (-6.1838598242047738e-08)*bt_g0_3;
    bt_l1_5 = bt_l1_5 + (-1.7735568746957142e-07)*bt_g0_4;
    bt_l1_5 = bt_l1_5 + (4.5252741642798355e-07)*bt_g0_5;
    bt_l1_5 = bt_l1_5 + (5.7209672377211973e-07)*bt_g0_6;
    bt_l1_5 = bt_l1_5 + (5.7345368986716494e-07)*bt_g0_7;
    bt_l1_5 = bt_l1_5 + (0.0060920133255422115)*bt_g0_8;
    bt_l1_5 = bt_l1_5 + (-5.6733853170953807e-07)*bt_g0_9;
    bt_l1_5 = bt_l1_5 + (-0.00032119182287715375)*bt_g0_10;
    bt_l1_5 = bt_l1_5 + (-1.0482503967068624e-06)*bt_g0_11;
    bt_l1_5 = bt_l1_5 + (3.5985198110211059e-07)*bt_g0_12;
    bt_l1_5 = bt_l1_5 + (-0.0028174016624689102)*bt_g0_13;
    bt_l1_5 = bt_l1_5 + (-4.3657954051923298e-07)*bt_g0_14;
    bt_l1_5 = bt_l1_5 + (-3.8004313296369219e-07)*bt_g0_15;
    bt_l1_5 = bt_l1_5 + (0.00097831676248461008)*bt_g0_16;
    bt_l1_5 = bt_l1_5 + (0.0014902834082022309)*bt_g0_17;
    bt_l1_5 = bt_l1_5 + (-2.2134361188363982e-06)*bt_g0_18;
    bt_l1_5 = bt_l1_5 + (5.4755167866460397e-07)*bt_g0_19;
    bt_l1_5 = bt_l1_5 + (5.6338768672503647e-07)*bt_g0_20;
    bt_l1_5 = bt_l1_5 + (-4.0161842207453446e-07)*bt_g0_21;
    bt_l1_5 = bt_l1_5 + (0.0015062777092680335)*bt_g0_22;
    bt_l1_5 = bt_l1_5 + (-9.6659583448399644e-08)*bt_g0_23;
    bt_l1_5 = bt_l1_5 + (-6.271149004533072e-07)*bt_g0_24;
    bt_l1_5 = bt_l1_5 + (-8.1023827647186408e-08)*bt_g0_25;
    bt_l1_5 = bt_l1_5 + (-7.719660288785235e-07)*bt_g0_26;
    bt_l1_5 = bt_l1_5 + (0.000533943937625736)*bt_g0_27;
    bt_l1_5 = bt_l1_5 + (4.0172812987293582e-07)*bt_g0_28;
    bt_l1_5 = bt_l1_5 + (-3.0904773211659631e-06)*bt_g0_29;
    bt_l1_5 = bt_l1_5 + (4.8898704108069069e-07)*bt_g0_30;
    bt_l1_5 = bt_l1_5 + (-1.505178914840144e-07)*bt_g0_31;
    bt_l1_5 = bt_l1_5 + (5.7894044402928557e-07)*bt_g0_32;
    bt_l1_5 = bt_l1_5 + (1.6688638879713835e-06)*bt_g0_33;
    bt_l1_5 = bt_l1_5 + (4.9144250624522101e-07)*bt_g0_34;
    bt_l1_5 = bt_l1_5 + (-4.4127503429081116e-07)*bt_g0_35;
    bt_l1_5 = bt_l1_5 + (-4.8526743512411485e-07)*bt_g0_36;
    bt_l1_5 = bt_l1_5 + (9.7579821556337265e-08)*bt_g0_37;
    bt_l1_5 = bt_l1_5 + (-5.6200951803475618e-07)*bt_g0_38;
    bt_l1_5 = bt_l1_5 + (-1.0825872323039221e-06)*bt_g0_39;
    bt_l1_5 = bt_l1_5 + (5.8718995887829806e-07)*bt_g0_40;
    bt_l1_5 = bt_l1_5 + (5.143967314324982e-07)*bt_g0_41;
    bt_l1_5 = bt_l1_5 + (6.062833222131303e-07)*bt_g0_42;
    bt_l1_5 = bt_l1_5 + (5.9926156836809241e-07)*bt_g0_43;
    bt_l1_5 = bt_l1_5 + (-2.1731382560119528e-07)*bt_g0_44;
    bt_l1_5 = bt_l1_5 + (-2.2656955422917235e-07)*bt_g0_45;
    bt_l1_5 = bt_l1_5 + (-5.3124654186831322e-07)*bt_g0_46;
    bt_l1_5 = bt_l1_5 + (-5.8438672567717731e-07)*bt_g0_47;
    bt_l1_5 = bt_l1_5 + (-5.8633111166273011e-07)*bt_g0_48;
    bt_l1_5 = bt_l1_5 + (3.2941352401394397e-07)*bt_g0_49;
    bt_l1_5 = bt_l1_5 + (3.8288890209514648e-06)*bt_g0_50;
    bt_l1_5 = bt_l1_5 + (5.7805783626463381e-07)*bt_g0_51;
    bt_l1_5 = bt_l1_5 + (2.5168907313855016e-07)*bt_g0_52;
    bt_l1_5 = bt_l1_5 + (1.2184131037429324e-07)*bt_g0_53;
    bt_l1_5 = bt_l1_5 + (3.1933996780253437e-08)*bt_g0_54;
    bt_l1_5 = bt_l1_5 + (3.5448863400233677e-07)*bt_g0_55;
    bt_l1_5 = bt_l1_5 + (-3.6429051419872849e-07)*bt_g0_56;
    bt_l1_5 = bt_l1_5 + (-5.361118837754475e-07)*bt_g0_57;
    bt_l1_5 = bt_l1_5 + (-0.0024408327881246805)*bt_g0_58;
    bt_l1_5 = bt_l1_5 + (-1.7394266649262136e-07)*bt_g0_59;
    bt_l1_5 = bt_l1_5 + (2.1694772840419319e-06)*bt_g0_60;
    bt_l1_5 = bt_l1_5 + (5.5550776778545696e-07)*bt_g0_61;
    bt_l1_5 = bt_l1_5 + (-3.9691414599474228e-07)*bt_g0_62;
    bt_l1_5 = bt_l1_5 + (0.0014182770391926169)*bt_g0_63;
    bt_l1_6 = 0.0070156073197722435;
    bt_l1_6 = bt_l1_6 + (4.1091902858170215e-07)*bt_g0_0;
    bt_l1_6 = bt_l1_6 + (8.3301654285605764e-07)*bt_g0_1;
    bt_l1_6 = bt_l1_6 + (-0.0024481804575771093)*bt_g0_2;
    bt_l1_6 = bt_l1_6 + (-6.1840673026836157e-08)*bt_g0_3;
    bt_l1_6 = bt_l1_6 + (-1.7735119683948142e-07)*bt_g0_4;
    bt_l1_6 = bt_l1_6 + (4.5252622271618748e-07)*bt_g0_5;
    bt_l1_6 = bt_l1_6 + (5.7209598480767454e-07)*bt_g0_6;
    bt_l1_6 = bt_l1_6 + (5.7345323511981405e-07)*bt_g0_7;
    bt_l1_6 = bt_l1_6 + (0.0060919756069779396)*bt_g0_8;
    bt_l1_6 = bt_l1_6 + (-5.6733875908321352e-07)*bt_g0_9;
    bt_l1_6 = bt_l1_6 + (-0.00032119167735800147)*bt_g0_10;
    bt_l1_6 = bt_l1_6 + (-1.0482664265509811e-06)*bt_g0_11;
    bt_l1_6 = bt_l1_6 + (3.5985016211270704e-07)*bt_g0_12;
    bt_l1_6 = bt_l1_6 + (-0.0028173569589853287)*bt_g0_13;
    bt_l1_6 = bt_l1_6 + (-4.3657942683239526e-07)*bt_g0_14;
    bt_l1_6 = bt_l1_6 + (-3.8004196767360554e-07)*bt_g0_15;
    bt_l1_6 = bt_l1_6 + (0.0009782667038962245)*bt_g0_16;
    bt_l1_6 = bt_l1_6 + (0.0014903220580890775)*bt_g0_17;
    bt_l1_6 = bt_l1_6 + (-2.2134361188363982e-06)*bt_g0_18;
    bt_l1_6 = bt_l1_6 + (5.4755287237640005e-07)*bt_g0_19;
    bt_l1_6 = bt_l1_6 + (5.6338740250794217e-07)*bt_g0_20;
    bt_l1_6 = bt_l1_6 + (-4.0161731362786668e-07)*bt_g0_21;
    bt_l1_6 = bt_l1_6 + (0.0015063011087477207)*bt_g0_22;
    bt_l1_6 = bt_l1_6 + (-9.6656222581259499e-08)*bt_g0_23;
    bt_l1_6 = bt_l1_6 + (-6.2711495729672606e-07)*bt_g0_24;
    bt_l1_6 = bt_l1_6 + (-8.1021575226714049e-08)*bt_g0_25;
    bt_l1_6 = bt_l1_6 + (-7.7195500125526451e-07)*bt_g0_26;
    bt_l1_6 = bt_l1_6 + (0.00053392775589600205)*bt_g0_27;
    bt_l1_6 = bt_l1_6 + (4.0173003412746766e-07)*bt_g0_28;
    bt_l1_6 = bt_l1_6 + (-3.0904423056199448e-06)*bt_g0_29;
    bt_l1_6 = bt_l1_6 + (4.8898601789915119e-07)*bt_g0_30;
    bt_l1_6 = bt_l1_6 + (-1.5051584512093541e-07)*bt_g0_31;
    bt_l1_6 = bt_l1_6 + (5.7893970506484038e-07)*bt_g0_32;
    bt_l1_6 = bt_l1_6 + (1.668846948632563e-06)*bt_g0_33;
    bt_l1_6 = bt_l1_6 + (4.9144199465445126e-07)*bt_g0_34;
    bt_l1_6 = bt_l1_6 + (-4.4127349951850192e-07)*bt_g0_35;
    bt_l1_6 = bt_l1_6 + (-4.8526737828069599e-07)*bt_g0_36;
    bt_l1_6 = bt_l1_6 + (9.7577981250651646e-08)*bt_g0_37;
    bt_l1_6 = bt_l1_6 + (-5.620090632874053e-07)*bt_g0_38;
    bt_l1_6 = bt_l1_6 + (-1.0825833669514395e-06)*bt_g0_39;
    bt_l1_6 = bt_l1_6 + (5.8719001572171692e-07)*bt_g0_40;
    bt_l1_6 = bt_l1_6 + (5.1439587878121529e-07)*bt_g0_41;
    bt_l1_6 = bt_l1_6 + (6.0628326536971144e-07)*bt_g0_42;
    bt_l1_6 = bt_l1_6 + (5.9926207995886216e-07)*bt_g0_43;
    bt_l1_6 = bt_l1_6 + (-2.1731204924435588e-07)*bt_g0_44;
    bt_l1_6 = bt_l1_6 + (-2.2657167164652492e-07)*bt_g0_45;
    bt_l1_6 = bt_l1_6 + (-5.3124580290386803e-07)*bt_g0_46;
    bt_l1_6 = bt_l1_6 + (-5.8438627092982642e-07)*bt_g0_47;
    bt_l1_6 = bt_l1_6 + (-5.8633094113247353e-07)*bt_g0_48;
    bt_l1_6 = bt_l1_6 + (3.2941215977189131e-07)*bt_g0_49;
    bt_l1_6 = bt_l1_6 + (3.828839908237569e-06)*bt_g0_50;
    bt_l1_6 = bt_l1_6 + (5.7805829101198469e-07)*bt_g0_51;
    bt_l1_6 = bt_l1_6 + (2.5169120476675744e-07)*bt_g0_52;
    bt_l1_6 = bt_l1_6 + (1.2184077036181407e-07)*bt_g0_53;
    bt_l1_6 = bt_l1_6 + (3.1931541855101386e-08)*bt_g0_54;
    bt_l1_6 = bt_l1_6 + (3.5448732660370297e-07)*bt_g0_55;
    bt_l1_6 = bt_l1_6 + (-3.6429096894607937e-07)*bt_g0_56;
    bt_l1_6 = bt_l1_6 + (-5.3612853889717371e-07)*bt_g0_57;
    bt_l1_6 = bt_l1_6 + (-0.0024407841265201569)*bt_g0_58;
    bt_l1_6 = bt_l1_6 + (-1.7394117435287626e-07)*bt_g0_59;
    bt_l1_6 = bt_l1_6 + (2.1694809220207389e-06)*bt_g0_60;
    bt_l1_6 = bt_l1_6 + (5.5550793831571355e-07)*bt_g0_61;
    bt_l1_6 = bt_l1_6 + (-3.969130375480745e-07)*bt_g0_62;
    bt_l1_6 = bt_l1_6 + (0.0014182844897732139)*bt_g0_63;
    bt_l1_7 = 0.0070156343281269073;
    bt_l1_7 = bt_l1_7 + (4.1091973912443791e-07)*bt_g0_0;
    bt_l1_7 = bt_l1_7 + (8.3300722053536447e-07)*bt_g0_1;
    bt_l1_7 = bt_l1_7 + (-0.0024482181761413813)*bt_g0_2;
    bt_l1_7 = bt_l1_7 + (-6.1838427711791155e-08)*bt_g0_3;
    bt_l1_7 = bt_l1_7 + (-1.7735628432546946e-07)*bt_g0_4;
    bt_l1_7 = bt_l1_7 + (4.5252753011482127e-07)*bt_g0_5;
    bt_l1_7 = bt_l1_7 + (5.7209678061553859e-07)*bt_g0_6;
    bt_l1_7 = bt_l1_7 + (5.7345391724084038e-07)*bt_g0_7;
    bt_l1_7 = bt_l1_7 + (0.0060920128598809242)*bt_g0_8;
    bt_l1_7 = bt_l1_7 + (-5.6733898645688896e-07)*bt_g0_9;
    bt_l1_7 = bt_l1_7 + (-0.00032118934905156493)*bt_g0_10;
    bt_l1_7 = bt_l1_7 + (-1.0482465313543798e-06)*bt_g0_11;
    bt_l1_7 = bt_l1_7 + (3.5985226531920489e-07)*bt_g0_12;
    bt_l1_7 = bt_l1_7 + (-0.0028174202889204025)*bt_g0_13;
    bt_l1_7 = bt_l1_7 + (-4.3657979631461785e-07)*bt_g0_14;
    bt_l1_7 = bt_l1_7 + (-3.8004344560249592e-07)*bt_g0_15;
    bt_l1_7 = bt_l1_7 + (0.00097831396851688623)*bt_g0_16;
    bt_l1_7 = bt_l1_7 + (0.0014902782859280705)*bt_g0_17;
    bt_l1_7 = bt_l1_7 + (-2.213430889241863e-06)*bt_g0_18;
    bt_l1_7 = bt_l1_7 + (5.4755156497776625e-07)*bt_g0_19;
    bt_l1_7 = bt_l1_7 + (5.6338802778554964e-07)*bt_g0_20;
    bt_l1_7 = bt_l1_7 + (-4.0161876313504763e-07)*bt_g0_21;
    bt_l1_7 = bt_l1_7 + (0.0015062849270179868)*bt_g0_22;
    bt_l1_7 = bt_l1_7 + (-9.6660208726007113e-08)*bt_g0_23;
    bt_l1_7 = bt_l1_7 + (-6.2711535520065809e-07)*bt_g0_24;
    bt_l1_7 = bt_l1_7 + (-8.1024026599152421e-08)*bt_g0_25;
    bt_l1_7 = bt_l1_7 + (-7.7196500569698401e-07)*bt_g0_26;
    bt_l1_7 = bt_l1_7 + (0.00053395959548652172)*bt_g0_27;
    bt_l1_7 = bt_l1_7 + (4.0172810145122639e-07)*bt_g0_28;
    bt_l1_7 = bt_l1_7 + (-3.0904761842975859e-06)*bt_g0_29;
    bt_l1_7 = bt_l1_7 + (4.8898743898462271e-07)*bt_g0_30;
    bt_l1_7 = bt_l1_7 + (-1.5051813306854456e-07)*bt_g0_31;
    bt_l1_7 = bt_l1_7 + (5.7894101246347418e-07)*bt_g0_32;
    bt_l1_7 = bt_l1_7 + (1.6688617279214668e-06)*bt_g0_33;
    bt_l1_7 = bt_l1_7 + (4.9144233571496443e-07)*bt_g0_34;
    bt_l1_7 = bt_l1_7 + (-4.4127537535132433e-07)*bt_g0_35;
    bt_l1_7 = bt_l1_7 + (-4.8526788987146574e-07)*bt_g0_36;
    bt_l1_7 = bt_l1_7 + (9.7580752367321111e-08)*bt_g0_37;
    bt_l1_7 = bt_l1_7 + (-5.6200968856501277e-07)*bt_g0_38;
    bt_l1_7 = bt_l1_7 + (-1.0825854133145185e-06)*bt_g0_39;
    bt_l1_7 = bt_l1_7 + (5.8719029993881122e-07)*bt_g0_40;
    bt_l1_7 = bt_l1_7 + (5.1439741355352453e-07)*bt_g0_41;
    bt_l1_7 = bt_l1_7 + (6.0628360643022461e-07)*bt_g0_42;
    bt_l1_7 = bt_l1_7 + (5.9926168205493013e-07)*bt_g0_43;
    bt_l1_7 = bt_l1_7 + (-2.1731418087256316e-07)*bt_g0_44;
    bt_l1_7 = bt_l1_7 + (-2.2656939790977049e-07)*bt_g0_45;
    bt_l1_7 = bt_l1_7 + (-5.3124693977224524e-07)*bt_g0_46;
    bt_l1_7 = bt_l1_7 + (-5.843871804245282e-07)*bt_g0_47;
    bt_l1_7 = bt_l1_7 + (-5.8633150956666213e-07)*bt_g0_48;
    bt_l1_7 = bt_l1_7 + (3.2941389349616657e-07)*bt_g0_49;
    bt_l1_7 = bt_l1_7 + (3.8288862924673595e-06)*bt_g0_50;
    bt_l1_7 = bt_l1_7 + (5.7805800679489039e-07)*bt_g0_51;
    bt_l1_7 = bt_l1_7 + (2.5168910156025959e-07)*bt_g0_52;
    bt_l1_7 = bt_l1_7 + (1.2184158038053283e-07)*bt_g0_53;
    bt_l1_7 = bt_l1_7 + (3.193425612835199e-08)*bt_g0_54;
    bt_l1_7 = bt_l1_7 + (3.5448906032797822e-07)*bt_g0_55;
    bt_l1_7 = bt_l1_7 + (-3.6428949101718899e-07)*bt_g0_56;
    bt_l1_7 = bt_l1_7 + (-5.361095531952742e-07)*bt_g0_57;
    bt_l1_7 = bt_l1_7 + (-0.0024408299941569567)*bt_g0_58;
    bt_l1_7 = bt_l1_7 + (-1.7394292228800623e-07)*bt_g0_59;
    bt_l1_7 = bt_l1_7 + (2.1694741008104756e-06)*bt_g0_60;
    bt_l1_7 = bt_l1_7 + (5.5550799515913241e-07)*bt_g0_61;
    bt_l1_7 = bt_l1_7 + (-3.9691431652499887e-07)*bt_g0_62;
    bt_l1_7 = bt_l1_7 + (0.0014182870509102941)*bt_g0_63;
    bt_l1_8 = 0.0070156040601432323;
    bt_l1_8 = bt_l1_8 + (4.1091877278631728e-07)*bt_g0_0;
    bt_l1_8 = bt_l1_8 + (8.3301625863896334e-07)*bt_g0_1;
    bt_l1_8 = bt_l1_8 + (-0.002448181388899684)*bt_g0_2;
    bt_l1_8 = bt_l1_8 + (-6.1840772502819163e-08)*bt_g0_3;
    bt_l1_8 = bt_l1_8 + (-1.7735160895426816e-07)*bt_g0_4;
    bt_l1_8 = bt_l1_8 + (4.5252602376422146e-07)*bt_g0_5;
    bt_l1_8 = bt_l1_8 + (5.7209598480767454e-07)*bt_g0_6;
    bt_l1_8 = bt_l1_8 + (5.7345272352904431e-07)*bt_g0_7;
    bt_l1_8 = bt_l1_8 + (0.0060919621028006077)*bt_g0_8;
    bt_l1_8 = bt_l1_8 + (-5.6733870223979466e-07)*bt_g0_9;
    bt_l1_8 = bt_l1_8 + (-0.00032119412207975984)*bt_g0_10;
    bt_l1_8 = bt_l1_8 + (-1.0482633570063626e-06)*bt_g0_11;
    bt_l1_8 = bt_l1_8 + (3.5984987789561274e-07)*bt_g0_12;
    bt_l1_8 = bt_l1_8 + (-0.0028173255268484354)*bt_g0_13;
    bt_l1_8 = bt_l1_8 + (-4.3657897208504437e-07)*bt_g0_14;
    bt_l1_8 = bt_l1_8 + (-3.8004168345651124e-07)*bt_g0_15;
    bt_l1_8 = bt_l1_8 + (0.00097826705314218998)*bt_g0_16;
    bt_l1_8 = bt_l1_8 + (0.0014903178671374917)*bt_g0_17;
    bt_l1_8 = bt_l1_8 + (-2.2134333903522929e-06)*bt_g0_18;
    bt_l1_8 = bt_l1_8 + (5.475523607856303e-07)*bt_g0_19;
    bt_l1_8 = bt_l1_8 + (5.6338711829084787e-07)*bt_g0_20;
    bt_l1_8 = bt_l1_8 + (-4.0161702941077237e-07)*bt_g0_21;
    bt_l1_8 = bt_l1_8 + (0.0015062879538163543)*bt_g0_22;
    bt_l1_8 = bt_l1_8 + (-9.6656933123995259e-08)*bt_g0_23;
    bt_l1_8 = bt_l1_8 + (-6.2711455939279404e-07)*bt_g0_24;
    bt_l1_8 = bt_l1_8 + (-8.1021433118166897e-08)*bt_g0_25;
    bt_l1_8 = bt_l1_8 + (-7.7195437597765704e-07)*bt_g0_26;
    bt_l1_8 = bt_l1_8 + (0.0005339193157851696)*bt_g0_27;
    bt_l1_8 = bt_l1_8 + (4.0172983517550165e-07)*bt_g0_28;
    bt_l1_8 = bt_l1_8 + (-3.0904363939043833e-06)*bt_g0_29;
    bt_l1_8 = bt_l1_8 + (4.8898579052547575e-07)*bt_g0_30;
    bt_l1_8 = bt_l1_8 + (-1.5051554669298639e-07)*bt_g0_31;
    bt_l1_8 = bt_l1_8 + (5.789395345345838e-07)*bt_g0_32;
    bt_l1_8 = bt_l1_8 + (1.66884410646162e-06)*bt_g0_33;
    bt_l1_8 = bt_l1_8 + (4.914413693768438e-07)*bt_g0_34;
    bt_l1_8 = bt_l1_8 + (-4.4127361320533964e-07)*bt_g0_35;
    bt_l1_8 = bt_l1_8 + (-4.8526715090702055e-07)*bt_g0_36;
    bt_l1_8 = bt_l1_8 + (9.7578435998002533e-08)*bt_g0_37;
    bt_l1_8 = bt_l1_8 + (-5.6200889275714871e-07)*bt_g0_38;
    bt_l1_8 = bt_l1_8 + (-1.0825808658410097e-06)*bt_g0_39;
    bt_l1_8 = bt_l1_8 + (5.8718978834804147e-07)*bt_g0_40;
    bt_l1_8 = bt_l1_8 + (5.1439576509437757e-07)*bt_g0_41;
    bt_l1_8 = bt_l1_8 + (6.0628326536971144e-07)*bt_g0_42;
    bt_l1_8 = bt_l1_8 + (5.9926185258518672e-07)*bt_g0_43;
    bt_l1_8 = bt_l1_8 + (-2.1731187871409929e-07)*bt_g0_44;
    bt_l1_8 = bt_l1_8 + (-2.2657188480934565e-07)*bt_g0_45;
    bt_l1_8 = bt_l1_8 + (-5.3124563237361144e-07)*bt_g0_46;
    bt_l1_8 = bt_l1_8 + (-5.8438610039956984e-07)*bt_g0_47;
    bt_l1_8 = bt_l1_8 + (-5.8633071375879808e-07)*bt_g0_48;
    bt_l1_8 = bt_l1_8 + (3.2941179028966872e-07)*bt_g0_49;
    bt_l1_8 = bt_l1_8 + (3.8288330870273057e-06)*bt_g0_50;
    bt_l1_8 = bt_l1_8 + (5.7805834785540355e-07)*bt_g0_51;
    bt_l1_8 = bt_l1_8 + (2.5169117634504801e-07)*bt_g0_52;
    bt_l1_8 = bt_l1_8 + (1.2184055719899334e-07)*bt_g0_53;
    bt_l1_8 = bt_l1_8 + (3.1931513433391956e-08)*bt_g0_54;
    bt_l1_8 = bt_l1_8 + (3.5448701396489923e-07)*bt_g0_55;
    bt_l1_8 = bt_l1_8 + (-3.6428963312573615e-07)*bt_g0_56;
    bt_l1_8 = bt_l1_8 + (-5.3612615147358156e-07)*bt_g0_57;
    bt_l1_8 = bt_l1_8 + (-0.0024407808668911457)*bt_g0_58;
    bt_l1_8 = bt_l1_8 + (-1.7394101803347439e-07)*bt_g0_59;
    bt_l1_8 = bt_l1_8 + (2.169476829294581e-06)*bt_g0_60;
    bt_l1_8 = bt_l1_8 + (5.5550736988152494e-07)*bt_g0_61;
    bt_l1_8 = bt_l1_8 + (-3.9691269648756133e-07)*bt_g0_62;
    bt_l1_8 = bt_l1_8 + (0.001418282394297421)*bt_g0_63;
    bt_l1_9 = 0.0070156059227883816;
    bt_l1_9 = bt_l1_9 + (4.1091979596785677e-07)*bt_g0_0;
    bt_l1_9 = bt_l1_9 + (8.3300847109057941e-07)*bt_g0_1;
    bt_l1_9 = bt_l1_9 + (-0.0024482181761413813)*bt_g0_2;
    bt_l1_9 = bt_l1_9 + (-6.1838882459142042e-08)*bt_g0_3;
    bt_l1_9 = bt_l1_9 + (-1.7735617063863174e-07)*bt_g0_4;
    bt_l1_9 = bt_l1_9 + (4.5252767222336843e-07)*bt_g0_5;
    bt_l1_9 = bt_l1_9 + (5.7209723536288948e-07)*bt_g0_6;
    bt_l1_9 = bt_l1_9 + (5.7345414461451583e-07)*bt_g0_7;
    bt_l1_9 = bt_l1_9 + (0.00609201705083251)*bt_g0_8;
    bt_l1_9 = bt_l1_9 + (-5.673392138305644e-07)*bt_g0_9;
    bt_l1_9 = bt_l1_9 + (-0.00032119202660396695)*bt_g0_10;
    bt_l1_9 = bt_l1_9 + (-1.0482492598384852e-06)*bt_g0_11;
    bt_l1_9 = bt_l1_9 + (3.5985232216262375e-07)*bt_g0_12;
    bt_l1_9 = bt_l1_9 + (-0.0028174035251140594)*bt_g0_13;
    bt_l1_9 = bt_l1_9 + (-4.3658013737513102e-07)*bt_g0_14;
    bt_l1_9 = bt_l1_9 + (-3.8004347402420535e-07)*bt_g0_15;
    bt_l1_9 = bt_l1_9 + (0.00097833783365786076)*bt_g0_16;
    bt_l1_9 = bt_l1_9 + (0.0014903004048392177)*bt_g0_17;
    bt_l1_9 = bt_l1_9 + (-2.213430889241863e-06)*bt_g0_18;
    bt_l1_9 = bt_l1_9 + (5.4755230394221144e-07)*bt_g0_19;
    bt_l1_9 = bt_l1_9 + (5.6338825515922508e-07)*bt_g0_20;
    bt_l1_9 = bt_l1_9 + (-4.0161887682188535e-07)*bt_g0_21;
    bt_l1_9 = bt_l1_9 + (0.0015062969177961349)*bt_g0_22;
    bt_l1_9 = bt_l1_9 + (-9.6660045301177888e-08)*bt_g0_23;
    bt_l1_9 = bt_l1_9 + (-6.2711580994800897e-07)*bt_g0_24;
    bt_l1_9 = bt_l1_9 + (-8.102376369834019e-08)*bt_g0_25;
    bt_l1_9 = bt_l1_9 + (-7.7196580150484806e-07)*bt_g0_26;
    bt_l1_9 = bt_l1_9 + (0.00053395930444821715)*bt_g0_27;
    bt_l1_9 = bt_l1_9 + (4.0172855619857728e-07)*bt_g0_28;
    bt_l1_9 = bt_l1_9 + (-3.0904745926818578e-06)*bt_g0_29;
    bt_l1_9 = bt_l1_9 + (4.8898732529778499e-07)*bt_g0_30;
    bt_l1_9 = bt_l1_9 + (-1.5051810464683513e-07)*bt_g0_31;
    bt_l1_9 = bt_l1_9 + (5.7894101246347418e-07)*bt_g0_32;
    bt_l1_9 = bt_l1_9 + (1.6688624100424931e-06)*bt_g0_33;
    bt_l1_9 = bt_l1_9 + (4.9144279046231532e-07)*bt_g0_34;
    bt_l1_9 = bt_l1_9 + (-4.4127548903816205e-07)*bt_g0_35;
    bt_l1_9 = bt_l1_9 + (-4.8526811724514118e-07)*bt_g0_36;
    bt_l1_9 = bt_l1_9 + (9.7580866054158832e-08)*bt_g0_37;
    bt_l1_9 = bt_l1_9 + (-5.6200991593868821e-07)*bt_g0_38;
    bt_l1_9 = bt_l1_9 + (-1.0825862091223826e-06)*bt_g0_39;
    bt_l1_9 = bt_l1_9 + (5.8719069784274325e-07)*bt_g0_40;
    bt_l1_9 = bt_l1_9 + (5.1439758408378111e-07)*bt_g0_41;
    bt_l1_9 = bt_l1_9 + (6.0628394749073777e-07)*bt_g0_42;
    bt_l1_9 = bt_l1_9 + (5.9926225048911874e-07)*bt_g0_43;
    bt_l1_9 = bt_l1_9 + (-2.1731392507717828e-07)*bt_g0_44;
    bt_l1_9 = bt_l1_9 + (-2.2656983844626666e-07)*bt_g0_45;
    bt_l1_9 = bt_l1_9 + (-5.3124733767617727e-07)*bt_g0_46;
    bt_l1_9 = bt_l1_9 + (-5.8438752148504136e-07)*bt_g0_47;
    bt_l1_9 = bt_l1_9 + (-5.8633162325349986e-07)*bt_g0_48;
    bt_l1_9 = bt_l1_9 + (3.2941414929155144e-07)*bt_g0_49;
    bt_l1_9 = bt_l1_9 + (3.8288858377200086e-06)*bt_g0_50;
    bt_l1_9 = bt_l1_9 + (5.7805812048172811e-07)*bt_g0_51;
    bt_l1_9 = bt_l1_9 + (2.516896699944482e-07)*bt_g0_52;
    bt_l1_9 = bt_l1_9 + (1.2184170827822527e-07)*bt_g0_53;
    bt_l1_9 = bt_l1_9 + (3.1933982569398722e-08)*bt_g0_54;
    bt_l1_9 = bt_l1_9 + (3.5448911717139708e-07)*bt_g0_55;
    bt_l1_9 = bt_l1_9 + (-3.6428923522180412e-07)*bt_g0_56;
    bt_l1_9 = bt_l1_9 + (-5.3610995109920623e-07)*bt_g0_57;
    bt_l1_9 = bt_l1_9 + (-0.0024408155586570501)*bt_g0_58;
    bt_l1_9 = bt_l1_9 + (-1.7394276596860436e-07)*bt_g0_59;
    bt_l1_9 = bt_l1_9 + (2.1694745555578265e-06)*bt_g0_60;
    bt_l1_9 = bt_l1_9 + (5.5550839306306443e-07)*bt_g0_61;
    bt_l1_9 = bt_l1_9 + (-3.9691457232038374e-07)*bt_g0_62;
    bt_l1_9 = bt_l1_9 + (0.0014182927552610636)*bt_g0_63;
    bt_l1_10 = -0.0064570754766464233;
    bt_l1_10 = bt_l1_10 + (5.7200086303055286e-06)*bt_g0_0;
    bt_l1_10 = bt_l1_10 + (1.3319606296136044e-05)*bt_g0_1;
    bt_l1_10 = bt_l1_10 + (-0.054831381887197495)*bt_g0_2;
    bt_l1_10 = bt_l1_10 + (-4.1106504795607179e-06)*bt_g0_3;
    bt_l1_10 = bt_l1_10 + (3.9857663978182245e-06)*bt_g0_4;
    bt_l1_10 = bt_l1_10 + (4.9595068958296906e-06)*bt_g0_5;
    bt_l1_10 = bt_l1_10 + (7.4326467256469186e-06)*bt_g0_6;
    bt_l1_10 = bt_l1_10 + (7.3911733124987222e-06)*bt_g0_7;
    bt_l1_10 = bt_l1_10 + (0.10571293532848358)*bt_g0_8;
    bt_l1_10 = bt_l1_10 + (-8.3648210420506075e-06)*bt_g0_9;
    bt_l1_10 = bt_l1_10 + (0.033079866319894791)*bt_g0_10;
    bt_l1_10 = bt_l1_10 + (-4.4126725697424263e-05)*bt_g0_11;
    bt_l1_10 = bt_l1_10 + (2.3209388473333092e-06)*bt_g0_12;
    bt_l1_10 = bt_l1_10 + (-0.008339771069586277)*bt_g0_13;
    bt_l1_10 = bt_l1_10 + (-6.207878868735861e-06)*bt_g0_14;
    bt_l1_10 = bt_l1_10 + (-3.67023153557966e-06)*bt_g0_15;
    bt_l1_10 = bt_l1_10 + (0.11821933090686798)*bt_g0_16;
    bt_l1_10 = bt_l1_10 + (0.069024980068206787)*bt_g0_17;
    bt_l1_10 = bt_l1_10 + (-2.8768932679668069e-05)*bt_g0_18;
    bt_l1_10 = bt_l1_10 + (9.2982672867947258e-06)*bt_g0_19;
    bt_l1_10 = bt_l1_10 + (7.5985021794622298e-06)*bt_g0_20;
    bt_l1_10 = bt_l1_10 + (-4.2578622014843859e-06)*bt_g0_21;
    bt_l1_10 = bt_l1_10 + (-0.080968976020812988)*bt_g0_22;
    bt_l1_10 = bt_l1_10 + (3.1290239803638542e-06)*bt_g0_23;
    bt_l1_10 = bt_l1_10 + (-8.3321119745960459e-06)*bt_g0_24;
    bt_l1_10 = bt_l1_10 + (2.1153316538402578e-06)*bt_g0_25;
    bt_l1_10 = bt_l1_10 + (4.9617647164268419e-06)*bt_g0_26;
    bt_l1_10 = bt_l1_10 + (-0.16222809255123138)*bt_g0_27;
    bt_l1_10 = bt_l1_10 + (8.591944606450852e-06)*bt_g0_28;
    bt_l1_10 = bt_l1_10 + (-7.1052454586606473e-07)*bt_g0_29;
    bt_l1_10 = bt_l1_10 + (5.81951917411061e-06)*bt_g0_30;
    bt_l1_10 = bt_l1_10 + (8.1904937587751192e-07)*bt_g0_31;
    bt_l1_10 = bt_l1_10 + (6.8227891460992396e-06)*bt_g0_32;
    bt_l1_10 = bt_l1_10 + (9.2139987373229815e-07)*bt_g0_33;
    bt_l1_10 = bt_l1_10 + (6.0791649048042018e-06)*bt_g0_34;
    bt_l1_10 = bt_l1_10 + (-4.6105974433885422e-06)*bt_g0_35;
    bt_l1_10 = bt_l1_10 + (-6.9239204094628803e-06)*bt_g0_36;
    bt_l1_10 = bt_l1_10 + (-6.5810985461212113e-07)*bt_g0_37;
    bt_l1_10 = bt_l1_10 + (-7.2856178121583071e-06)*bt_g0_38;
    bt_l1_10 = bt_l1_10 + (-9.1454603534657508e-06)*bt_g0_39;
    bt_l1_10 = bt_l1_10 + (8.2403030319255777e-06)*bt_g0_40;
    bt_l1_10 = bt_l1_10 + (6.1277155509742443e-06)*bt_g0_41;
    bt_l1_10 = bt_l1_10 + (8.5770525402040221e-06)*bt_g0_42;
    bt_l1_10 = bt_l1_10 + (8.4459552454063669e-06)*bt_g0_43;
    bt_l1_10 = bt_l1_10 + (-3.351846373789158e-07)*bt_g0_44;
    bt_l1_10 = bt_l1_10 + (-6.6047750806319527e-06)*bt_g0_45;
    bt_l1_10 = bt_l1_10 + (-6.3121692619461101e-06)*bt_g0_46;
    bt_l1_10 = bt_l1_10 + (-7.7093800427974202e-06)*bt_g0_47;
    bt_l1_10 = bt_l1_10 + (-7.9863548307912424e-06)*bt_g0_48;
    bt_l1_10 = bt_l1_10 + (2.9283701223903336e-06)*bt_g0_49;
    bt_l1_10 = bt_l1_10 + (-4.6296381128740904e-07)*bt_g0_50;
    bt_l1_10 = bt_l1_10 + (8.6026975623099133e-06)*bt_g0_51;
    bt_l1_10 = bt_l1_10 + (6.8263229877629783e-06)*bt_g0_52;
    bt_l1_10 = bt_l1_10 + (7.1037788984540384e-07)*bt_g0_53;
    bt_l1_10 = bt_l1_10 + (-2.8991544240852818e-06)*bt_g0_54;
    bt_l1_10 = bt_l1_10 + (2.9819157134625129e-06)*bt_g0_55;
    bt_l1_10 = bt_l1_10 + (-4.8861234063224401e-06)*bt_g0_56;
    bt_l1_10 = bt_l1_10 + (-3.1604533432982862e-05)*bt_g0_57;
    bt_l1_10 = bt_l1_10 + (0.049111079424619675)*bt_g0_58;
    bt_l1_10 = bt_l1_10 + (-6.0241916344239144e-08)*bt_g0_59;
    bt_l1_10 = bt_l1_10 + (2.9595263185910881e-05)*bt_g0_60;
    bt_l1_10 = bt_l1_10 + (7.6680662459693849e-06)*bt_g0_61;
    bt_l1_10 = bt_l1_10 + (-4.123571216041455e-06)*bt_g0_62;
    bt_l1_10 = bt_l1_10 + (0.032155998051166534)*bt_g0_63;
    bt_l1_11 = 0.0070156385190784931;
    bt_l1_11 = bt_l1_11 + (4.1091934122050588e-07)*bt_g0_0;
    bt_l1_11 = bt_l1_11 + (8.3301000586288865e-07)*bt_g0_1;
    bt_l1_11 = bt_l1_11 + (-0.0024482200387865305)*bt_g0_2;
    bt_l1_11 = bt_l1_11 + (-6.183909562196277e-08)*bt_g0_3;
    bt_l1_11 = bt_l1_11 + (-1.7735527535478468e-07)*bt_g0_4;
    bt_l1_11 = bt_l1_11 + (4.525269901023421e-07)*bt_g0_5;
    bt_l1_11 = bt_l1_11 + (5.7209643955502543e-07)*bt_g0_6;
    bt_l1_11 = bt_l1_11 + (5.7345340565007064e-07)*bt_g0_7;
    bt_l1_11 = bt_l1_11 + (0.0060920063406229019)*bt_g0_8;
    bt_l1_11 = bt_l1_11 + (-5.6733853170953807e-07)*bt_g0_9;
    bt_l1_11 = bt_l1_11 + (-0.00032119418028742075)*bt_g0_10;
    bt_l1_11 = bt_l1_11 + (-1.048251760948915e-06)*bt_g0_11;
    bt_l1_11 = bt_l1_11 + (3.5985149793305027e-07)*bt_g0_12;
    bt_l1_11 = bt_l1_11 + (-0.0028173895552754402)*bt_g0_13;
    bt_l1_11 = bt_l1_11 + (-4.3657945525410469e-07)*bt_g0_14;
    bt_l1_11 = bt_l1_11 + (-3.8004270663805073e-07)*bt_g0_15;
    bt_l1_11 = bt_l1_11 + (0.00097829184960573912)*bt_g0_16;
    bt_l1_11 = bt_l1_11 + (0.0014902718830853701)*bt_g0_17;
    bt_l1_11 = bt_l1_11 + (-2.2134324808575911e-06)*bt_g0_18;
    bt_l1_11 = bt_l1_11 + (5.4755179235144169e-07)*bt_g0_19;
    bt_l1_11 = bt_l1_11 + (5.6338762988161761e-07)*bt_g0_20;
    bt_l1_11 = bt_l1_11 + (-4.0161793890547415e-07)*bt_g0_21;
    bt_l1_11 = bt_l1_11 + (0.001506275380961597)*bt_g0_22;
    bt_l1_11 = bt_l1_11 + (-9.6659277915023267e-08)*bt_g0_23;
    bt_l1_11 = bt_l1_11 + (-6.2711478676646948e-07)*bt_g0_24;
    bt_l1_11 = bt_l1_11 + (-8.1023287634707231e-08)*bt_g0_25;
    bt_l1_11 = bt_l1_11 + (-7.7196352776809363e-07)*bt_g0_26;
    bt_l1_11 = bt_l1_11 + (0.00053393008420243859)*bt_g0_27;
    bt_l1_11 = bt_l1_11 + (4.0172841409003013e-07)*bt_g0_28;
    bt_l1_11 = bt_l1_11 + (-3.0904673167242436e-06)*bt_g0_29;
    bt_l1_11 = bt_l1_11 + (4.8898681370701524e-07)*bt_g0_30;
    bt_l1_11 = bt_l1_11 + (-1.5051745094751823e-07)*bt_g0_31;
    bt_l1_11 = bt_l1_11 + (5.7894021665561013e-07)*bt_g0_32;
    bt_l1_11 = bt_l1_11 + (1.6688577488821466e-06)*bt_g0_33;
    bt_l1_11 = bt_l1_11 + (4.9144216518470785e-07)*bt_g0_34;
    bt_l1_11 = bt_l1_11 + (-4.4127457954346028e-07)*bt_g0_35;
    bt_l1_11 = bt_l1_11 + (-4.8526754881095258e-07)*bt_g0_36;
    bt_l1_11 = bt_l1_11 + (9.7580006297448563e-08)*bt_g0_37;
    bt_l1_11 = bt_l1_11 + (-5.6200940434791846e-07)*bt_g0_38;
    bt_l1_11 = bt_l1_11 + (-1.0825848448803299e-06)*bt_g0_39;
    bt_l1_11 = bt_l1_11 + (5.8718995887829806e-07)*bt_g0_40;
    bt_l1_11 = bt_l1_11 + (5.1439661774566048e-07)*bt_g0_41;
    bt_l1_11 = bt_l1_11 + (6.0628326536971144e-07)*bt_g0_42;
    bt_l1_11 = bt_l1_11 + (5.9926151152467355e-07)*bt_g0_43;
    bt_l1_11 = bt_l1_11 + (-2.1731341348640854e-07)*bt_g0_44;
    bt_l1_11 = bt_l1_11 + (-2.2656995213310438e-07)*bt_g0_45;
    bt_l1_11 = bt_l1_11 + (-5.3124625765121891e-07)*bt_g0_46;
    bt_l1_11 = bt_l1_11 + (-5.8438672567717731e-07)*bt_g0_47;
    bt_l1_11 = bt_l1_11 + (-5.8633105481931125e-07)*bt_g0_48;
    bt_l1_11 = bt_l1_11 + (3.2941332506197796e-07)*bt_g0_49;
    bt_l1_11 = bt_l1_11 + (3.8288785617623944e-06)*bt_g0_50;
    bt_l1_11 = bt_l1_11 + (5.7805789310805267e-07)*bt_g0_51;
    bt_l1_11 = bt_l1_11 + (2.5168949946419161e-07)*bt_g0_52;
    bt_l1_11 = bt_l1_11 + (1.2184123932001967e-07)*bt_g0_53;
    bt_l1_11 = bt_l1_11 + (3.1933474531342654e-08)*bt_g0_54;
    bt_l1_11 = bt_l1_11 + (3.544882929418236e-07)*bt_g0_55;
    bt_l1_11 = bt_l1_11 + (-3.6428980365599273e-07)*bt_g0_56;
    bt_l1_11 = bt_l1_11 + (-5.3611370276485104e-07)*bt_g0_57;
    bt_l1_11 = bt_l1_11 + (-0.0024408355820924044)*bt_g0_58;
    bt_l1_11 = bt_l1_11 + (-1.7394233964296291e-07)*bt_g0_59;
    bt_l1_11 = bt_l1_11 + (2.1694752376788529e-06)*bt_g0_60;
    bt_l1_11 = bt_l1_11 + (5.5550759725520038e-07)*bt_g0_61;
    bt_l1_11 = bt_l1_11 + (-3.9691391862106684e-07)*bt_g0_62;
    bt_l1_11 = bt_l1_11 + (0.0014182775048539042)*bt_g0_63;
    bt_l1_12 = 0.0070156250149011612;
    bt_l1_12 = bt_l1_12 + (4.1091871594289842e-07)*bt_g0_0;
    bt_l1_12 = bt_l1_12 + (8.3302649045435828e-07)*bt_g0_1;
    bt_l1_12 = bt_l1_12 + (-0.0024481650907546282)*bt_g0_2;
    bt_l1_12 = bt_l1_12 + (-6.1843337562095257e-08)*bt_g0_3;
    bt_l1_12 = bt_l1_12 + (-1.7734537038904818e-07)*bt_g0_4;
    bt_l1_12 = bt_l1_12 + (4.525247447872971e-07)*bt_g0_5;
    bt_l1_12 = bt_l1_12 + (5.7209547321690479e-07)*bt_g0_6;
    bt_l1_12 = bt_l1_12 + (5.7345226878169342e-07)*bt_g0_7;
    bt_l1_12 = bt_l1_12 + (0.0060919439420104027)*bt_g0_8;
    bt_l1_12 = bt_l1_12 + (-5.6733910014372668e-07)*bt_g0_9;
    bt_l1_12 = bt_l1_12 + (-0.00032119476236402988)*bt_g0_10;
    bt_l1_12 = bt_l1_12 + (-1.0482855259397184e-06)*bt_g0_11;
    bt_l1_12 = bt_l1_12 + (3.5984777468911489e-07)*bt_g0_12;
    bt_l1_12 = bt_l1_12 + (-0.0028173425234854221)*bt_g0_13;
    bt_l1_12 = bt_l1_12 + (-4.3657891524162551e-07)*bt_g0_14;
    bt_l1_12 = bt_l1_12 + (-3.8004020552762086e-07)*bt_g0_15;
    bt_l1_12 = bt_l1_12 + (0.00097814307082444429)*bt_g0_16;
    bt_l1_12 = bt_l1_12 + (0.001490327762439847)*bt_g0_17;
    bt_l1_12 = bt_l1_12 + (-2.2134381651994772e-06)*bt_g0_18;
    bt_l1_12 = bt_l1_12 + (5.4755435030529043e-07)*bt_g0_19;
    bt_l1_12 = bt_l1_12 + (5.6338689091717242e-07)*bt_g0_20;
    bt_l1_12 = bt_l1_12 + (-4.0161614833778003e-07)*bt_g0_21;
    bt_l1_12 = bt_l1_12 + (0.0015062934253364801)*bt_g0_22;
    bt_l1_12 = bt_l1_12 + (-9.6652414072195825e-08)*bt_g0_23;
    bt_l1_12 = bt_l1_12 + (-6.271146162362129e-07)*bt_g0_24;
    bt_l1_12 = bt_l1_12 + (-8.101849147124085e-08)*bt_g0_25;
    bt_l1_12 = bt_l1_12 + (-7.7193863035063259e-07)*bt_g0_26;
    bt_l1_12 = bt_l1_12 + (0.0005338981281965971)*bt_g0_27;
    bt_l1_12 = bt_l1_12 + (4.0173233628593152e-07)*bt_g0_28;
    bt_l1_12 = bt_l1_12 + (-3.0903913739166455e-06)*bt_g0_29;
    bt_l1_12 = bt_l1_12 + (4.889849947176117e-07)*bt_g0_30;
    bt_l1_12 = bt_l1_12 + (-1.5051335822136025e-07)*bt_g0_31;
    bt_l1_12 = bt_l1_12 + (5.7893907978723291e-07)*bt_g0_32;
    bt_l1_12 = bt_l1_12 + (1.6688195501046721e-06)*bt_g0_33;
    bt_l1_12 = bt_l1_12 + (4.9144080094265519e-07)*bt_g0_34;
    bt_l1_12 = bt_l1_12 + (-4.4127230580670584e-07)*bt_g0_35;
    bt_l1_12 = bt_l1_12 + (-4.8526698037676397e-07)*bt_g0_36;
    bt_l1_12 = bt_l1_12 + (9.7575167501418036e-08)*bt_g0_37;
    bt_l1_12 = bt_l1_12 + (-5.6200860854005441e-07)*bt_g0_38;
    bt_l1_12 = bt_l1_12 + (-1.0825775689227157e-06)*bt_g0_39;
    bt_l1_12 = bt_l1_12 + (5.8719024309539236e-07)*bt_g0_40;
    bt_l1_12 = bt_l1_12 + (5.1439496928651351e-07)*bt_g0_41;
    bt_l1_12 = bt_l1_12 + (6.0628349274338689e-07)*bt_g0_42;
    bt_l1_12 = bt_l1_12 + (5.9926219364569988e-07)*bt_g0_43;
    bt_l1_12 = bt_l1_12 + (-2.1730969024247315e-07)*bt_g0_44;
    bt_l1_12 = bt_l1_12 + (-2.2657469855857926e-07)*bt_g0_45;
    bt_l1_12 = bt_l1_12 + (-5.3124495025258511e-07)*bt_g0_46;
    bt_l1_12 = bt_l1_12 + (-5.8438604355615098e-07)*bt_g0_47;
    bt_l1_12 = bt_l1_12 + (-5.8633094113247353e-07)*bt_g0_48;
    bt_l1_12 = bt_l1_12 + (3.2941022709565004e-07)*bt_g0_49;
    bt_l1_12 = bt_l1_12 + (3.8287730603769887e-06)*bt_g0_50;
    bt_l1_12 = bt_l1_12 + (5.7805954156719963e-07)*bt_g0_51;
    bt_l1_12 = bt_l1_12 + (2.5169381956402503e-07)*bt_g0_52;
    bt_l1_12 = bt_l1_12 + (1.2184007402993302e-07)*bt_g0_53;
    bt_l1_12 = bt_l1_12 + (3.1928696131444667e-08)*bt_g0_54;
    bt_l1_12 = bt_l1_12 + (3.5448550761429942e-07)*bt_g0_55;
    bt_l1_12 = bt_l1_12 + (-3.6429159422368684e-07)*bt_g0_56;
    bt_l1_12 = bt_l1_12 + (-5.3615099204762373e-07)*bt_g0_57;
    bt_l1_12 = bt_l1_12 + (-0.0024407566525042057)*bt_g0_58;
    bt_l1_12 = bt_l1_12 + (-1.7393927009834442e-07)*bt_g0_59;
    bt_l1_12 = bt_l1_12 + (2.1694838778785197e-06)*bt_g0_60;
    bt_l1_12 = bt_l1_12 + (5.5550759725520038e-07)*bt_g0_61;
    bt_l1_12 = bt_l1_12 + (-3.9691167330602184e-07)*bt_g0_62;
    bt_l1_12 = bt_l1_12 + (0.0014182906597852707)*bt_g0_63;
    bt_l1_13 = 0.0070156506262719631;
    bt_l1_13 = bt_l1_13 + (4.1091831803896639e-07)*bt_g0_0;
    bt_l1_13 = bt_l1_13 + (8.3301915765332524e-07)*bt_g0_1;
    bt_l1_13 = bt_l1_13 + (-0.0024481785949319601)*bt_g0_2;
    bt_l1_13 = bt_l1_13 + (-6.1841106457904971e-08)*bt_g0_3;
    bt_l1_13 = bt_l1_13 + (-1.7735013102537778e-07)*bt_g0_4;
    bt_l1_13 = bt_l1_13 + (4.5252551217345172e-07)*bt_g0_5;
    bt_l1_13 = bt_l1_13 + (5.7209541637348593e-07)*bt_g0_6;
    bt_l1_13 = bt_l1_13 + (5.7345232562511228e-07)*bt_g0_7;
    bt_l1_13 = bt_l1_13 + (0.0060919527895748615)*bt_g0_8;
    bt_l1_13 = bt_l1_13 + (-5.6733853170953807e-07)*bt_g0_9;
    bt_l1_13 = bt_l1_13 + (-0.00032119094976224005)*bt_g0_10;
    bt_l1_13 = bt_l1_13 + (-1.0482694960955996e-06)*bt_g0_11;
    bt_l1_13 = bt_l1_13 + (3.5984930946142413e-07)*bt_g0_12;
    bt_l1_13 = bt_l1_13 + (-0.0028173604514449835)*bt_g0_13;
    bt_l1_13 = bt_l1_13 + (-4.3657863102453121e-07)*bt_g0_14;
    bt_l1_13 = bt_l1_13 + (-3.8004128555257921e-07)*bt_g0_15;
    bt_l1_13 = bt_l1_13 + (0.0009781958069652319)*bt_g0_16;
    bt_l1_13 = bt_l1_13 + (0.0014902908587828279)*bt_g0_17;
    bt_l1_13 = bt_l1_13 + (-2.2134340724733192e-06)*bt_g0_18;
    bt_l1_13 = bt_l1_13 + (5.4755207656853599e-07)*bt_g0_19;
    bt_l1_13 = bt_l1_13 + (5.6338683407375356e-07)*bt_g0_20;
    bt_l1_13 = bt_l1_13 + (-4.0161671677196864e-07)*bt_g0_21;
    bt_l1_13 = bt_l1_13 + (0.0015062891179695725)*bt_g0_22;
    bt_l1_13 = bt_l1_13 + (-9.665610178899442e-08)*bt_g0_23;
    bt_l1_13 = bt_l1_13 + (-6.2711410464544315e-07)*bt_g0_24;
    bt_l1_13 = bt_l1_13 + (-8.1020999687098083e-08)*bt_g0_25;
    bt_l1_13 = bt_l1_13 + (-7.7195085168568767e-07)*bt_g0_26;
    bt_l1_13 = bt_l1_13 + (0.00053391163237392902)*bt_g0_27;
    bt_l1_13 = bt_l1_13 + (4.0172980675379222e-07)*bt_g0_28;
    bt_l1_13 = bt_l1_13 + (-3.0904252525942866e-06)*bt_g0_29;
    bt_l1_13 = bt_l1_13 + (4.8898533577812486e-07)*bt_g0_30;
    bt_l1_13 = bt_l1_13 + (-1.5051539037358452e-07)*bt_g0_31;
    bt_l1_13 = bt_l1_13 + (5.7893913663065177e-07)*bt_g0_32;
    bt_l1_13 = bt_l1_13 + (1.6688366031303303e-06)*bt_g0_33;
    bt_l1_13 = bt_l1_13 + (4.914406304123986e-07)*bt_g0_34;
    bt_l1_13 = bt_l1_13 + (-4.4127304477115104e-07)*bt_g0_35;
    bt_l1_13 = bt_l1_13 + (-4.8526669615966966e-07)*bt_g0_36;
    bt_l1_13 = bt_l1_13 + (9.757702201795837e-08)*bt_g0_37;
    bt_l1_13 = bt_l1_13 + (-5.6200838116637897e-07)*bt_g0_38;
    bt_l1_13 = bt_l1_13 + (-1.0825806384673342e-06)*bt_g0_39;
    bt_l1_13 = bt_l1_13 + (5.8718950413094717e-07)*bt_g0_40;
    bt_l1_13 = bt_l1_13 + (5.1439531034702668e-07)*bt_g0_41;
    bt_l1_13 = bt_l1_13 + (6.0628281062236056e-07)*bt_g0_42;
    bt_l1_13 = bt_l1_13 + (5.9926128415099811e-07)*bt_g0_43;
    bt_l1_13 = bt_l1_13 + (-2.1731115396050882e-07)*bt_g0_44;
    bt_l1_13 = bt_l1_13 + (-2.2657205533960223e-07)*bt_g0_45;
    bt_l1_13 = bt_l1_13 + (-5.312451207828417e-07)*bt_g0_46;
    bt_l1_13 = bt_l1_13 + (-5.8438564565221895e-07)*bt_g0_47;
    bt_l1_13 = bt_l1_13 + (-5.8633042954170378e-07)*bt_g0_48;
    bt_l1_13 = bt_l1_13 + (3.2941085237325751e-07)*bt_g0_49;
    bt_l1_13 = bt_l1_13 + (3.8288180803647265e-06)*bt_g0_50;
    bt_l1_13 = bt_l1_13 + (5.7805834785540355e-07)*bt_g0_51;
    bt_l1_13 = bt_l1_13 + (2.5169129003188573e-07)*bt_g0_52;
    bt_l1_13 = bt_l1_13 + (1.2184028719275375e-07)*bt_g0_53;
    bt_l1_13 = bt_l1_13 + (3.1931051580613712e-08)*bt_g0_54;
    bt_l1_13 = bt_l1_13 + (3.5448653079583892e-07)*bt_g0_55;
    bt_l1_13 = bt_l1_13 + (-3.6429048577701906e-07)*bt_g0_56;
    bt_l1_13 = bt_l1_13 + (-5.3613274531016941e-07)*bt_g0_57;
    bt_l1_13 = bt_l1_13 + (-0.0024407906457781792)*bt_g0_58;
    bt_l1_13 = bt_l1_13 + (-1.739407480272348e-07)*bt_g0_59;
    bt_l1_13 = bt_l1_13 + (2.1694786482839845e-06)*bt_g0_60;
    bt_l1_13 = bt_l1_13 + (5.5550702882101177e-07)*bt_g0_61;
    bt_l1_13 = bt_l1_13 + (-3.9691229858362931e-07)*bt_g0_62;
    bt_l1_13 = bt_l1_13 + (0.0014182836748659611)*bt_g0_63;
    bt_l1_14 = 0.0070156175643205643;
    bt_l1_14 = bt_l1_14 + (4.1091965385930962e-07)*bt_g0_0;
    bt_l1_14 = bt_l1_14 + (8.3300886899451143e-07)*bt_g0_1;
    bt_l1_14 = bt_l1_14 + (-0.0024482081644237041)*bt_g0_2;
    bt_l1_14 = bt_l1_14 + (-6.183909562196277e-08)*bt_g0_3;
    bt_l1_14 = bt_l1_14 + (-1.7735553115016955e-07)*bt_g0_4;
    bt_l1_14 = bt_l1_14 + (4.5252730274114583e-07)*bt_g0_5;
    bt_l1_14 = bt_l1_14 + (5.7209700798921403e-07)*bt_g0_6;
    bt_l1_14 = bt_l1_14 + (5.7345391724084038e-07)*bt_g0_7;
    bt_l1_14 = bt_l1_14 + (0.0060920016840100288)*bt_g0_8;
    bt_l1_14 = bt_l1_14 + (-5.673392138305644e-07)*bt_g0_9;
    bt_l1_14 = bt_l1_14 + (-0.00032119202660396695)*bt_g0_10;
    bt_l1_14 = bt_l1_14 + (-1.0482491461516474e-06)*bt_g0_11;
    bt_l1_14 = bt_l1_14 + (3.5985209478894831e-07)*bt_g0_12;
    bt_l1_14 = bt_l1_14 + (-0.0028174114413559437)*bt_g0_13;
    bt_l1_14 = bt_l1_14 + (-4.3657999526658386e-07)*bt_g0_14;
    bt_l1_14 = bt_l1_14 + (-3.8004321822882048e-07)*bt_g0_15;
    bt_l1_14 = bt_l1_14 + (0.00097830791492015123)*bt_g0_16;
    bt_l1_14 = bt_l1_14 + (0.0014902963303029537)*bt_g0_17;
    bt_l1_14 = bt_l1_14 + (-2.2134313439892139e-06)*bt_g0_18;
    bt_l1_14 = bt_l1_14 + (5.4755224709879258e-07)*bt_g0_19;
    bt_l1_14 = bt_l1_14 + (5.6338831200264394e-07)*bt_g0_20;
    bt_l1_14 = bt_l1_14 + (-4.0161862102650048e-07)*bt_g0_21;
    bt_l1_14 = bt_l1_14 + (0.0015062872553244233)*bt_g0_22;
    bt_l1_14 = bt_l1_14 + (-9.6659206860749691e-08)*bt_g0_23;
    bt_l1_14 = bt_l1_14 + (-6.2711580994800897e-07)*bt_g0_24;
    bt_l1_14 = bt_l1_14 + (-8.1023486586673243e-08)*bt_g0_25;
    bt_l1_14 = bt_l1_14 + (-7.719631298641616e-07)*bt_g0_26;
    bt_l1_14 = bt_l1_14 + (0.00053395668510347605)*bt_g0_27;
    bt_l1_14 = bt_l1_14 + (4.0172872672883386e-07)*bt_g0_28;
    bt_l1_14 = bt_l1_14 + (-3.0904664072295418e-06)*bt_g0_29;
    bt_l1_14 = bt_l1_14 + (4.8898732529778499e-07)*bt_g0_30;
    bt_l1_14 = bt_l1_14 + (-1.5051776358632196e-07)*bt_g0_31;
    bt_l1_14 = bt_l1_14 + (5.7894067140296102e-07)*bt_g0_32;
    bt_l1_14 = bt_l1_14 + (1.6688592268110369e-06)*bt_g0_33;
    bt_l1_14 = bt_l1_14 + (4.9144250624522101e-07)*bt_g0_34;
    bt_l1_14 = bt_l1_14 + (-4.4127503429081116e-07)*bt_g0_35;
    bt_l1_14 = bt_l1_14 + (-4.8526800355830346e-07)*bt_g0_36;
    bt_l1_14 = bt_l1_14 + (9.7580468150226807e-08)*bt_g0_37;
    bt_l1_14 = bt_l1_14 + (-5.6200980225185049e-07)*bt_g0_38;
    bt_l1_14 = bt_l1_14 + (-1.0825846175066545e-06)*bt_g0_39;
    bt_l1_14 = bt_l1_14 + (5.8719081152958097e-07)*bt_g0_40;
    bt_l1_14 = bt_l1_14 + (5.1439741355352453e-07)*bt_g0_41;
    bt_l1_14 = bt_l1_14 + (6.0628394749073777e-07)*bt_g0_42;
    bt_l1_14 = bt_l1_14 + (5.992623073325376e-07)*bt_g0_43;
    bt_l1_14 = bt_l1_14 + (-2.1731365507093869e-07)*bt_g0_44;
    bt_l1_14 = bt_l1_14 + (-2.2657002318737796e-07)*bt_g0_45;
    bt_l1_14 = bt_l1_14 + (-5.3124705345908296e-07)*bt_g0_46;
    bt_l1_14 = bt_l1_14 + (-5.8438735095478478e-07)*bt_g0_47;
    bt_l1_14 = bt_l1_14 + (-5.8633150956666213e-07)*bt_g0_48;
    bt_l1_14 = bt_l1_14 + (3.2941400718300429e-07)*bt_g0_49;
    bt_l1_14 = bt_l1_14 + (3.8288749237835873e-06)*bt_g0_50;
    bt_l1_14 = bt_l1_14 + (5.7805823416856583e-07)*bt_g0_51;
    bt_l1_14 = bt_l1_14 + (2.5168984052470478e-07)*bt_g0_52;
    bt_l1_14 = bt_l1_14 + (1.2184165143480641e-07)*bt_g0_53;
    bt_l1_14 = bt_l1_14 + (3.1933588218180375e-08)*bt_g0_54;
    bt_l1_14 = bt_l1_14 + (3.5448869084575563e-07)*bt_g0_55;
    bt_l1_14 = bt_l1_14 + (-3.6428943417377013e-07)*bt_g0_56;
    bt_l1_14 = bt_l1_14 + (-5.3611302064382471e-07)*bt_g0_57;
    bt_l1_14 = bt_l1_14 + (-0.0024408209137618542)*bt_g0_58;
    bt_l1_14 = bt_l1_14 + (-1.7394262386005721e-07)*bt_g0_59;
    bt_l1_14 = bt_l1_14 + (2.1694745555578265e-06)*bt_g0_60;
    bt_l1_14 = bt_l1_14 + (5.5550833621964557e-07)*bt_g0_61;
    bt_l1_14 = bt_l1_14 + (-3.9691431652499887e-07)*bt_g0_62;
    bt_l1_14 = bt_l1_14 + (0.0014182849554345012)*bt_g0_63;
    bt_l1_15 = 0.0070155886933207512;
    bt_l1_15 = bt_l1_15 + (4.1091990965469449e-07)*bt_g0_0;
    bt_l1_15 = bt_l1_15 + (8.3300085407245206e-07)*bt_g0_1;
    bt_l1_15 = bt_l1_15 + (-0.0024482333101332188)*bt_g0_2;
    bt_l1_15 = bt_l1_15 + (-6.1837212683713005e-08)*bt_g0_3;
    bt_l1_15 = bt_l1_15 + (-1.7735980861743883e-07)*bt_g0_4;
    bt_l1_15 = bt_l1_15 + (4.5252841118781362e-07)*bt_g0_5;
    bt_l1_15 = bt_l1_15 + (5.7209746273656492e-07)*bt_g0_6;
    bt_l1_15 = bt_l1_15 + (5.7345437198819127e-07)*bt_g0_7;
    bt_l1_15 = bt_l1_15 + (0.0060920175164937973)*bt_g0_8;
    bt_l1_15 = bt_l1_15 + (-5.673389296134701e-07)*bt_g0_9;
    bt_l1_15 = bt_l1_15 + (-0.00032119295792654157)*bt_g0_10;
    bt_l1_15 = bt_l1_15 + (-1.0482353900442831e-06)*bt_g0_11;
    bt_l1_15 = bt_l1_15 + (3.5985362956125755e-07)*bt_g0_12;
    bt_l1_15 = bt_l1_15 + (-0.0028173904865980148)*bt_g0_13;
    bt_l1_15 = bt_l1_15 + (-4.3658008053171216e-07)*bt_g0_14;
    bt_l1_15 = bt_l1_15 + (-3.8004424141035997e-07)*bt_g0_15;
    bt_l1_15 = bt_l1_15 + (0.00097841070964932442)*bt_g0_16;
    bt_l1_15 = bt_l1_15 + (0.0014903041301295161)*bt_g0_17;
    bt_l1_15 = bt_l1_15 + (-2.2134283881314332e-06)*bt_g0_18;
    bt_l1_15 = bt_l1_15 + (5.4755099654357764e-07)*bt_g0_19;
    bt_l1_15 = bt_l1_15 + (5.6338825515922508e-07)*bt_g0_20;
    bt_l1_15 = bt_l1_15 + (-4.016193884126551e-07)*bt_g0_21;
    bt_l1_15 = bt_l1_15 + (0.0015062990132719278)*bt_g0_22;
    bt_l1_15 = bt_l1_15 + (-9.6662489568188903e-08)*bt_g0_23;
    bt_l1_15 = bt_l1_15 + (-6.2711535520065809e-07)*bt_g0_24;
    bt_l1_15 = bt_l1_15 + (-8.1025255838085286e-08)*bt_g0_25;
    bt_l1_15 = bt_l1_15 + (-7.7197461223477148e-07)*bt_g0_26;
    bt_l1_15 = bt_l1_15 + (0.00053396588191390038)*bt_g0_27;
    bt_l1_15 = bt_l1_15 + (4.0172693616113975e-07)*bt_g0_28;
    bt_l1_15 = bt_l1_15 + (-3.0905025596439373e-06)*bt_g0_29;
    bt_l1_15 = bt_l1_15 + (4.889878937319736e-07)*bt_g0_30;
    bt_l1_15 = bt_l1_15 + (-1.505193836237595e-07)*bt_g0_31;
    bt_l1_15 = bt_l1_15 + (5.7894118299373076e-07)*bt_g0_32;
    bt_l1_15 = bt_l1_15 + (1.6688763935235329e-06)*bt_g0_33;
    bt_l1_15 = bt_l1_15 + (4.9144290414915304e-07)*bt_g0_34;
    bt_l1_15 = bt_l1_15 + (-4.4127608589406009e-07)*bt_g0_35;
    bt_l1_15 = bt_l1_15 + (-4.8526811724514118e-07)*bt_g0_36;
    bt_l1_15 = bt_l1_15 + (9.7582514513305796e-08)*bt_g0_37;
    bt_l1_15 = bt_l1_15 + (-5.6201014331236365e-07)*bt_g0_38;
    bt_l1_15 = bt_l1_15 + (-1.0825880281117861e-06)*bt_g0_39;
    bt_l1_15 = bt_l1_15 + (5.8719035678223008e-07)*bt_g0_40;
    bt_l1_15 = bt_l1_15 + (5.1439764092719997e-07)*bt_g0_41;
    bt_l1_15 = bt_l1_15 + (6.0628349274338689e-07)*bt_g0_42;
    bt_l1_15 = bt_l1_15 + (5.9926207995886216e-07)*bt_g0_43;
    bt_l1_15 = bt_l1_15 + (-2.1731538879521395e-07)*bt_g0_44;
    bt_l1_15 = bt_l1_15 + (-2.2656816156541026e-07)*bt_g0_45;
    bt_l1_15 = bt_l1_15 + (-5.3124733767617727e-07)*bt_g0_46;
    bt_l1_15 = bt_l1_15 + (-5.8438706673769047e-07)*bt_g0_47;
    bt_l1_15 = bt_l1_15 + (-5.8633145272324327e-07)*bt_g0_48;
    bt_l1_15 = bt_l1_15 + (3.2941537142505695e-07)*bt_g0_49;
    bt_l1_15 = bt_l1_15 + (3.8289194890239742e-06)*bt_g0_50;
    bt_l1_15 = bt_l1_15 + (5.7805721098702634e-07)*bt_g0_51;
    bt_l1_15 = bt_l1_15 + (2.5168804995701066e-07)*bt_g0_52;
    bt_l1_15 = bt_l1_15 + (1.2184203512788372e-07)*bt_g0_53;
    bt_l1_15 = bt_l1_15 + (3.193561681769097e-08)*bt_g0_54;
    bt_l1_15 = bt_l1_15 + (3.5448985613584227e-07)*bt_g0_55;
    bt_l1_15 = bt_l1_15 + (-3.6428849625735893e-07)*bt_g0_56;
    bt_l1_15 = bt_l1_15 + (-5.3609585393132875e-07)*bt_g0_57;
    bt_l1_15 = bt_l1_15 + (-0.0024408299941569567)*bt_g0_58;
    bt_l1_15 = bt_l1_15 + (-1.7394390283698158e-07)*bt_g0_59;
    bt_l1_15 = bt_l1_15 + (2.1694700080843177e-06)*bt_g0_60;
    bt_l1_15 = bt_l1_15 + (5.5550810884597013e-07)*bt_g0_61;
    bt_l1_15 = bt_l1_15 + (-3.9691505548944406e-07)*bt_g0_62;
    bt_l1_15 = bt_l1_15 + (0.0014182898448780179)*bt_g0_63;
    bt_l1_16 = 0.0070156389847397804;
    bt_l1_16 = bt_l1_16 + (4.109191706902493e-07)*bt_g0_0;
    bt_l1_16 = bt_l1_16 + (8.3301193853912991e-07)*bt_g0_1;
    bt_l1_16 = bt_l1_16 + (-0.0024482090957462788)*bt_g0_2;
    bt_l1_16 = bt_l1_16 + (-6.183945089333065e-08)*bt_g0_3;
    bt_l1_16 = bt_l1_16 + (-1.7735412427555275e-07)*bt_g0_4;
    bt_l1_16 = bt_l1_16 + (4.525269901023421e-07)*bt_g0_5;
    bt_l1_16 = bt_l1_16 + (5.7209626902476884e-07)*bt_g0_6;
    bt_l1_16 = bt_l1_16 + (5.7345334880665177e-07)*bt_g0_7;
    bt_l1_16 = bt_l1_16 + (0.0060919956304132938)*bt_g0_8;
    bt_l1_16 = bt_l1_16 + (-5.6733853170953807e-07)*bt_g0_9;
    bt_l1_16 = bt_l1_16 + (-0.00032119004754349589)*bt_g0_10;
    bt_l1_16 = bt_l1_16 + (-1.0482566494829371e-06)*bt_g0_11;
    bt_l1_16 = bt_l1_16 + (3.5985127055937483e-07)*bt_g0_12;
    bt_l1_16 = bt_l1_16 + (-0.0028173958417028189)*bt_g0_13;
    bt_l1_16 = bt_l1_16 + (-4.3657945525410469e-07)*bt_g0_14;
    bt_l1_16 = bt_l1_16 + (-3.8004259295121301e-07)*bt_g0_15;
    bt_l1_16 = bt_l1_16 + (0.00097827007994055748)*bt_g0_16;
    bt_l1_16 = bt_l1_16 + (0.0014902849216014147)*bt_g0_17;
    bt_l1_16 = bt_l1_16 + (-2.2134352093416965e-06)*bt_g0_18;
    bt_l1_16 = bt_l1_16 + (5.4755196288169827e-07)*bt_g0_19;
    bt_l1_16 = bt_l1_16 + (5.6338751619477989e-07)*bt_g0_20;
    bt_l1_16 = bt_l1_16 + (-4.0161799574889301e-07)*bt_g0_21;
    bt_l1_16 = bt_l1_16 + (0.0015062863240018487)*bt_g0_22;
    bt_l1_16 = bt_l1_16 + (-9.6658119730363978e-08)*bt_g0_23;
    bt_l1_16 = bt_l1_16 + (-6.2711507098356378e-07)*bt_g0_24;
    bt_l1_16 = bt_l1_16 + (-8.1022974995903496e-08)*bt_g0_25;
    bt_l1_16 = bt_l1_16 + (-7.7196091297082603e-07)*bt_g0_26;
    bt_l1_16 = bt_l1_16 + (0.00053393765119835734)*bt_g0_27;
    bt_l1_16 = bt_l1_16 + (4.0172878357225272e-07)*bt_g0_28;
    bt_l1_16 = bt_l1_16 + (-3.0904598133929539e-06)*bt_g0_29;
    bt_l1_16 = bt_l1_16 + (4.8898664317675866e-07)*bt_g0_30;
    bt_l1_16 = bt_l1_16 + (-1.5051702462187677e-07)*bt_g0_31;
    bt_l1_16 = bt_l1_16 + (5.7894033034244785e-07)*bt_g0_32;
    bt_l1_16 = bt_l1_16 + (1.6688557025190676e-06)*bt_g0_33;
    bt_l1_16 = bt_l1_16 + (4.9144222202812671e-07)*bt_g0_34;
    bt_l1_16 = bt_l1_16 + (-4.4127455112175085e-07)*bt_g0_35;
    bt_l1_16 = bt_l1_16 + (-4.8526749196753372e-07)*bt_g0_36;
    bt_l1_16 = bt_l1_16 + (9.7579061275610002e-08)*bt_g0_37;
    bt_l1_16 = bt_l1_16 + (-5.6200923381766188e-07)*bt_g0_38;
    bt_l1_16 = bt_l1_16 + (-1.0825852996276808e-06)*bt_g0_39;
    bt_l1_16 = bt_l1_16 + (5.8719001572171692e-07)*bt_g0_40;
    bt_l1_16 = bt_l1_16 + (5.1439656090224162e-07)*bt_g0_41;
    bt_l1_16 = bt_l1_16 + (6.0628315168287372e-07)*bt_g0_42;
    bt_l1_16 = bt_l1_16 + (5.9926173889834899e-07)*bt_g0_43;
    bt_l1_16 = bt_l1_16 + (-2.1731302979333122e-07)*bt_g0_44;
    bt_l1_16 = bt_l1_16 + (-2.2657029319361754e-07)*bt_g0_45;
    bt_l1_16 = bt_l1_16 + (-5.3124620080780005e-07)*bt_g0_46;
    bt_l1_16 = bt_l1_16 + (-5.8438644146008301e-07)*bt_g0_47;
    bt_l1_16 = bt_l1_16 + (-5.8633099797589239e-07)*bt_g0_48;
    bt_l1_16 = bt_l1_16 + (3.2941321137514024e-07)*bt_g0_49;
    bt_l1_16 = bt_l1_16 + (3.8288667383312713e-06)*bt_g0_50;
    bt_l1_16 = bt_l1_16 + (5.7805806363830925e-07)*bt_g0_51;
    bt_l1_16 = bt_l1_16 + (2.516899542115425e-07)*bt_g0_52;
    bt_l1_16 = bt_l1_16 + (1.2184109721147252e-07)*bt_g0_53;
    bt_l1_16 = bt_l1_16 + (3.1932941624290834e-08)*bt_g0_54;
    bt_l1_16 = bt_l1_16 + (3.5448803714643873e-07)*bt_g0_55;
    bt_l1_16 = bt_l1_16 + (-3.6429051419872849e-07)*bt_g0_56;
    bt_l1_16 = bt_l1_16 + (-5.3611910288964282e-07)*bt_g0_57;
    bt_l1_16 = bt_l1_16 + (-0.002440811600536108)*bt_g0_58;
    bt_l1_16 = bt_l1_16 + (-1.7394202700415917e-07)*bt_g0_59;
    bt_l1_16 = bt_l1_16 + (2.1694777387892827e-06)*bt_g0_60;
    bt_l1_16 = bt_l1_16 + (5.5550788147229468e-07)*bt_g0_61;
    bt_l1_16 = bt_l1_16 + (-3.9691380493422912e-07)*bt_g0_62;
    bt_l1_16 = bt_l1_16 + (0.0014182677259668708)*bt_g0_63;
    bt_l1_17 = 0.0070156464353203773;
    bt_l1_17 = bt_l1_17 + (4.1091905700341158e-07)*bt_g0_0;
    bt_l1_17 = bt_l1_17 + (8.3301614495212561e-07)*bt_g0_1;
    bt_l1_17 = bt_l1_17 + (-0.0024481993168592453)*bt_g0_2;
    bt_l1_17 = bt_l1_17 + (-6.1840388809741853e-08)*bt_g0_3;
    bt_l1_17 = bt_l1_17 + (-1.7735175106281531e-07)*bt_g0_4;
    bt_l1_17 = bt_l1_17 + (4.5252647851157235e-07)*bt_g0_5;
    bt_l1_17 = bt_l1_17 + (5.7209592796425568e-07)*bt_g0_6;
    bt_l1_17 = bt_l1_17 + (5.7345300774613861e-07)*bt_g0_7;
    bt_l1_17 = bt_l1_17 + (0.0060919793322682381)*bt_g0_8;
    bt_l1_17 = bt_l1_17 + (-5.6733858855295694e-07)*bt_g0_9;
    bt_l1_17 = bt_l1_17 + (-0.00032118929084390402)*bt_g0_10;
    bt_l1_17 = bt_l1_17 + (-1.0482638117537135e-06)*bt_g0_11;
    bt_l1_17 = bt_l1_17 + (3.5985010526928818e-07)*bt_g0_12;
    bt_l1_17 = bt_l1_17 + (-0.0028173830360174179)*bt_g0_13;
    bt_l1_17 = bt_l1_17 + (-4.3657908577188209e-07)*bt_g0_14;
    bt_l1_17 = bt_l1_17 + (-3.8004208136044326e-07)*bt_g0_15;
    bt_l1_17 = bt_l1_17 + (0.00097823131363838911)*bt_g0_16;
    bt_l1_17 = bt_l1_17 + (0.0014902842231094837)*bt_g0_17;
    bt_l1_17 = bt_l1_17 + (-2.2134345272206701e-06)*bt_g0_18;
    bt_l1_17 = bt_l1_17 + (5.4755253131588688e-07)*bt_g0_19;
    bt_l1_17 = bt_l1_17 + (5.6338728882110445e-07)*bt_g0_20;
    bt_l1_17 = bt_l1_17 + (-4.0161725678444782e-07)*bt_g0_21;
    bt_l1_17 = bt_l1_17 + (0.0015062929596751928)*bt_g0_22;
    bt_l1_17 = bt_l1_17 + (-9.6656911807713186e-08)*bt_g0_23;
    bt_l1_17 = bt_l1_17 + (-6.2711484360988834e-07)*bt_g0_24;
    bt_l1_17 = bt_l1_17 + (-8.1021873654663068e-08)*bt_g0_25;
    bt_l1_17 = bt_l1_17 + (-7.7195670655783033e-07)*bt_g0_26;
    bt_l1_17 = bt_l1_17 + (0.00053392705740407109)*bt_g0_27;
    bt_l1_17 = bt_l1_17 + (4.0172957938011677e-07)*bt_g0_28;
    bt_l1_17 = bt_l1_17 + (-3.0904457162250765e-06)*bt_g0_29;
    bt_l1_17 = bt_l1_17 + (4.8898601789915119e-07)*bt_g0_30;
    bt_l1_17 = bt_l1_17 + (-1.5051617197059386e-07)*bt_g0_31;
    bt_l1_17 = bt_l1_17 + (5.789395345345838e-07)*bt_g0_32;
    bt_l1_17 = bt_l1_17 + (1.6688485402482911e-06)*bt_g0_33;
    bt_l1_17 = bt_l1_17 + (4.9144176728077582e-07)*bt_g0_34;
    bt_l1_17 = bt_l1_17 + (-4.4127401110927167e-07)*bt_g0_35;
    bt_l1_17 = bt_l1_17 + (-4.8526737828069599e-07)*bt_g0_36;
    bt_l1_17 = bt_l1_17 + (9.7577995461506362e-08)*bt_g0_37;
    bt_l1_17 = bt_l1_17 + (-5.6200894960056758e-07)*bt_g0_38;
    bt_l1_17 = bt_l1_17 + (-1.0825832532646018e-06)*bt_g0_39;
    bt_l1_17 = bt_l1_17 + (5.8719001572171692e-07)*bt_g0_40;
    bt_l1_17 = bt_l1_17 + (5.1439587878121529e-07)*bt_g0_41;
    bt_l1_17 = bt_l1_17 + (6.0628315168287372e-07)*bt_g0_42;
    bt_l1_17 = bt_l1_17 + (5.9926156836809241e-07)*bt_g0_43;
    bt_l1_17 = bt_l1_17 + (-2.1731213450948417e-07)*bt_g0_44;
    bt_l1_17 = bt_l1_17 + (-2.2657138742943062e-07)*bt_g0_45;
    bt_l1_17 = bt_l1_17 + (-5.3124563237361144e-07)*bt_g0_46;
    bt_l1_17 = bt_l1_17 + (-5.843861572429887e-07)*bt_g0_47;
    bt_l1_17 = bt_l1_17 + (-5.8633077060221694e-07)*bt_g0_48;
    bt_l1_17 = bt_l1_17 + (3.2941233030214789e-07)*bt_g0_49;
    bt_l1_17 = bt_l1_17 + (3.8288430914690252e-06)*bt_g0_50;
    bt_l1_17 = bt_l1_17 + (5.7805817732514697e-07)*bt_g0_51;
    bt_l1_17 = bt_l1_17 + (2.5169092054966313e-07)*bt_g0_52;
    bt_l1_17 = bt_l1_17 + (1.2184072772924992e-07)*bt_g0_53;
    bt_l1_17 = bt_l1_17 + (3.1932032129589061e-08)*bt_g0_54;
    bt_l1_17 = bt_l1_17 + (3.5448724133857468e-07)*bt_g0_55;
    bt_l1_17 = bt_l1_17 + (-3.642909973677888e-07)*bt_g0_56;
    bt_l1_17 = bt_l1_17 + (-5.3612552619597409e-07)*bt_g0_57;
    bt_l1_17 = bt_l1_17 + (-0.0024407964665442705)*bt_g0_58;
    bt_l1_17 = bt_l1_17 + (-1.7394147278082528e-07)*bt_g0_59;
    bt_l1_17 = bt_l1_17 + (2.1694813767680898e-06)*bt_g0_60;
    bt_l1_17 = bt_l1_17 + (5.5550765409861924e-07)*bt_g0_61;
    bt_l1_17 = bt_l1_17 + (-3.9691326492174994e-07)*bt_g0_62;
    bt_l1_17 = bt_l1_17 + (0.0014182708691805601)*bt_g0_63;
    bt_l1_18 = -0.0081611527130007744;
    bt_l1_18 = bt_l1_18 + (-8.2319508010186837e-07)*bt_g0_0;
    bt_l1_18 = bt_l1_18 + (7.2065695349010639e-06)*bt_g0_1;
    bt_l1_18 = bt_l1_18 + (0.13268499076366425)*bt_g0_2;
    bt_l1_18 = bt_l1_18 + (-1.1114319704574882e-06)*bt_g0_3;
    bt_l1_18 = bt_l1_18 + (3.5717848732019775e-06)*bt_g0_4;
    bt_l1_18 = bt_l1_18 + (-3.6768309996659809e-07)*bt_g0_5;
    bt_l1_18 = bt_l1_18 + (4.4146267441647069e-07)*bt_g0_6;
    bt_l1_18 = bt_l1_18 + (3.9964740494724538e-07)*bt_g0_7;
    bt_l1_18 = bt_l1_18 + (-0.08959314227104187)*bt_g0_8;
    bt_l1_18 = bt_l1_18 + (-8.2840836057584966e-07)*bt_g0_9;
    bt_l1_18 = bt_l1_18 + (0.011414304375648499)*bt_g0_10;
    bt_l1_18 = bt_l1_18 + (-4.9180148380401079e-06)*bt_g0_11;
    bt_l1_18 = bt_l1_18 + (-1.6719610584914335e-06)*bt_g0_12;
    bt_l1_18 = bt_l1_18 + (0.038626983761787415)*bt_g0_13;
    bt_l1_18 = bt_l1_18 + (5.4718850606150227e-07)*bt_g0_14;
    bt_l1_18 = bt_l1_18 + (5.7610958492659847e-07)*bt_g0_15;
    bt_l1_18 = bt_l1_18 + (0.019945265725255013)*bt_g0_16;
    bt_l1_18 = bt_l1_18 + (0.0466107577085495)*bt_g0_17;
    bt_l1_18 = bt_l1_18 + (-1.2418130609148648e-05)*bt_g0_18;
    bt_l1_18 = bt_l1_18 + (1.4924059996701544e-06)*bt_g0_19;
    bt_l1_18 = bt_l1_18 + (7.2177505217041471e-07)*bt_g0_20;
    bt_l1_18 = bt_l1_18 + (3.3261264320572081e-07)*bt_g0_21;
    bt_l1_18 = bt_l1_18 + (-0.023028114810585976)*bt_g0_22;
    bt_l1_18 = bt_l1_18 + (2.4446389943477698e-06)*bt_g0_23;
    bt_l1_18 = bt_l1_18 + (-1.0950262776532327e-06)*bt_g0_24;
    bt_l1_18 = bt_l1_18 + (1.7487006971350638e-06)*bt_g0_25;
    bt_l1_18 = bt_l1_18 + (1.9843262180074817e-06)*bt_g0_26;
    bt_l1_18 = bt_l1_18 + (-0.062209613621234894)*bt_g0_27;
    bt_l1_18 = bt_l1_18 + (7.7607421644643182e-07)*bt_g0_28;
    bt_l1_18 = bt_l1_18 + (3.0188991786417319e-06)*bt_g0_29;
    bt_l1_18 = bt_l1_18 + (-6.0362265230651246e-07)*bt_g0_30;
    bt_l1_18 = bt_l1_18 + (1.5490254554606508e-06)*bt_g0_31;
    bt_l1_18 = bt_l1_18 + (7.1166709858516697e-07)*bt_g0_32;
    bt_l1_18 = bt_l1_18 + (-1.2644760545299505e-06)*bt_g0_33;
    bt_l1_18 = bt_l1_18 + (-6.1647295979128103e-07)*bt_g0_34;
    bt_l1_18 = bt_l1_18 + (5.5596825632164837e-07)*bt_g0_35;
    bt_l1_18 = bt_l1_18 + (5.2175187192915473e-07)*bt_g0_36;
    bt_l1_18 = bt_l1_18 + (-2.6451889425516129e-06)*bt_g0_37;
    bt_l1_18 = bt_l1_18 + (-4.2994437876586744e-07)*bt_g0_38;
    bt_l1_18 = bt_l1_18 + (-7.2829211603675503e-06)*bt_g0_39;
    bt_l1_18 = bt_l1_18 + (1.1660762311294093e-06)*bt_g0_40;
    bt_l1_18 = bt_l1_18 + (-6.6448535562813049e-08)*bt_g0_41;
    bt_l1_18 = bt_l1_18 + (1.0872355460378458e-06)*bt_g0_42;
    bt_l1_18 = bt_l1_18 + (1.0631616760292673e-06)*bt_g0_43;
    bt_l1_18 = bt_l1_18 + (1.2512751936810673e-06)*bt_g0_44;
    bt_l1_18 = bt_l1_18 + (-1.0422492096040514e-06)*bt_g0_45;
    bt_l1_18 = bt_l1_18 + (-2.2632470120242942e-07)*bt_g0_46;
    bt_l1_18 = bt_l1_18 + (-7.947448921186151e-07)*bt_g0_47;
    bt_l1_18 = bt_l1_18 + (-9.1002169710918679e-07)*bt_g0_48;
    bt_l1_18 = bt_l1_18 + (-1.8446489775669761e-06)*bt_g0_49;
    bt_l1_18 = bt_l1_18 + (-7.1340432441502344e-06)*bt_g0_50;
    bt_l1_18 = bt_l1_18 + (1.625110940040031e-06)*bt_g0_51;
    bt_l1_18 = bt_l1_18 + (4.8438266730954638e-07)*bt_g0_52;
    bt_l1_18 = bt_l1_18 + (-2.9324283445930632e-07)*bt_g0_53;
    bt_l1_18 = bt_l1_18 + (-1.8850425931304926e-06)*bt_g0_54;
    bt_l1_18 = bt_l1_18 + (-8.7249577518377919e-07)*bt_g0_55;
    bt_l1_18 = bt_l1_18 + (-4.1031935325008817e-06)*bt_g0_56;
    bt_l1_18 = bt_l1_18 + (-4.7972175707400311e-06)*bt_g0_57;
    bt_l1_18 = bt_l1_18 + (-0.088372804224491119)*bt_g0_58;
    bt_l1_18 = bt_l1_18 + (6.3856049337118748e-07)*bt_g0_59;
    bt_l1_18 = bt_l1_18 + (1.2352384146652184e-05)*bt_g0_60;
    bt_l1_18 = bt_l1_18 + (6.7533153469412355e-07)*bt_g0_61;
    bt_l1_18 = bt_l1_18 + (3.2103133662531036e-07)*bt_g0_62;
    bt_l1_18 = bt_l1_18 + (-0.01864110492169857)*bt_g0_63;
    bt_l1_19 = 0.0070156189613044262;
    bt_l1_19 = bt_l1_19 + (4.1091962543760019e-07)*bt_g0_0;
    bt_l1_19 = bt_l1_19 + (8.3300608366698725e-07)*bt_g0_1;
    bt_l1_19 = bt_l1_19 + (-0.0024482149165123701)*bt_g0_2;
    bt_l1_19 = bt_l1_19 + (-6.1837667431063892e-08)*bt_g0_3;
    bt_l1_19 = bt_l1_19 + (-1.7735759172410326e-07)*bt_g0_4;
    bt_l1_19 = bt_l1_19 + (4.5252787117533444e-07)*bt_g0_5;
    bt_l1_19 = bt_l1_19 + (5.7209717851947062e-07)*bt_g0_6;
    bt_l1_19 = bt_l1_19 + (5.734540309276781e-07)*bt_g0_7;
    bt_l1_19 = bt_l1_19 + (0.0060920328833162785)*bt_g0_8;
    bt_l1_19 = bt_l1_19 + (-5.6733870223979466e-07)*bt_g0_9;
    bt_l1_19 = bt_l1_19 + (-0.00032118966919369996)*bt_g0_10;
    bt_l1_19 = bt_l1_19 + (-1.0482449397386517e-06)*bt_g0_11;
    bt_l1_19 = bt_l1_19 + (3.5985294744023122e-07)*bt_g0_12;
    bt_l1_19 = bt_l1_19 + (-0.0028174105100333691)*bt_g0_13;
    bt_l1_19 = bt_l1_19 + (-4.3657985315803671e-07)*bt_g0_14;
    bt_l1_19 = bt_l1_19 + (-3.8004384350642795e-07)*bt_g0_15;
    bt_l1_19 = bt_l1_19 + (0.00097836658824235201)*bt_g0_16;
    bt_l1_19 = bt_l1_19 + (0.0014902831753715873)*bt_g0_17;
    bt_l1_19 = bt_l1_19 + (-2.2134347545943456e-06)*bt_g0_18;
    bt_l1_19 = bt_l1_19 + (5.475513376040908e-07)*bt_g0_19;
    bt_l1_19 = bt_l1_19 + (5.6338785725529306e-07)*bt_g0_20;
    bt_l1_19 = bt_l1_19 + (-4.0161896208701364e-07)*bt_g0_21;
    bt_l1_19 = bt_l1_19 + (0.0015062820166349411)*bt_g0_22;
    bt_l1_19 = bt_l1_19 + (-9.6660762949341006e-08)*bt_g0_23;
    bt_l1_19 = bt_l1_19 + (-6.2711495729672606e-07)*bt_g0_24;
    bt_l1_19 = bt_l1_19 + (-8.1024694509324036e-08)*bt_g0_25;
    bt_l1_19 = bt_l1_19 + (-7.7197171322040958e-07)*bt_g0_26;
    bt_l1_19 = bt_l1_19 + (0.00053395866416394711)*bt_g0_27;
    bt_l1_19 = bt_l1_19 + (4.0172750459532836e-07)*bt_g0_28;
    bt_l1_19 = bt_l1_19 + (-3.0904941468179459e-06)*bt_g0_29;
    bt_l1_19 = bt_l1_19 + (4.8898755267146043e-07)*bt_g0_30;
    bt_l1_19 = bt_l1_19 + (-1.5051890045469918e-07)*bt_g0_31;
    bt_l1_19 = bt_l1_19 + (5.7894095562005532e-07)*bt_g0_32;
    bt_l1_19 = bt_l1_19 + (1.6688720734236995e-06)*bt_g0_33;
    bt_l1_19 = bt_l1_19 + (4.9144301783599076e-07)*bt_g0_34;
    bt_l1_19 = bt_l1_19 + (-4.4127565956841863e-07)*bt_g0_35;
    bt_l1_19 = bt_l1_19 + (-4.8526783302804688e-07)*bt_g0_36;
    bt_l1_19 = bt_l1_19 + (9.7580993951851269e-08)*bt_g0_37;
    bt_l1_19 = bt_l1_19 + (-5.6200997278210707e-07)*bt_g0_38;
    bt_l1_19 = bt_l1_19 + (-1.0825888239196502e-06)*bt_g0_39;
    bt_l1_19 = bt_l1_19 + (5.8719007256513578e-07)*bt_g0_40;
    bt_l1_19 = bt_l1_19 + (5.1439741355352453e-07)*bt_g0_41;
    bt_l1_19 = bt_l1_19 + (6.0628337905654917e-07)*bt_g0_42;
    bt_l1_19 = bt_l1_19 + (5.992620231154433e-07)*bt_g0_43;
    bt_l1_19 = bt_l1_19 + (-2.1731446508965746e-07)*bt_g0_44;
    bt_l1_19 = bt_l1_19 + (-2.2656861631276115e-07)*bt_g0_45;
    bt_l1_19 = bt_l1_19 + (-5.3124705345908296e-07)*bt_g0_46;
    bt_l1_19 = bt_l1_19 + (-5.8438695305085275e-07)*bt_g0_47;
    bt_l1_19 = bt_l1_19 + (-5.8633128219298669e-07)*bt_g0_48;
    bt_l1_19 = bt_l1_19 + (3.2941434824351745e-07)*bt_g0_49;
    bt_l1_19 = bt_l1_19 + (3.828908120340202e-06)*bt_g0_50;
    bt_l1_19 = bt_l1_19 + (5.7805760889095836e-07)*bt_g0_51;
    bt_l1_19 = bt_l1_19 + (2.5168853312607098e-07)*bt_g0_52;
    bt_l1_19 = bt_l1_19 + (1.2184169406737055e-07)*bt_g0_53;
    bt_l1_19 = bt_l1_19 + (3.1934963118374071e-08)*bt_g0_54;
    bt_l1_19 = bt_l1_19 + (3.5448920243652537e-07)*bt_g0_55;
    bt_l1_19 = bt_l1_19 + (-3.6429051419872849e-07)*bt_g0_56;
    bt_l1_19 = bt_l1_19 + (-5.361050625651842e-07)*bt_g0_57;
    bt_l1_19 = bt_l1_19 + (-0.0024408395402133465)*bt_g0_58;
    bt_l1_19 = bt_l1_19 + (-1.7394344808963069e-07)*bt_g0_59;
    bt_l1_19 = bt_l1_19 + (2.1694775114156073e-06)*bt_g0_60;
    bt_l1_19 = bt_l1_19 + (5.5550799515913241e-07)*bt_g0_61;
    bt_l1_19 = bt_l1_19 + (-3.9691468600722146e-07)*bt_g0_62;
    bt_l1_19 = bt_l1_19 + (0.0014182986924424767)*bt_g0_63;
    bt_l1_20 = 0.0070156198926270008;
    bt_l1_20 = bt_l1_20 + (4.109195401724719e-07)*bt_g0_0;
    bt_l1_20 = bt_l1_20 + (8.330068794748513e-07)*bt_g0_1;
    bt_l1_20 = bt_l1_20 + (-0.0024482235312461853)*bt_g0_2;
    bt_l1_20 = bt_l1_20 + (-6.1838299814098718e-08)*bt_g0_3;
    bt_l1_20 = bt_l1_20 + (-1.7735679591623921e-07)*bt_g0_4;
    bt_l1_20 = bt_l1_20 + (4.5252767222336843e-07)*bt_g0_5;
    bt_l1_20 = bt_l1_20 + (5.7209683745895745e-07)*bt_g0_6;
    bt_l1_20 = bt_l1_20 + (5.7345397408425924e-07)*bt_g0_7;
    bt_l1_20 = bt_l1_20 + (0.0060920207761228085)*bt_g0_8;
    bt_l1_20 = bt_l1_20 + (-5.6733875908321352e-07)*bt_g0_9;
    bt_l1_20 = bt_l1_20 + (-0.00032119089155457914)*bt_g0_10;
    bt_l1_20 = bt_l1_20 + (-1.0482463039807044e-06)*bt_g0_11;
    bt_l1_20 = bt_l1_20 + (3.5985232216262375e-07)*bt_g0_12;
    bt_l1_20 = bt_l1_20 + (-0.0028173977043479681)*bt_g0_13;
    bt_l1_20 = bt_l1_20 + (-4.3657968262778013e-07)*bt_g0_14;
    bt_l1_20 = bt_l1_20 + (-3.8004355928933364e-07)*bt_g0_15;
    bt_l1_20 = bt_l1_20 + (0.00097833864856511354)*bt_g0_16;
    bt_l1_20 = bt_l1_20 + (0.0014902871334925294)*bt_g0_17;
    bt_l1_20 = bt_l1_20 + (-2.2134327082312666e-06)*bt_g0_18;
    bt_l1_20 = bt_l1_20 + (5.4755179235144169e-07)*bt_g0_19;
    bt_l1_20 = bt_l1_20 + (5.6338774356845533e-07)*bt_g0_20;
    bt_l1_20 = bt_l1_20 + (-4.0161879155675706e-07)*bt_g0_21;
    bt_l1_20 = bt_l1_20 + (0.0015062958700582385)*bt_g0_22;
    bt_l1_20 = bt_l1_20 + (-9.6660457415964629e-08)*bt_g0_23;
    bt_l1_20 = bt_l1_20 + (-6.271151846704015e-07)*bt_g0_24;
    bt_l1_20 = bt_l1_20 + (-8.1024104758853355e-08)*bt_g0_25;
    bt_l1_20 = bt_l1_20 + (-7.719683594586968e-07)*bt_g0_26;
    bt_l1_20 = bt_l1_20 + (0.00053395575378090143)*bt_g0_27;
    bt_l1_20 = bt_l1_20 + (4.0172793092096981e-07)*bt_g0_28;
    bt_l1_20 = bt_l1_20 + (-3.0904827781341737e-06)*bt_g0_29;
    bt_l1_20 = bt_l1_20 + (4.8898738214120385e-07)*bt_g0_30;
    bt_l1_20 = bt_l1_20 + (-1.5051824675538228e-07)*bt_g0_31;
    bt_l1_20 = bt_l1_20 + (5.7894078508979874e-07)*bt_g0_32;
    bt_l1_20 = bt_l1_20 + (1.6688662753949757e-06)*bt_g0_33;
    bt_l1_20 = bt_l1_20 + (4.9144261993205873e-07)*bt_g0_34;
    bt_l1_20 = bt_l1_20 + (-4.4127526166448661e-07)*bt_g0_35;
    bt_l1_20 = bt_l1_20 + (-4.8526771934120916e-07)*bt_g0_36;
    bt_l1_20 = bt_l1_20 + (9.7580461044799449e-08)*bt_g0_37;
    bt_l1_20 = bt_l1_20 + (-5.6200968856501277e-07)*bt_g0_38;
    bt_l1_20 = bt_l1_20 + (-1.0825859817487071e-06)*bt_g0_39;
    bt_l1_20 = bt_l1_20 + (5.871901862519735e-07)*bt_g0_40;
    bt_l1_20 = bt_l1_20 + (5.1439707249301136e-07)*bt_g0_41;
    bt_l1_20 = bt_l1_20 + (6.0628337905654917e-07)*bt_g0_42;
    bt_l1_20 = bt_l1_20 + (5.9926173889834899e-07)*bt_g0_43;
    bt_l1_20 = bt_l1_20 + (-2.1731406718572543e-07)*bt_g0_44;
    bt_l1_20 = bt_l1_20 + (-2.2656928422293277e-07)*bt_g0_45;
    bt_l1_20 = bt_l1_20 + (-5.312467123985698e-07)*bt_g0_46;
    bt_l1_20 = bt_l1_20 + (-5.8438689620743389e-07)*bt_g0_47;
    bt_l1_20 = bt_l1_20 + (-5.8633122534956783e-07)*bt_g0_48;
    bt_l1_20 = bt_l1_20 + (3.2941417771326087e-07)*bt_g0_49;
    bt_l1_20 = bt_l1_20 + (3.828892204182921e-06)*bt_g0_50;
    bt_l1_20 = bt_l1_20 + (5.7805789310805267e-07)*bt_g0_51;
    bt_l1_20 = bt_l1_20 + (2.5168895945171244e-07)*bt_g0_52;
    bt_l1_20 = bt_l1_20 + (1.2184160880224226e-07)*bt_g0_53;
    bt_l1_20 = bt_l1_20 + (3.1934380473330748e-08)*bt_g0_54;
    bt_l1_20 = bt_l1_20 + (3.5448891821943107e-07)*bt_g0_55;
    bt_l1_20 = bt_l1_20 + (-3.6428986049941159e-07)*bt_g0_56;
    bt_l1_20 = bt_l1_20 + (-5.3610961003869306e-07)*bt_g0_57;
    bt_l1_20 = bt_l1_20 + (-0.0024408185854554176)*bt_g0_58;
    bt_l1_20 = bt_l1_20 + (-1.7394302176398924e-07)*bt_g0_59;
    bt_l1_20 = bt_l1_20 + (2.1694743281841511e-06)*bt_g0_60;
    bt_l1_20 = bt_l1_20 + (5.5550799515913241e-07)*bt_g0_61;
    bt_l1_20 = bt_l1_20 + (-3.969143449467083e-07)*bt_g0_62;
    bt_l1_20 = bt_l1_20 + (0.001418287749402225)*bt_g0_63;
    bt_l1_21 = 0.0070156422443687916;
    bt_l1_21 = bt_l1_21 + (4.1091928437708702e-07)*bt_g0_0;
    bt_l1_21 = bt_l1_21 + (8.3300989217605093e-07)*bt_g0_1;
    bt_l1_21 = bt_l1_21 + (-0.002448217011988163)*bt_g0_2;
    bt_l1_21 = bt_l1_21 + (-6.1838534293201519e-08)*bt_g0_3;
    bt_l1_21 = bt_l1_21 + (-1.7735523272222053e-07)*bt_g0_4;
    bt_l1_21 = bt_l1_21 + (4.5252741642798355e-07)*bt_g0_5;
    bt_l1_21 = bt_l1_21 + (5.7209655324186315e-07)*bt_g0_6;
    bt_l1_21 = bt_l1_21 + (5.7345363302374608e-07)*bt_g0_7;
    bt_l1_21 = bt_l1_21 + (0.0060920068062841892)*bt_g0_8;
    bt_l1_21 = bt_l1_21 + (-5.673386453963758e-07)*bt_g0_9;
    bt_l1_21 = bt_l1_21 + (-0.00032119013485498726)*bt_g0_10;
    bt_l1_21 = bt_l1_21 + (-1.0482522156962659e-06)*bt_g0_11;
    bt_l1_21 = bt_l1_21 + (3.5985200952382002e-07)*bt_g0_12;
    bt_l1_21 = bt_l1_21 + (-0.0028174126055091619)*bt_g0_13;
    bt_l1_21 = bt_l1_21 + (-4.3657939841068583e-07)*bt_g0_14;
    bt_l1_21 = bt_l1_21 + (-3.8004318980711105e-07)*bt_g0_15;
    bt_l1_21 = bt_l1_21 + (0.00097830186132341623)*bt_g0_16;
    bt_l1_21 = bt_l1_21 + (0.0014902743278071284)*bt_g0_17;
    bt_l1_21 = bt_l1_21 + (-2.2134370283311e-06)*bt_g0_18;
    bt_l1_21 = bt_l1_21 + (5.4755179235144169e-07)*bt_g0_19;
    bt_l1_21 = bt_l1_21 + (5.6338762988161761e-07)*bt_g0_20;
    bt_l1_21 = bt_l1_21 + (-4.0161850733966276e-07)*bt_g0_21;
    bt_l1_21 = bt_l1_21 + (0.001506284112110734)*bt_g0_22;
    bt_l1_21 = bt_l1_21 + (-9.6659576342972287e-08)*bt_g0_23;
    bt_l1_21 = bt_l1_21 + (-6.2711501414014492e-07)*bt_g0_24;
    bt_l1_21 = bt_l1_21 + (-8.1023735276630759e-08)*bt_g0_25;
    bt_l1_21 = bt_l1_21 + (-7.719657446614292e-07)*bt_g0_26;
    bt_l1_21 = bt_l1_21 + (0.00053394981659948826)*bt_g0_27;
    bt_l1_21 = bt_l1_21 + (4.0172807302951696e-07)*bt_g0_28;
    bt_l1_21 = bt_l1_21 + (-3.0904768664186122e-06)*bt_g0_29;
    bt_l1_21 = bt_l1_21 + (4.8898704108069069e-07)*bt_g0_30;
    bt_l1_21 = bt_l1_21 + (-1.505178914840144e-07)*bt_g0_31;
    bt_l1_21 = bt_l1_21 + (5.7894050087270443e-07)*bt_g0_32;
    bt_l1_21 = bt_l1_21 + (1.6688640016582212e-06)*bt_g0_33;
    bt_l1_21 = bt_l1_21 + (4.9144273361889645e-07)*bt_g0_34;
    bt_l1_21 = bt_l1_21 + (-4.4127506271252059e-07)*bt_g0_35;
    bt_l1_21 = bt_l1_21 + (-4.8526754881095258e-07)*bt_g0_36;
    bt_l1_21 = bt_l1_21 + (9.7579565760952391e-08)*bt_g0_37;
    bt_l1_21 = bt_l1_21 + (-5.6200963172159391e-07)*bt_g0_38;
    bt_l1_21 = bt_l1_21 + (-1.0825879144249484e-06)*bt_g0_39;
    bt_l1_21 = bt_l1_21 + (5.8719007256513578e-07)*bt_g0_40;
    bt_l1_21 = bt_l1_21 + (5.1439684511933592e-07)*bt_g0_41;
    bt_l1_21 = bt_l1_21 + (6.062833222131303e-07)*bt_g0_42;
    bt_l1_21 = bt_l1_21 + (5.9926156836809241e-07)*bt_g0_43;
    bt_l1_21 = bt_l1_21 + (-2.1731362664922926e-07)*bt_g0_44;
    bt_l1_21 = bt_l1_21 + (-2.2656958265088178e-07)*bt_g0_45;
    bt_l1_21 = bt_l1_21 + (-5.3124642818147549e-07)*bt_g0_46;
    bt_l1_21 = bt_l1_21 + (-5.8438678252059617e-07)*bt_g0_47;
    bt_l1_21 = bt_l1_21 + (-5.8633094113247353e-07)*bt_g0_48;
    bt_l1_21 = bt_l1_21 + (3.2941375138761941e-07)*bt_g0_49;
    bt_l1_21 = bt_l1_21 + (3.8288872019620612e-06)*bt_g0_50;
    bt_l1_21 = bt_l1_21 + (5.7805783626463381e-07)*bt_g0_51;
    bt_l1_21 = bt_l1_21 + (2.516893005122256e-07)*bt_g0_52;
    bt_l1_21 = bt_l1_21 + (1.2184125353087438e-07)*bt_g0_53;
    bt_l1_21 = bt_l1_21 + (3.1934010991108153e-08)*bt_g0_54;
    bt_l1_21 = bt_l1_21 + (3.5448871926746506e-07)*bt_g0_55;
    bt_l1_21 = bt_l1_21 + (-3.6429096894607937e-07)*bt_g0_56;
    bt_l1_21 = bt_l1_21 + (-5.3611393013852648e-07)*bt_g0_57;
    bt_l1_21 = bt_l1_21 + (-0.0024408311583101749)*bt_g0_58;
    bt_l1_21 = bt_l1_21 + (-1.739426096492025e-07)*bt_g0_59;
    bt_l1_21 = bt_l1_21 + (2.1694802398997126e-06)*bt_g0_60;
    bt_l1_21 = bt_l1_21 + (5.5550776778545696e-07)*bt_g0_61;
    bt_l1_21 = bt_l1_21 + (-3.9691408915132342e-07)*bt_g0_62;
    bt_l1_21 = bt_l1_21 + (0.0014182849554345012)*bt_g0_63;
    bt_l1_22 = 0.0070156743749976158;
    bt_l1_22 = bt_l1_22 + (4.1091803382187209e-07)*bt_g0_0;
    bt_l1_22 = bt_l1_22 + (8.3303029896342196e-07)*bt_g0_1;
    bt_l1_22 = bt_l1_22 + (-0.0024481615982949734)*bt_g0_2;
    bt_l1_22 = bt_l1_22 + (-6.1843500986924482e-08)*bt_g0_3;
    bt_l1_22 = bt_l1_22 + (-1.7734345192366163e-07)*bt_g0_4;
    bt_l1_22 = bt_l1_22 + (4.5252392055772361e-07)*bt_g0_5;
    bt_l1_22 = bt_l1_22 + (5.7209484793929732e-07)*bt_g0_6;
    bt_l1_22 = bt_l1_22 + (5.7345164350408595e-07)*bt_g0_7;
    bt_l1_22 = bt_l1_22 + (0.0060919136740267277)*bt_g0_8;
    bt_l1_22 = bt_l1_22 + (-5.6733841802270035e-07)*bt_g0_9;
    bt_l1_22 = bt_l1_22 + (-0.00032118958188220859)*bt_g0_10;
    bt_l1_22 = bt_l1_22 + (-1.0482925745236571e-06)*bt_g0_11;
    bt_l1_22 = bt_l1_22 + (3.5984686519441311e-07)*bt_g0_12;
    bt_l1_22 = bt_l1_22 + (-0.0028173427563160658)*bt_g0_13;
    bt_l1_22 = bt_l1_22 + (-4.3657840365085576e-07)*bt_g0_14;
    bt_l1_22 = bt_l1_22 + (-3.8003969393685111e-07)*bt_g0_15;
    bt_l1_22 = bt_l1_22 + (0.00097807857673615217)*bt_g0_16;
    bt_l1_22 = bt_l1_22 + (0.0014902879483997822)*bt_g0_17;
    bt_l1_22 = bt_l1_22 + (-2.213443167420337e-06)*bt_g0_18;
    bt_l1_22 = bt_l1_22 + (5.4755383871452068e-07)*bt_g0_19;
    bt_l1_22 = bt_l1_22 + (5.6338637932640268e-07)*bt_g0_20;
    bt_l1_22 = bt_l1_22 + (-4.0161535252991598e-07)*bt_g0_21;
    bt_l1_22 = bt_l1_22 + (0.0015062793390825391)*bt_g0_22;
    bt_l1_22 = bt_l1_22 + (-9.6651447734075191e-08)*bt_g0_23;
    bt_l1_22 = bt_l1_22 + (-6.2711382042834884e-07)*bt_g0_24;
    bt_l1_22 = bt_l1_22 + (-8.1018100672736182e-08)*bt_g0_25;
    bt_l1_22 = bt_l1_22 + (-7.7193777769934968e-07)*bt_g0_26;
    bt_l1_22 = bt_l1_22 + (0.00053387472871690989)*bt_g0_27;
    bt_l1_22 = bt_l1_22 + (4.0173225102080323e-07)*bt_g0_28;
    bt_l1_22 = bt_l1_22 + (-3.0903859169484349e-06)*bt_g0_29;
    bt_l1_22 = bt_l1_22 + (4.8898414206632879e-07)*bt_g0_30;
    bt_l1_22 = bt_l1_22 + (-1.5051276136546221e-07)*bt_g0_31;
    bt_l1_22 = bt_l1_22 + (5.7893811344911228e-07)*bt_g0_32;
    bt_l1_22 = bt_l1_22 + (1.6688153436916764e-06)*bt_g0_33;
    bt_l1_22 = bt_l1_22 + (4.9144040303872316e-07)*bt_g0_34;
    bt_l1_22 = bt_l1_22 + (-4.4127156684226065e-07)*bt_g0_35;
    bt_l1_22 = bt_l1_22 + (-4.8526641194257536e-07)*bt_g0_36;
    bt_l1_22 = bt_l1_22 + (9.7573462198852212e-08)*bt_g0_37;
    bt_l1_22 = bt_l1_22 + (-5.6200764220193378e-07)*bt_g0_38;
    bt_l1_22 = bt_l1_22 + (-1.0825791605384438e-06)*bt_g0_39;
    bt_l1_22 = bt_l1_22 + (5.8718961781778489e-07)*bt_g0_40;
    bt_l1_22 = bt_l1_22 + (5.1439440085232491e-07)*bt_g0_41;
    bt_l1_22 = bt_l1_22 + (6.062827537789417e-07)*bt_g0_42;
    bt_l1_22 = bt_l1_22 + (5.9926151152467355e-07)*bt_g0_43;
    bt_l1_22 = bt_l1_22 + (-2.1730903654315625e-07)*bt_g0_44;
    bt_l1_22 = bt_l1_22 + (-2.2657475540199812e-07)*bt_g0_45;
    bt_l1_22 = bt_l1_22 + (-5.3124432497497764e-07)*bt_g0_46;
    bt_l1_22 = bt_l1_22 + (-5.8438519090486807e-07)*bt_g0_47;
    bt_l1_22 = bt_l1_22 + (-5.8633014532460948e-07)*bt_g0_48;
    bt_l1_22 = bt_l1_22 + (3.2940897654043511e-07)*bt_g0_49;
    bt_l1_22 = bt_l1_22 + (3.828763965429971e-06)*bt_g0_50;
    bt_l1_22 = bt_l1_22 + (5.7805914366326761e-07)*bt_g0_51;
    bt_l1_22 = bt_l1_22 + (2.5169396167257219e-07)*bt_g0_52;
    bt_l1_22 = bt_l1_22 + (1.2183947717403498e-07)*bt_g0_53;
    bt_l1_22 = bt_l1_22 + (3.1928060195696162e-08)*bt_g0_54;
    bt_l1_22 = bt_l1_22 + (3.5448448443275993e-07)*bt_g0_55;
    bt_l1_22 = bt_l1_22 + (-3.6429253214009805e-07)*bt_g0_56;
    bt_l1_22 = bt_l1_22 + (-5.3615690376318526e-07)*bt_g0_57;
    bt_l1_22 = bt_l1_22 + (-0.0024407582823187113)*bt_g0_58;
    bt_l1_22 = bt_l1_22 + (-1.7393877271842939e-07)*bt_g0_59;
    bt_l1_22 = bt_l1_22 + (2.1694897895940812e-06)*bt_g0_60;
    bt_l1_22 = bt_l1_22 + (5.5550685829075519e-07)*bt_g0_61;
    bt_l1_22 = bt_l1_22 + (-3.9691104802841437e-07)*bt_g0_62;
    bt_l1_22 = bt_l1_22 + (0.0014182860031723976)*bt_g0_63;
    bt_l1_23 = 0.007015611045062542;
    bt_l1_23 = bt_l1_23 + (4.1091971070272848e-07)*bt_g0_0;
    bt_l1_23 = bt_l1_23 + (8.3300477626835345e-07)*bt_g0_1;
    bt_l1_23 = bt_l1_23 + (-0.0024482253938913345)*bt_g0_2;
    bt_l1_23 = bt_l1_23 + (-6.183788059388462e-08)*bt_g0_3;
    bt_l1_23 = bt_l1_23 + (-1.7735837332111259e-07)*bt_g0_4;
    bt_l1_23 = bt_l1_23 + (4.5252778591020615e-07)*bt_g0_5;
    bt_l1_23 = bt_l1_23 + (5.7209712167605176e-07)*bt_g0_6;
    bt_l1_23 = bt_l1_23 + (5.7345408777109697e-07)*bt_g0_7;
    bt_l1_23 = bt_l1_23 + (0.006092047318816185)*bt_g0_8;
    bt_l1_23 = bt_l1_23 + (-5.6733875908321352e-07)*bt_g0_9;
    bt_l1_23 = bt_l1_23 + (-0.00032119292882271111)*bt_g0_10;
    bt_l1_23 = bt_l1_23 + (-1.0482424386282219e-06)*bt_g0_11;
    bt_l1_23 = bt_l1_23 + (3.598528337533935e-07)*bt_g0_12;
    bt_l1_23 = bt_l1_23 + (-0.0028173963073641062)*bt_g0_13;
    bt_l1_23 = bt_l1_23 + (-4.3657973947119899e-07)*bt_g0_14;
    bt_l1_23 = bt_l1_23 + (-3.800437013978808e-07)*bt_g0_15;
    bt_l1_23 = bt_l1_23 + (0.00097837578505277634)*bt_g0_16;
    bt_l1_23 = bt_l1_23 + (0.0014902849216014147)*bt_g0_17;
    bt_l1_23 = bt_l1_23 + (-2.2134295249998104e-06)*bt_g0_18;
    bt_l1_23 = bt_l1_23 + (5.4755116707383422e-07)*bt_g0_19;
    bt_l1_23 = bt_l1_23 + (5.6338797094213078e-07)*bt_g0_20;
    bt_l1_23 = bt_l1_23 + (-4.0161896208701364e-07)*bt_g0_21;
    bt_l1_23 = bt_l1_23 + (0.0015062823658809066)*bt_g0_22;
    bt_l1_23 = bt_l1_23 + (-9.666175770917107e-08)*bt_g0_23;
    bt_l1_23 = bt_l1_23 + (-6.2711524151382037e-07)*bt_g0_24;
    bt_l1_23 = bt_l1_23 + (-8.1024587927913672e-08)*bt_g0_25;
    bt_l1_23 = bt_l1_23 + (-7.7197108794280211e-07)*bt_g0_26;
    bt_l1_23 = bt_l1_23 + (0.00053395313443616033)*bt_g0_27;
    bt_l1_23 = bt_l1_23 + (4.0172747617361892e-07)*bt_g0_28;
    bt_l1_23 = bt_l1_23 + (-3.0904927825758932e-06)*bt_g0_29;
    bt_l1_23 = bt_l1_23 + (4.889876095148793e-07)*bt_g0_30;
    bt_l1_23 = bt_l1_23 + (-1.5051870150273317e-07)*bt_g0_31;
    bt_l1_23 = bt_l1_23 + (5.7894095562005532e-07)*bt_g0_32;
    bt_l1_23 = bt_l1_23 + (1.6688705954948091e-06)*bt_g0_33;
    bt_l1_23 = bt_l1_23 + (4.9144273361889645e-07)*bt_g0_34;
    bt_l1_23 = bt_l1_23 + (-4.4127551745987148e-07)*bt_g0_35;
    bt_l1_23 = bt_l1_23 + (-4.852676624977903e-07)*bt_g0_36;
    bt_l1_23 = bt_l1_23 + (9.7581320801509719e-08)*bt_g0_37;
    bt_l1_23 = bt_l1_23 + (-5.6200997278210707e-07)*bt_g0_38;
    bt_l1_23 = bt_l1_23 + (-1.0825865501828957e-06)*bt_g0_39;
    bt_l1_23 = bt_l1_23 + (5.8719029993881122e-07)*bt_g0_40;
    bt_l1_23 = bt_l1_23 + (5.1439735671010567e-07)*bt_g0_41;
    bt_l1_23 = bt_l1_23 + (6.0628337905654917e-07)*bt_g0_42;
    bt_l1_23 = bt_l1_23 + (5.9926219364569988e-07)*bt_g0_43;
    bt_l1_23 = bt_l1_23 + (-2.1731464983076876e-07)*bt_g0_44;
    bt_l1_23 = bt_l1_23 + (-2.2656864473447058e-07)*bt_g0_45;
    bt_l1_23 = bt_l1_23 + (-5.312469966156641e-07)*bt_g0_46;
    bt_l1_23 = bt_l1_23 + (-5.8438700989427161e-07)*bt_g0_47;
    bt_l1_23 = bt_l1_23 + (-5.8633139587982441e-07)*bt_g0_48;
    bt_l1_23 = bt_l1_23 + (3.2941446193035517e-07)*bt_g0_49;
    bt_l1_23 = bt_l1_23 + (3.8289067560981493e-06)*bt_g0_50;
    bt_l1_23 = bt_l1_23 + (5.7805772257779608e-07)*bt_g0_51;
    bt_l1_23 = bt_l1_23 + (2.5168841943923326e-07)*bt_g0_52;
    bt_l1_23 = bt_l1_23 + (1.2184180775420828e-07)*bt_g0_53;
    bt_l1_23 = bt_l1_23 + (3.1934845878822671e-08)*bt_g0_54;
    bt_l1_23 = bt_l1_23 + (3.5448923085823481e-07)*bt_g0_55;
    bt_l1_23 = bt_l1_23 + (-3.6428951943889842e-07)*bt_g0_56;
    bt_l1_23 = bt_l1_23 + (-5.3610312988894293e-07)*bt_g0_57;
    bt_l1_23 = bt_l1_23 + (-0.0024408444296568632)*bt_g0_58;
    bt_l1_23 = bt_l1_23 + (-1.7394339124621183e-07)*bt_g0_59;
    bt_l1_23 = bt_l1_23 + (2.1694741008104756e-06)*bt_g0_60;
    bt_l1_23 = bt_l1_23 + (5.5550805200255127e-07)*bt_g0_61;
    bt_l1_23 = bt_l1_23 + (-3.9691471442893089e-07)*bt_g0_62;
    bt_l1_23 = bt_l1_23 + (0.0014182989252731204)*bt_g0_63;
    bt_l1_24 = -0.024849347770214081;
    bt_l1_24 = bt_l1_24 + (-1.4532051295645942e-07)*bt_g0_0;
    bt_l1_24 = bt_l1_24 + (-2.1110954548930749e-05)*bt_g0_1;
    bt_l1_24 = bt_l1_24 + (0.11137226969003677)*bt_g0_2;
    bt_l1_24 = bt_l1_24 + (4.3347345126676373e-06)*bt_g0_3;
    bt_l1_24 = bt_l1_24 + (-1.5425639503519051e-05)*bt_g0_4;
    bt_l1_24 = bt_l1_24 + (1.4135142691884539e-06)*bt_g0_5;
    bt_l1_24 = bt_l1_24 + (3.888974902110931e-07)*bt_g0_6;
    bt_l1_24 = bt_l1_24 + (4.5660937075808761e-07)*bt_g0_7;
    bt_l1_24 = bt_l1_24 + (-0.017925901338458061)*bt_g0_8;
    bt_l1_24 = bt_l1_24 + (1.1820042118415586e-06)*bt_g0_9;
    bt_l1_24 = bt_l1_24 + (-0.018275715410709381)*bt_g0_10;
    bt_l1_24 = bt_l1_24 + (7.5837800977751613e-05)*bt_g0_11;
    bt_l1_24 = bt_l1_24 + (2.9952939257782418e-06)*bt_g0_12;
    bt_l1_24 = bt_l1_24 + (0.0071332463994622231)*bt_g0_13;
    bt_l1_24 = bt_l1_24 + (2.4089550265671278e-07)*bt_g0_14;
    bt_l1_24 = bt_l1_24 + (-1.7535952565594926e-06)*bt_g0_15;
    bt_l1_24 = bt_l1_24 + (0.0051943296566605568)*bt_g0_16;
    bt_l1_24 = bt_l1_24 + (-0.092180393636226654)*bt_g0_17;
    bt_l1_24 = bt_l1_24 + (5.9412435803096741e-05)*bt_g0_18;
    bt_l1_24 = bt_l1_24 + (-6.0926040532649495e-06)*bt_g0_19;
    bt_l1_24 = bt_l1_24 + (-8.0638130839361111e-08)*bt_g0_20;
    bt_l1_24 = bt_l1_24 + (-1.4252316304919077e-06)*bt_g0_21;
    bt_l1_24 = bt_l1_24 + (-0.18283557891845703)*bt_g0_22;
    bt_l1_24 = bt_l1_24 + (-1.0958763596136123e-05)*bt_g0_23;
    bt_l1_24 = bt_l1_24 + (1.842555263920076e-07)*bt_g0_24;
    bt_l1_24 = bt_l1_24 + (-4.0145532693713903e-06)*bt_g0_25;
    bt_l1_24 = bt_l1_24 + (-1.2988884918740951e-05)*bt_g0_26;
    bt_l1_24 = bt_l1_24 + (0.084186822175979614)*bt_g0_27;
    bt_l1_24 = bt_l1_24 + (-5.9152644098503515e-06)*bt_g0_28;
    bt_l1_24 = bt_l1_24 + (1.975391114683589e-06)*bt_g0_29;
    bt_l1_24 = bt_l1_24 + (1.0523328910494456e-06)*bt_g0_30;
    bt_l1_24 = bt_l1_24 + (-3.4987797334906645e-06)*bt_g0_31;
    bt_l1_24 = bt_l1_24 + (8.4514806530933129e-07)*bt_g0_32;
    bt_l1_24 = bt_l1_24 + (-2.5059396193682915e-06)*bt_g0_33;
    bt_l1_24 = bt_l1_24 + (-5.3917847253615037e-06)*bt_g0_34;
    bt_l1_24 = bt_l1_24 + (-1.6450609336970956e-06)*bt_g0_35;
    bt_l1_24 = bt_l1_24 + (4.3248593328826246e-07)*bt_g0_36;
    bt_l1_24 = bt_l1_24 + (7.9772235039854422e-06)*bt_g0_37;
    bt_l1_24 = bt_l1_24 + (-3.2652684467393556e-07)*bt_g0_38;
    bt_l1_24 = bt_l1_24 + (2.1838081011082977e-05)*bt_g0_39;
    bt_l1_24 = bt_l1_24 + (-6.2381127463595476e-07)*bt_g0_40;
    bt_l1_24 = bt_l1_24 + (1.0110228458870552e-06)*bt_g0_41;
    bt_l1_24 = bt_l1_24 + (-9.3176390691951383e-07)*bt_g0_42;
    bt_l1_24 = bt_l1_24 + (-8.7450325736426748e-07)*bt_g0_43;
    bt_l1_24 = bt_l1_24 + (-3.118676886515459e-06)*bt_g0_44;
    bt_l1_24 = bt_l1_24 + (5.3048688641865738e-06)*bt_g0_45;
    bt_l1_24 = bt_l1_24 + (-9.6995597687055124e-07)*bt_g0_46;
    bt_l1_24 = bt_l1_24 + (-8.2917217980593705e-08)*bt_g0_47;
    bt_l1_24 = bt_l1_24 + (3.4795090186889865e-07)*bt_g0_48;
    bt_l1_24 = bt_l1_24 + (1.2433794154276256e-06)*bt_g0_49;
    bt_l1_24 = bt_l1_24 + (3.4568593036965467e-06)*bt_g0_50;
    bt_l1_24 = bt_l1_24 + (-2.8061031116521917e-06)*bt_g0_51;
    bt_l1_24 = bt_l1_24 + (-5.4425495363830123e-06)*bt_g0_52;
    bt_l1_24 = bt_l1_24 + (1.9222027276555309e-06)*bt_g0_53;
    bt_l1_24 = bt_l1_24 + (4.2544584175630007e-06)*bt_g0_54;
    bt_l1_24 = bt_l1_24 + (2.1597002159978729e-06)*bt_g0_55;
    bt_l1_24 = bt_l1_24 + (1.4292645573732443e-05)*bt_g0_56;
    bt_l1_24 = bt_l1_24 + (5.61072192795109e-05)*bt_g0_57;
    bt_l1_24 = bt_l1_24 + (0.21115176379680634)*bt_g0_58;
    bt_l1_24 = bt_l1_24 + (-2.6211091608274728e-06)*bt_g0_59;
    bt_l1_24 = bt_l1_24 + (-6.0356305766617879e-05)*bt_g0_60;
    bt_l1_24 = bt_l1_24 + (-3.9264793372240092e-07)*bt_g0_61;
    bt_l1_24 = bt_l1_24 + (-1.4950765034882352e-06)*bt_g0_62;
    bt_l1_24 = bt_l1_24 + (-0.01750434935092926)*bt_g0_63;
    bt_l1_25 = 0.0070156296715140343;
    bt_l1_25 = bt_l1_25 + (4.1091931279879645e-07)*bt_g0_0;
    bt_l1_25 = bt_l1_25 + (8.330097784892132e-07)*bt_g0_1;
    bt_l1_25 = bt_l1_25 + (-0.0024482135195285082)*bt_g0_2;
    bt_l1_25 = bt_l1_25 + (-6.1838584031193022e-08)*bt_g0_3;
    bt_l1_25 = bt_l1_25 + (-1.7735543167418655e-07)*bt_g0_4;
    bt_l1_25 = bt_l1_25 + (4.5252747327140241e-07)*bt_g0_5;
    bt_l1_25 = bt_l1_25 + (5.7209678061553859e-07)*bt_g0_6;
    bt_l1_25 = bt_l1_25 + (5.7345391724084038e-07)*bt_g0_7;
    bt_l1_25 = bt_l1_25 + (0.0060920338146388531)*bt_g0_8;
    bt_l1_25 = bt_l1_25 + (-5.6733875908321352e-07)*bt_g0_9;
    bt_l1_25 = bt_l1_25 + (-0.00032119191018864512)*bt_g0_10;
    bt_l1_25 = bt_l1_25 + (-1.0482532388778054e-06)*bt_g0_11;
    bt_l1_25 = bt_l1_25 + (3.598521800540766e-07)*bt_g0_12;
    bt_l1_25 = bt_l1_25 + (-0.0028174102772027254)*bt_g0_13;
    bt_l1_25 = bt_l1_25 + (-4.3657971104948956e-07)*bt_g0_14;
    bt_l1_25 = bt_l1_25 + (-3.8004324665052991e-07)*bt_g0_15;
    bt_l1_25 = bt_l1_25 + (0.00097832782194018364)*bt_g0_16;
    bt_l1_25 = bt_l1_25 + (0.0014902797993272543)*bt_g0_17;
    bt_l1_25 = bt_l1_25 + (-2.2134370283311e-06)*bt_g0_18;
    bt_l1_25 = bt_l1_25 + (5.4755190603827941e-07)*bt_g0_19;
    bt_l1_25 = bt_l1_25 + (5.633878004118742e-07)*bt_g0_20;
    bt_l1_25 = bt_l1_25 + (-4.0161864944820991e-07)*bt_g0_21;
    bt_l1_25 = bt_l1_25 + (0.0015062903985381126)*bt_g0_22;
    bt_l1_25 = bt_l1_25 + (-9.6659704240664723e-08)*bt_g0_23;
    bt_l1_25 = bt_l1_25 + (-6.2711524151382037e-07)*bt_g0_24;
    bt_l1_25 = bt_l1_25 + (-8.1023806330904335e-08)*bt_g0_25;
    bt_l1_25 = bt_l1_25 + (-7.719673362771573e-07)*bt_g0_26;
    bt_l1_25 = bt_l1_25 + (0.00053395080612972379)*bt_g0_27;
    bt_l1_25 = bt_l1_25 + (4.0172827198148298e-07)*bt_g0_28;
    bt_l1_25 = bt_l1_25 + (-3.0904780032869894e-06)*bt_g0_29;
    bt_l1_25 = bt_l1_25 + (4.8898732529778499e-07)*bt_g0_30;
    bt_l1_25 = bt_l1_25 + (-1.5051803359256155e-07)*bt_g0_31;
    bt_l1_25 = bt_l1_25 + (5.7894072824637988e-07)*bt_g0_32;
    bt_l1_25 = bt_l1_25 + (1.6688647974660853e-06)*bt_g0_33;
    bt_l1_25 = bt_l1_25 + (4.9144301783599076e-07)*bt_g0_34;
    bt_l1_25 = bt_l1_25 + (-4.4127509113423002e-07)*bt_g0_35;
    bt_l1_25 = bt_l1_25 + (-4.8526760565437144e-07)*bt_g0_36;
    bt_l1_25 = bt_l1_25 + (9.7579956559457059e-08)*bt_g0_37;
    bt_l1_25 = bt_l1_25 + (-5.6200957487817504e-07)*bt_g0_38;
    bt_l1_25 = bt_l1_25 + (-1.0825880281117861e-06)*bt_g0_39;
    bt_l1_25 = bt_l1_25 + (5.871901862519735e-07)*bt_g0_40;
    bt_l1_25 = bt_l1_25 + (5.143970156495925e-07)*bt_g0_41;
    bt_l1_25 = bt_l1_25 + (6.0628366327364347e-07)*bt_g0_42;
    bt_l1_25 = bt_l1_25 + (5.9926190942860558e-07)*bt_g0_43;
    bt_l1_25 = bt_l1_25 + (-2.1731383981204999e-07)*bt_g0_44;
    bt_l1_25 = bt_l1_25 + (-2.2656966791601008e-07)*bt_g0_45;
    bt_l1_25 = bt_l1_25 + (-5.3124676924198866e-07)*bt_g0_46;
    bt_l1_25 = bt_l1_25 + (-5.8438700989427161e-07)*bt_g0_47;
    bt_l1_25 = bt_l1_25 + (-5.8633122534956783e-07)*bt_g0_48;
    bt_l1_25 = bt_l1_25 + (3.2941395033958543e-07)*bt_g0_49;
    bt_l1_25 = bt_l1_25 + (3.8288917494355701e-06)*bt_g0_50;
    bt_l1_25 = bt_l1_25 + (5.7805800679489039e-07)*bt_g0_51;
    bt_l1_25 = bt_l1_25 + (2.5168921524709731e-07)*bt_g0_52;
    bt_l1_25 = bt_l1_25 + (1.2184140985027625e-07)*bt_g0_53;
    bt_l1_25 = bt_l1_25 + (3.1934209943074165e-08)*bt_g0_54;
    bt_l1_25 = bt_l1_25 + (3.5448880453259335e-07)*bt_g0_55;
    bt_l1_25 = bt_l1_25 + (-3.642907131506945e-07)*bt_g0_56;
    bt_l1_25 = bt_l1_25 + (-5.3611313433066243e-07)*bt_g0_57;
    bt_l1_25 = bt_l1_25 + (-0.0024408320896327496)*bt_g0_58;
    bt_l1_25 = bt_l1_25 + (-1.7394262386005721e-07)*bt_g0_59;
    bt_l1_25 = bt_l1_25 + (2.1694791030313354e-06)*bt_g0_60;
    bt_l1_25 = bt_l1_25 + (5.5550788147229468e-07)*bt_g0_61;
    bt_l1_25 = bt_l1_25 + (-3.9691423125987058e-07)*bt_g0_62;
    bt_l1_25 = bt_l1_25 + (0.0014183031162247062)*bt_g0_63;
    bt_l1_26 = 0.0070156357251107693;
    bt_l1_26 = bt_l1_26 + (4.1091905700341158e-07)*bt_g0_0;
    bt_l1_26 = bt_l1_26 + (8.3301495124032954e-07)*bt_g0_1;
    bt_l1_26 = bt_l1_26 + (-0.0024481955915689468)*bt_g0_2;
    bt_l1_26 = bt_l1_26 + (-6.1840047749228688e-08)*bt_g0_3;
    bt_l1_26 = bt_l1_26 + (-1.7735266055751708e-07)*bt_g0_4;
    bt_l1_26 = bt_l1_26 + (4.5252647851157235e-07)*bt_g0_5;
    bt_l1_26 = bt_l1_26 + (5.7209609849451226e-07)*bt_g0_6;
    bt_l1_26 = bt_l1_26 + (5.7345306458955747e-07)*bt_g0_7;
    bt_l1_26 = bt_l1_26 + (0.0060919891111552715)*bt_g0_8;
    bt_l1_26 = bt_l1_26 + (-5.6733858855295694e-07)*bt_g0_9;
    bt_l1_26 = bt_l1_26 + (-0.00032119001843966544)*bt_g0_10;
    bt_l1_26 = bt_l1_26 + (-1.048260742209095e-06)*bt_g0_11;
    bt_l1_26 = bt_l1_26 + (3.5985073054689565e-07)*bt_g0_12;
    bt_l1_26 = bt_l1_26 + (-0.0028173751197755337)*bt_g0_13;
    bt_l1_26 = bt_l1_26 + (-4.3657914261530095e-07)*bt_g0_14;
    bt_l1_26 = bt_l1_26 + (-3.8004210978215269e-07)*bt_g0_15;
    bt_l1_26 = bt_l1_26 + (0.00097825669217854738)*bt_g0_16;
    bt_l1_26 = bt_l1_26 + (0.0014902910916134715)*bt_g0_17;
    bt_l1_26 = bt_l1_26 + (-2.2134377104521263e-06)*bt_g0_18;
    bt_l1_26 = bt_l1_26 + (5.4755201972511713e-07)*bt_g0_19;
    bt_l1_26 = bt_l1_26 + (5.6338717513426673e-07)*bt_g0_20;
    bt_l1_26 = bt_l1_26 + (-4.016174273147044e-07)*bt_g0_21;
    bt_l1_26 = bt_l1_26 + (0.0015062844613566995)*bt_g0_22;
    bt_l1_26 = bt_l1_26 + (-9.6657579717884801e-08)*bt_g0_23;
    bt_l1_26 = bt_l1_26 + (-6.271149004533072e-07)*bt_g0_24;
    bt_l1_26 = bt_l1_26 + (-8.102234261286867e-08)*bt_g0_25;
    bt_l1_26 = bt_l1_26 + (-7.719586392340716e-07)*bt_g0_26;
    bt_l1_26 = bt_l1_26 + (0.00053392688278108835)*bt_g0_27;
    bt_l1_26 = bt_l1_26 + (4.0172926674131304e-07)*bt_g0_28;
    bt_l1_26 = bt_l1_26 + (-3.0904511731932871e-06)*bt_g0_29;
    bt_l1_26 = bt_l1_26 + (4.8898590421231347e-07)*bt_g0_30;
    bt_l1_26 = bt_l1_26 + (-1.5051645618768816e-07)*bt_g0_31;
    bt_l1_26 = bt_l1_26 + (5.7893970506484038e-07)*bt_g0_32;
    bt_l1_26 = bt_l1_26 + (1.6688513824192341e-06)*bt_g0_33;
    bt_l1_26 = bt_l1_26 + (4.9144176728077582e-07)*bt_g0_34;
    bt_l1_26 = bt_l1_26 + (-4.412740395309811e-07)*bt_g0_35;
    bt_l1_26 = bt_l1_26 + (-4.8526720775043941e-07)*bt_g0_36;
    bt_l1_26 = bt_l1_26 + (9.7578421787147818e-08)*bt_g0_37;
    bt_l1_26 = bt_l1_26 + (-5.620090632874053e-07)*bt_g0_38;
    bt_l1_26 = bt_l1_26 + (-1.0825840490724659e-06)*bt_g0_39;
    bt_l1_26 = bt_l1_26 + (5.8718995887829806e-07)*bt_g0_40;
    bt_l1_26 = bt_l1_26 + (5.1439627668514731e-07)*bt_g0_41;
    bt_l1_26 = bt_l1_26 + (6.0628298115261714e-07)*bt_g0_42;
    bt_l1_26 = bt_l1_26 + (5.9926145468125469e-07)*bt_g0_43;
    bt_l1_26 = bt_l1_26 + (-2.1731246135914262e-07)*bt_g0_44;
    bt_l1_26 = bt_l1_26 + (-2.2657097531464387e-07)*bt_g0_45;
    bt_l1_26 = bt_l1_26 + (-5.3124580290386803e-07)*bt_g0_46;
    bt_l1_26 = bt_l1_26 + (-5.8438627092982642e-07)*bt_g0_47;
    bt_l1_26 = bt_l1_26 + (-5.863308274456358e-07)*bt_g0_48;
    bt_l1_26 = bt_l1_26 + (3.2941235872385732e-07)*bt_g0_49;
    bt_l1_26 = bt_l1_26 + (3.8288540054054465e-06)*bt_g0_50;
    bt_l1_26 = bt_l1_26 + (5.7805817732514697e-07)*bt_g0_51;
    bt_l1_26 = bt_l1_26 + (2.5169052264573111e-07)*bt_g0_52;
    bt_l1_26 = bt_l1_26 + (1.218408982595065e-07)*bt_g0_53;
    bt_l1_26 = bt_l1_26 + (3.1932376742815904e-08)*bt_g0_54;
    bt_l1_26 = bt_l1_26 + (3.5448749713395955e-07)*bt_g0_55;
    bt_l1_26 = bt_l1_26 + (-3.6429059946385678e-07)*bt_g0_56;
    bt_l1_26 = bt_l1_26 + (-5.3612313877238194e-07)*bt_g0_57;
    bt_l1_26 = bt_l1_26 + (-0.0024408048484474421)*bt_g0_58;
    bt_l1_26 = bt_l1_26 + (-1.7394147278082528e-07)*bt_g0_59;
    bt_l1_26 = bt_l1_26 + (2.1694804672733881e-06)*bt_g0_60;
    bt_l1_26 = bt_l1_26 + (5.5550736988152494e-07)*bt_g0_61;
    bt_l1_26 = bt_l1_26 + (-3.9691337860858766e-07)*bt_g0_62;
    bt_l1_26 = bt_l1_26 + (0.0014182747108861804)*bt_g0_63;
    bt_l1_27 = 0.0070156133733689785;
    bt_l1_27 = bt_l1_27 + (4.1091939806392475e-07)*bt_g0_0;
    bt_l1_27 = bt_l1_27 + (8.3300784581297194e-07)*bt_g0_1;
    bt_l1_27 = bt_l1_27 + (-0.002448210259899497)*bt_g0_2;
    bt_l1_27 = bt_l1_27 + (-6.1838527187774162e-08)*bt_g0_3;
    bt_l1_27 = bt_l1_27 + (-1.7735565904786199e-07)*bt_g0_4;
    bt_l1_27 = bt_l1_27 + (4.5252730274114583e-07)*bt_g0_5;
    bt_l1_27 = bt_l1_27 + (5.7209666692870087e-07)*bt_g0_6;
    bt_l1_27 = bt_l1_27 + (5.7345363302374608e-07)*bt_g0_7;
    bt_l1_27 = bt_l1_27 + (0.0060920100659132004)*bt_g0_8;
    bt_l1_27 = bt_l1_27 + (-5.6733858855295694e-07)*bt_g0_9;
    bt_l1_27 = bt_l1_27 + (-0.00032119126990437508)*bt_g0_10;
    bt_l1_27 = bt_l1_27 + (-1.0482508514542133e-06)*bt_g0_11;
    bt_l1_27 = bt_l1_27 + (3.5985203794552945e-07)*bt_g0_12;
    bt_l1_27 = bt_l1_27 + (-0.0028173842001706362)*bt_g0_13;
    bt_l1_27 = bt_l1_27 + (-4.3657959736265184e-07)*bt_g0_14;
    bt_l1_27 = bt_l1_27 + (-3.8004321822882048e-07)*bt_g0_15;
    bt_l1_27 = bt_l1_27 + (0.00097833329346030951)*bt_g0_16;
    bt_l1_27 = bt_l1_27 + (0.0014903000555932522)*bt_g0_17;
    bt_l1_27 = bt_l1_27 + (-2.2134340724733192e-06)*bt_g0_18;
    bt_l1_27 = bt_l1_27 + (5.4755184919486055e-07)*bt_g0_19;
    bt_l1_27 = bt_l1_27 + (5.6338768672503647e-07)*bt_g0_20;
    bt_l1_27 = bt_l1_27 + (-4.0161842207453446e-07)*bt_g0_21;
    bt_l1_27 = bt_l1_27 + (0.0015062877209857106)*bt_g0_22;
    bt_l1_27 = bt_l1_27 + (-9.6659903192630736e-08)*bt_g0_23;
    bt_l1_27 = bt_l1_27 + (-6.2711507098356378e-07)*bt_g0_24;
    bt_l1_27 = bt_l1_27 + (-8.1023870279750554e-08)*bt_g0_25;
    bt_l1_27 = bt_l1_27 + (-7.7196790471134591e-07)*bt_g0_26;
    bt_l1_27 = bt_l1_27 + (0.00053394725546240807)*bt_g0_27;
    bt_l1_27 = bt_l1_27 + (4.0172815829464525e-07)*bt_g0_28;
    bt_l1_27 = bt_l1_27 + (-3.0904775485396385e-06)*bt_g0_29;
    bt_l1_27 = bt_l1_27 + (4.8898704108069069e-07)*bt_g0_30;
    bt_l1_27 = bt_l1_27 + (-1.5051794832743326e-07)*bt_g0_31;
    bt_l1_27 = bt_l1_27 + (5.7894038718586671e-07)*bt_g0_32;
    bt_l1_27 = bt_l1_27 + (1.668864115345059e-06)*bt_g0_33;
    bt_l1_27 = bt_l1_27 + (4.9144261993205873e-07)*bt_g0_34;
    bt_l1_27 = bt_l1_27 + (-4.4127503429081116e-07)*bt_g0_35;
    bt_l1_27 = bt_l1_27 + (-4.8526754881095258e-07)*bt_g0_36;
    bt_l1_27 = bt_l1_27 + (9.7579963664884417e-08)*bt_g0_37;
    bt_l1_27 = bt_l1_27 + (-5.620093475044996e-07)*bt_g0_38;
    bt_l1_27 = bt_l1_27 + (-1.0825870049302466e-06)*bt_g0_39;
    bt_l1_27 = bt_l1_27 + (5.871901862519735e-07)*bt_g0_40;
    bt_l1_27 = bt_l1_27 + (5.1439678827591706e-07)*bt_g0_41;
    bt_l1_27 = bt_l1_27 + (6.0628326536971144e-07)*bt_g0_42;
    bt_l1_27 = bt_l1_27 + (5.9926145468125469e-07)*bt_g0_43;
    bt_l1_27 = bt_l1_27 + (-2.1731385402290471e-07)*bt_g0_44;
    bt_l1_27 = bt_l1_27 + (-2.2656949738575349e-07)*bt_g0_45;
    bt_l1_27 = bt_l1_27 + (-5.3124648502489435e-07)*bt_g0_46;
    bt_l1_27 = bt_l1_27 + (-5.8438678252059617e-07)*bt_g0_47;
    bt_l1_27 = bt_l1_27 + (-5.8633105481931125e-07)*bt_g0_48;
    bt_l1_27 = bt_l1_27 + (3.2941375138761941e-07)*bt_g0_49;
    bt_l1_27 = bt_l1_27 + (3.8288908399408683e-06)*bt_g0_50;
    bt_l1_27 = bt_l1_27 + (5.7805777942121495e-07)*bt_g0_51;
    bt_l1_27 = bt_l1_27 + (2.5168910156025959e-07)*bt_g0_52;
    bt_l1_27 = bt_l1_27 + (1.218414524828404e-07)*bt_g0_53;
    bt_l1_27 = bt_l1_27 + (3.1933979016685043e-08)*bt_g0_54;
    bt_l1_27 = bt_l1_27 + (3.5448863400233677e-07)*bt_g0_55;
    bt_l1_27 = bt_l1_27 + (-3.6429022998163418e-07)*bt_g0_56;
    bt_l1_27 = bt_l1_27 + (-5.3611000794262509e-07)*bt_g0_57;
    bt_l1_27 = bt_l1_27 + (-0.0024408085737377405)*bt_g0_58;
    bt_l1_27 = bt_l1_27 + (-1.7394268070347607e-07)*bt_g0_59;
    bt_l1_27 = bt_l1_27 + (2.1694766019209055e-06)*bt_g0_60;
    bt_l1_27 = bt_l1_27 + (5.5550776778545696e-07)*bt_g0_61;
    bt_l1_27 = bt_l1_27 + (-3.9691414599474228e-07)*bt_g0_62;
    bt_l1_27 = bt_l1_27 + (0.0014182858867570758)*bt_g0_63;
    bt_l1_28 = 0.010179141536355019;
    bt_l1_28 = bt_l1_28 + (3.7188838177826256e-06)*bt_g0_0;
    bt_l1_28 = bt_l1_28 + (-3.2866512356122257e-07)*bt_g0_1;
    bt_l1_28 = bt_l1_28 + (-0.090083539485931396)*bt_g0_2;
    bt_l1_28 = bt_l1_28 + (-1.087453938453109e-06)*bt_g0_3;
    bt_l1_28 = bt_l1_28 + (2.3810591756046051e-06)*bt_g0_4;
    bt_l1_28 = bt_l1_28 + (3.606204245443223e-06)*bt_g0_5;
    bt_l1_28 = bt_l1_28 + (4.64471531813615e-06)*bt_g0_6;
    bt_l1_28 = bt_l1_28 + (4.6592040234827437e-06)*bt_g0_7;
    bt_l1_28 = bt_l1_28 + (0.037498056888580322)*bt_g0_8;
    bt_l1_28 = bt_l1_28 + (-4.5356218834058382e-06)*bt_g0_9;
    bt_l1_28 = bt_l1_28 + (0.021973861381411552)*bt_g0_10;
    bt_l1_28 = bt_l1_28 + (-1.1798455489042681e-05)*bt_g0_11;
    bt_l1_28 = bt_l1_28 + (2.5155823095701635e-06)*bt_g0_12;
    bt_l1_28 = bt_l1_28 + (0.08374999463558197)*bt_g0_13;
    bt_l1_28 = bt_l1_28 + (-3.9615024434169754e-06)*bt_g0_14;
    bt_l1_28 = bt_l1_28 + (-2.9006200747971889e-06)*bt_g0_15;
    bt_l1_28 = bt_l1_28 + (-0.10931237787008286)*bt_g0_16;
    bt_l1_28 = bt_l1_28 + (0.21139818429946899)*bt_g0_17;
    bt_l1_28 = bt_l1_28 + (3.3235401133424602e-06)*bt_g0_18;
    bt_l1_28 = bt_l1_28 + (2.8786125767510384e-06)*bt_g0_19;
    bt_l1_28 = bt_l1_28 + (4.4798739509133156e-06)*bt_g0_20;
    bt_l1_28 = bt_l1_28 + (-3.1192791993817082e-06)*bt_g0_21;
    bt_l1_28 = bt_l1_28 + (0.0013849489623680711)*bt_g0_22;
    bt_l1_28 = bt_l1_28 + (1.5476283579118899e-06)*bt_g0_23;
    bt_l1_28 = bt_l1_28 + (-4.7676953727204818e-06)*bt_g0_24;
    bt_l1_28 = bt_l1_28 + (-1.887795946231563e-07)*bt_g0_25;
    bt_l1_28 = bt_l1_28 + (1.6493646398885176e-05)*bt_g0_26;
    bt_l1_28 = bt_l1_28 + (0.0077654612250626087)*bt_g0_27;
    bt_l1_28 = bt_l1_28 + (3.1497706913796719e-06)*bt_g0_28;
    bt_l1_28 = bt_l1_28 + (5.6909808336058632e-05)*bt_g0_29;
    bt_l1_28 = bt_l1_28 + (4.2145616134803277e-06)*bt_g0_30;
    bt_l1_28 = bt_l1_28 + (-7.9167824651449337e-07)*bt_g0_31;
    bt_l1_28 = bt_l1_28 + (4.1960279304475989e-06)*bt_g0_32;
    bt_l1_28 = bt_l1_28 + (-3.132922574877739e-05)*bt_g0_33;
    bt_l1_28 = bt_l1_28 + (4.4012452349306841e-07)*bt_g0_34;
    bt_l1_28 = bt_l1_28 + (-3.5289199331600685e-06)*bt_g0_35;
    bt_l1_28 = bt_l1_28 + (-4.363333573564887e-06)*bt_g0_36;
    bt_l1_28 = bt_l1_28 + (-2.8076302172053147e-08)*bt_g0_37;
    bt_l1_28 = bt_l1_28 + (-4.5560477701656055e-06)*bt_g0_38;
    bt_l1_28 = bt_l1_28 + (7.2840493885450996e-06)*bt_g0_39;
    bt_l1_28 = bt_l1_28 + (4.515876298682997e-06)*bt_g0_40;
    bt_l1_28 = bt_l1_28 + (4.1682510527607519e-06)*bt_g0_41;
    bt_l1_28 = bt_l1_28 + (4.6534264583897311e-06)*bt_g0_42;
    bt_l1_28 = bt_l1_28 + (4.5922165554657113e-06)*bt_g0_43;
    bt_l1_28 = bt_l1_28 + (-1.3860455965186702e-06)*bt_g0_44;
    bt_l1_28 = bt_l1_28 + (-2.3154884729592595e-06)*bt_g0_45;
    bt_l1_28 = bt_l1_28 + (-4.1322164179291576e-06)*bt_g0_46;
    bt_l1_28 = bt_l1_28 + (-4.5809961193299387e-06)*bt_g0_47;
    bt_l1_28 = bt_l1_28 + (-4.5584874897031114e-06)*bt_g0_48;
    bt_l1_28 = bt_l1_28 + (-7.3951088097601314e-07)*bt_g0_49;
    bt_l1_28 = bt_l1_28 + (-7.6114120020065457e-05)*bt_g0_50;
    bt_l1_28 = bt_l1_28 + (2.9361603992583696e-06)*bt_g0_51;
    bt_l1_28 = bt_l1_28 + (2.5147928681690246e-06)*bt_g0_52;
    bt_l1_28 = bt_l1_28 + (5.9329335044822074e-07)*bt_g0_53;
    bt_l1_28 = bt_l1_28 + (-2.3832866702377942e-07)*bt_g0_54;
    bt_l1_28 = bt_l1_28 + (2.7102792046207469e-06)*bt_g0_55;
    bt_l1_28 = bt_l1_28 + (1.9735498426598497e-06)*bt_g0_56;
    bt_l1_28 = bt_l1_28 + (-7.8520761235267855e-06)*bt_g0_57;
    bt_l1_28 = bt_l1_28 + (0.0085708051919937134)*bt_g0_58;
    bt_l1_28 = bt_l1_28 + (-8.3766121861117426e-07)*bt_g0_59;
    bt_l1_28 = bt_l1_28 + (-2.4289440716529498e-06)*bt_g0_60;
    bt_l1_28 = bt_l1_28 + (4.4332609832054004e-06)*bt_g0_61;
    bt_l1_28 = bt_l1_28 + (-3.0439080092037329e-06)*bt_g0_62;
    bt_l1_28 = bt_l1_28 + (-0.050908148288726807)*bt_g0_63;
    bt_l1_29 = 0.007015598937869072;
    bt_l1_29 = bt_l1_29 + (4.1092005176324164e-07)*bt_g0_0;
    bt_l1_29 = bt_l1_29 + (8.3300199094082927e-07)*bt_g0_1;
    bt_l1_29 = bt_l1_29 + (-0.0024482330773025751)*bt_g0_2;
    bt_l1_29 = bt_l1_29 + (-6.18373476868328e-08)*bt_g0_3;
    bt_l1_29 = bt_l1_29 + (-1.7735914070726722e-07)*bt_g0_4;
    bt_l1_29 = bt_l1_29 + (4.5252841118781362e-07)*bt_g0_5;
    bt_l1_29 = bt_l1_29 + (5.7209746273656492e-07)*bt_g0_6;
    bt_l1_29 = bt_l1_29 + (5.7345448567502899e-07)*bt_g0_7;
    bt_l1_29 = bt_l1_29 + (0.0060920305550098419)*bt_g0_8;
    bt_l1_29 = bt_l1_29 + (-5.6733915698714554e-07)*bt_g0_9;
    bt_l1_29 = bt_l1_29 + (-0.00032119153183884919)*bt_g0_10;
    bt_l1_29 = bt_l1_29 + (-1.0482381185283884e-06)*bt_g0_11;
    bt_l1_29 = bt_l1_29 + (3.5985351587441983e-07)*bt_g0_12;
    bt_l1_29 = bt_l1_29 + (-0.0028174147009849548)*bt_g0_13;
    bt_l1_29 = bt_l1_29 + (-4.3658019421854988e-07)*bt_g0_14;
    bt_l1_29 = bt_l1_29 + (-3.8004424141035997e-07)*bt_g0_15;
    bt_l1_29 = bt_l1_29 + (0.00097839604131877422)*bt_g0_16;
    bt_l1_29 = bt_l1_29 + (0.001490294118411839)*bt_g0_17;
    bt_l1_29 = bt_l1_29 + (-2.2134292976261349e-06)*bt_g0_18;
    bt_l1_29 = bt_l1_29 + (5.4755128076067194e-07)*bt_g0_19;
    bt_l1_29 = bt_l1_29 + (5.6338831200264394e-07)*bt_g0_20;
    bt_l1_29 = bt_l1_29 + (-4.0161955894291168e-07)*bt_g0_21;
    bt_l1_29 = bt_l1_29 + (0.0015062947059050202)*bt_g0_22;
    bt_l1_29 = bt_l1_29 + (-9.6662091664256877e-08)*bt_g0_23;
    bt_l1_29 = bt_l1_29 + (-6.2711563941775239e-07)*bt_g0_24;
    bt_l1_29 = bt_l1_29 + (-8.1025369524923008e-08)*bt_g0_25;
    bt_l1_29 = bt_l1_29 + (-7.7197370274006971e-07)*bt_g0_26;
    bt_l1_29 = bt_l1_29 + (0.00053397536976262927)*bt_g0_27;
    bt_l1_29 = bt_l1_29 + (4.0172727722165291e-07)*bt_g0_28;
    bt_l1_29 = bt_l1_29 + (-3.090499831159832e-06)*bt_g0_29;
    bt_l1_29 = bt_l1_29 + (4.8898829163590563e-07)*bt_g0_30;
    bt_l1_29 = bt_l1_29 + (-1.505194830997425e-07)*bt_g0_31;
    bt_l1_29 = bt_l1_29 + (5.7894152405424393e-07)*bt_g0_32;
    bt_l1_29 = bt_l1_29 + (1.6688755977156688e-06)*bt_g0_33;
    bt_l1_29 = bt_l1_29 + (4.9144313152282848e-07)*bt_g0_34;
    bt_l1_29 = bt_l1_29 + (-4.4127617115918838e-07)*bt_g0_35;
    bt_l1_29 = bt_l1_29 + (-4.8526828777539777e-07)*bt_g0_36;
    bt_l1_29 = bt_l1_29 + (9.758226582334828e-08)*bt_g0_37;
    bt_l1_29 = bt_l1_29 + (-5.6201031384262023e-07)*bt_g0_38;
    bt_l1_29 = bt_l1_29 + (-1.0825878007381107e-06)*bt_g0_39;
    bt_l1_29 = bt_l1_29 + (5.8719069784274325e-07)*bt_g0_40;
    bt_l1_29 = bt_l1_29 + (5.1439798198771314e-07)*bt_g0_41;
    bt_l1_29 = bt_l1_29 + (6.0628372011706233e-07)*bt_g0_42;
    bt_l1_29 = bt_l1_29 + (5.9926236417595646e-07)*bt_g0_43;
    bt_l1_29 = bt_l1_29 + (-2.1731536037350452e-07)*bt_g0_44;
    bt_l1_29 = bt_l1_29 + (-2.2656837472823099e-07)*bt_g0_45;
    bt_l1_29 = bt_l1_29 + (-5.3124790611036588e-07)*bt_g0_46;
    bt_l1_29 = bt_l1_29 + (-5.843874646416225e-07)*bt_g0_47;
    bt_l1_29 = bt_l1_29 + (-5.8633173694033758e-07)*bt_g0_48;
    bt_l1_29 = bt_l1_29 + (3.2941525773821922e-07)*bt_g0_49;
    bt_l1_29 = bt_l1_29 + (3.8289172152872197e-06)*bt_g0_50;
    bt_l1_29 = bt_l1_29 + (5.780575520475395e-07)*bt_g0_51;
    bt_l1_29 = bt_l1_29 + (2.5168810680042952e-07)*bt_g0_52;
    bt_l1_29 = bt_l1_29 + (1.2184224829070445e-07)*bt_g0_53;
    bt_l1_29 = bt_l1_29 + (3.1935694977391904e-08)*bt_g0_54;
    bt_l1_29 = bt_l1_29 + (3.5448991297926113e-07)*bt_g0_55;
    bt_l1_29 = bt_l1_29 + (-3.6428886573958152e-07)*bt_g0_56;
    bt_l1_29 = bt_l1_29 + (-5.3609915084962267e-07)*bt_g0_57;
    bt_l1_29 = bt_l1_29 + (-0.0024408302269876003)*bt_g0_58;
    bt_l1_29 = bt_l1_29 + (-1.7394384599356272e-07)*bt_g0_59;
    bt_l1_29 = bt_l1_29 + (2.1694709175790194e-06)*bt_g0_60;
    bt_l1_29 = bt_l1_29 + (5.5550839306306443e-07)*bt_g0_61;
    bt_l1_29 = bt_l1_29 + (-3.969152828631195e-07)*bt_g0_62;
    bt_l1_29 = bt_l1_29 + (0.0014182922895997763)*bt_g0_63;
    bt_l1_30 = 0.0070156087167561054;
    bt_l1_30 = bt_l1_30 + (4.1091919911195873e-07)*bt_g0_0;
    bt_l1_30 = bt_l1_30 + (8.3300881215109257e-07)*bt_g0_1;
    bt_l1_30 = bt_l1_30 + (-0.0024482004810124636)*bt_g0_2;
    bt_l1_30 = bt_l1_30 + (-6.1838747456022247e-08)*bt_g0_3;
    bt_l1_30 = bt_l1_30 + (-1.7735546009589598e-07)*bt_g0_4;
    bt_l1_30 = bt_l1_30 + (4.5252735958456469e-07)*bt_g0_5;
    bt_l1_30 = bt_l1_30 + (5.7209661008528201e-07)*bt_g0_6;
    bt_l1_30 = bt_l1_30 + (5.7345368986716494e-07)*bt_g0_7;
    bt_l1_30 = bt_l1_30 + (0.0060920147225260735)*bt_g0_8;
    bt_l1_30 = bt_l1_30 + (-5.6733870223979466e-07)*bt_g0_9;
    bt_l1_30 = bt_l1_30 + (-0.00032119106617756188)*bt_g0_10;
    bt_l1_30 = bt_l1_30 + (-1.04825301150413e-06)*bt_g0_11;
    bt_l1_30 = bt_l1_30 + (3.5985178215014457e-07)*bt_g0_12;
    bt_l1_30 = bt_l1_30 + (-0.0028173793107271194)*bt_g0_13;
    bt_l1_30 = bt_l1_30 + (-4.3657948367581412e-07)*bt_g0_14;
    bt_l1_30 = bt_l1_30 + (-3.8004299085514504e-07)*bt_g0_15;
    bt_l1_30 = bt_l1_30 + (0.00097833306062966585)*bt_g0_16;
    bt_l1_30 = bt_l1_30 + (0.0014903072733432055)*bt_g0_17;
    bt_l1_30 = bt_l1_30 + (-2.2134342998469947e-06)*bt_g0_18;
    bt_l1_30 = bt_l1_30 + (5.4755184919486055e-07)*bt_g0_19;
    bt_l1_30 = bt_l1_30 + (5.6338757303819875e-07)*bt_g0_20;
    bt_l1_30 = bt_l1_30 + (-4.0161827996598731e-07)*bt_g0_21;
    bt_l1_30 = bt_l1_30 + (0.0015062876045703888)*bt_g0_22;
    bt_l1_30 = bt_l1_30 + (-9.6659604764681717e-08)*bt_g0_23;
    bt_l1_30 = bt_l1_30 + (-6.2711484360988834e-07)*bt_g0_24;
    bt_l1_30 = bt_l1_30 + (-8.1023692644066614e-08)*bt_g0_25;
    bt_l1_30 = bt_l1_30 + (-7.7196597203510464e-07)*bt_g0_26;
    bt_l1_30 = bt_l1_30 + (0.00053394550923258066)*bt_g0_27;
    bt_l1_30 = bt_l1_30 + (4.0172810145122639e-07)*bt_g0_28;
    bt_l1_30 = bt_l1_30 + (-3.0904761842975859e-06)*bt_g0_29;
    bt_l1_30 = bt_l1_30 + (4.8898704108069069e-07)*bt_g0_30;
    bt_l1_30 = bt_l1_30 + (-1.5051776358632196e-07)*bt_g0_31;
    bt_l1_30 = bt_l1_30 + (5.7894033034244785e-07)*bt_g0_32;
    bt_l1_30 = bt_l1_30 + (1.6688624100424931e-06)*bt_g0_33;
    bt_l1_30 = bt_l1_30 + (4.9144261993205873e-07)*bt_g0_34;
    bt_l1_30 = bt_l1_30 + (-4.4127489218226401e-07)*bt_g0_35;
    bt_l1_30 = bt_l1_30 + (-4.8526743512411485e-07)*bt_g0_36;
    bt_l1_30 = bt_l1_30 + (9.7579821556337265e-08)*bt_g0_37;
    bt_l1_30 = bt_l1_30 + (-5.6200946119133732e-07)*bt_g0_38;
    bt_l1_30 = bt_l1_30 + (-1.082586436496058e-06)*bt_g0_39;
    bt_l1_30 = bt_l1_30 + (5.8719012940855464e-07)*bt_g0_40;
    bt_l1_30 = bt_l1_30 + (5.143967314324982e-07)*bt_g0_41;
    bt_l1_30 = bt_l1_30 + (6.062833222131303e-07)*bt_g0_42;
    bt_l1_30 = bt_l1_30 + (5.9926156836809241e-07)*bt_g0_43;
    bt_l1_30 = bt_l1_30 + (-2.1731364086008398e-07)*bt_g0_44;
    bt_l1_30 = bt_l1_30 + (-2.2656969633771951e-07)*bt_g0_45;
    bt_l1_30 = bt_l1_30 + (-5.3124642818147549e-07)*bt_g0_46;
    bt_l1_30 = bt_l1_30 + (-5.8438683936401503e-07)*bt_g0_47;
    bt_l1_30 = bt_l1_30 + (-5.8633094113247353e-07)*bt_g0_48;
    bt_l1_30 = bt_l1_30 + (3.2941360927907226e-07)*bt_g0_49;
    bt_l1_30 = bt_l1_30 + (3.8288862924673595e-06)*bt_g0_50;
    bt_l1_30 = bt_l1_30 + (5.7805783626463381e-07)*bt_g0_51;
    bt_l1_30 = bt_l1_30 + (2.516893005122256e-07)*bt_g0_52;
    bt_l1_30 = bt_l1_30 + (1.2184131037429324e-07)*bt_g0_53;
    bt_l1_30 = bt_l1_30 + (3.1933772959291673e-08)*bt_g0_54;
    bt_l1_30 = bt_l1_30 + (3.5448854873720848e-07)*bt_g0_55;
    bt_l1_30 = bt_l1_30 + (-3.6429025840334361e-07)*bt_g0_56;
    bt_l1_30 = bt_l1_30 + (-5.3611279327014927e-07)*bt_g0_57;
    bt_l1_30 = bt_l1_30 + (-0.0024408015888184309)*bt_g0_58;
    bt_l1_30 = bt_l1_30 + (-1.7394251017321949e-07)*bt_g0_59;
    bt_l1_30 = bt_l1_30 + (2.1694779661629582e-06)*bt_g0_60;
    bt_l1_30 = bt_l1_30 + (5.5550776778545696e-07)*bt_g0_61;
    bt_l1_30 = bt_l1_30 + (-3.9691406072961399e-07)*bt_g0_62;
    bt_l1_30 = bt_l1_30 + (0.0014182828599587083)*bt_g0_63;
    bt_l1_31 = 0.007015579380095005;
    bt_l1_31 = bt_l1_31 + (4.1091959701589076e-07)*bt_g0_0;
    bt_l1_31 = bt_l1_31 + (8.3300676578801358e-07)*bt_g0_1;
    bt_l1_31 = bt_l1_31 + (-0.0024481979198753834)*bt_g0_2;
    bt_l1_31 = bt_l1_31 + (-6.1838143494696851e-08)*bt_g0_3;
    bt_l1_31 = bt_l1_31 + (-1.773577196217957e-07)*bt_g0_4;
    bt_l1_31 = bt_l1_31 + (4.5252781433191558e-07)*bt_g0_5;
    bt_l1_31 = bt_l1_31 + (5.7209717851947062e-07)*bt_g0_6;
    bt_l1_31 = bt_l1_31 + (5.7345420145793469e-07)*bt_g0_7;
    bt_l1_31 = bt_l1_31 + (0.0060920272953808308)*bt_g0_8;
    bt_l1_31 = bt_l1_31 + (-5.6733898645688896e-07)*bt_g0_9;
    bt_l1_31 = bt_l1_31 + (-0.00032119208481162786)*bt_g0_10;
    bt_l1_31 = bt_l1_31 + (-1.048246076607029e-06)*bt_g0_11;
    bt_l1_31 = bt_l1_31 + (3.5985254953629919e-07)*bt_g0_12;
    bt_l1_31 = bt_l1_31 + (-0.0028173730242997408)*bt_g0_13;
    bt_l1_31 = bt_l1_31 + (-4.3657979631461785e-07)*bt_g0_14;
    bt_l1_31 = bt_l1_31 + (-3.800436161327525e-07)*bt_g0_15;
    bt_l1_31 = bt_l1_31 + (0.00097839534282684326)*bt_g0_16;
    bt_l1_31 = bt_l1_31 + (0.001490321010351181)*bt_g0_17;
    bt_l1_31 = bt_l1_31 + (-2.2134336177259684e-06)*bt_g0_18;
    bt_l1_31 = bt_l1_31 + (5.4755162182118511e-07)*bt_g0_19;
    bt_l1_31 = bt_l1_31 + (5.6338802778554964e-07)*bt_g0_20;
    bt_l1_31 = bt_l1_31 + (-4.0161893366530421e-07)*bt_g0_21;
    bt_l1_31 = bt_l1_31 + (0.0015062941238284111)*bt_g0_22;
    bt_l1_31 = bt_l1_31 + (-9.666072031677686e-08)*bt_g0_23;
    bt_l1_31 = bt_l1_31 + (-6.2711546888749581e-07)*bt_g0_24;
    bt_l1_31 = bt_l1_31 + (-8.1024225551118434e-08)*bt_g0_25;
    bt_l1_31 = bt_l1_31 + (-7.7196955317049287e-07)*bt_g0_26;
    bt_l1_31 = bt_l1_31 + (0.00053396087605506182)*bt_g0_27;
    bt_l1_31 = bt_l1_31 + (4.017277319690038e-07)*bt_g0_28;
    bt_l1_31 = bt_l1_31 + (-3.0904891445970861e-06)*bt_g0_29;
    bt_l1_31 = bt_l1_31 + (4.8898766635829816e-07)*bt_g0_30;
    bt_l1_31 = bt_l1_31 + (-1.5051861623760487e-07)*bt_g0_31;
    bt_l1_31 = bt_l1_31 + (5.7894078508979874e-07)*bt_g0_32;
    bt_l1_31 = bt_l1_31 + (1.6688685491317301e-06)*bt_g0_33;
    bt_l1_31 = bt_l1_31 + (4.9144301783599076e-07)*bt_g0_34;
    bt_l1_31 = bt_l1_31 + (-4.4127531850790547e-07)*bt_g0_35;
    bt_l1_31 = bt_l1_31 + (-4.8526777618462802e-07)*bt_g0_36;
    bt_l1_31 = bt_l1_31 + (9.7580816316167329e-08)*bt_g0_37;
    bt_l1_31 = bt_l1_31 + (-5.6200997278210707e-07)*bt_g0_38;
    bt_l1_31 = bt_l1_31 + (-1.0825880281117861e-06)*bt_g0_39;
    bt_l1_31 = bt_l1_31 + (5.8719035678223008e-07)*bt_g0_40;
    bt_l1_31 = bt_l1_31 + (5.1439729986668681e-07)*bt_g0_41;
    bt_l1_31 = bt_l1_31 + (6.0628349274338689e-07)*bt_g0_42;
    bt_l1_31 = bt_l1_31 + (5.9926196627202444e-07)*bt_g0_43;
    bt_l1_31 = bt_l1_31 + (-2.1731428034854616e-07)*bt_g0_44;
    bt_l1_31 = bt_l1_31 + (-2.265691279035309e-07)*bt_g0_45;
    bt_l1_31 = bt_l1_31 + (-5.3124705345908296e-07)*bt_g0_46;
    bt_l1_31 = bt_l1_31 + (-5.843871804245282e-07)*bt_g0_47;
    bt_l1_31 = bt_l1_31 + (-5.8633139587982441e-07)*bt_g0_48;
    bt_l1_31 = bt_l1_31 + (3.2941443350864574e-07)*bt_g0_49;
    bt_l1_31 = bt_l1_31 + (3.8289012991299387e-06)*bt_g0_50;
    bt_l1_31 = bt_l1_31 + (5.7805783626463381e-07)*bt_g0_51;
    bt_l1_31 = bt_l1_31 + (2.5168890260829357e-07)*bt_g0_52;
    bt_l1_31 = bt_l1_31 + (1.2184167985651584e-07)*bt_g0_53;
    bt_l1_31 = bt_l1_31 + (3.1934597188865155e-08)*bt_g0_54;
    bt_l1_31 = bt_l1_31 + (3.5448900348455936e-07)*bt_g0_55;
    bt_l1_31 = bt_l1_31 + (-3.6428974681257387e-07)*bt_g0_56;
    bt_l1_31 = bt_l1_31 + (-5.3610676786775002e-07)*bt_g0_57;
    bt_l1_31 = bt_l1_31 + (-0.002440806245431304)*bt_g0_58;
    bt_l1_31 = bt_l1_31 + (-1.7394310702911753e-07)*bt_g0_59;
    bt_l1_31 = bt_l1_31 + (2.169474782931502e-06)*bt_g0_60;
    bt_l1_31 = bt_l1_31 + (5.5550810884597013e-07)*bt_g0_61;
    bt_l1_31 = bt_l1_31 + (-3.9691454389867431e-07)*bt_g0_62;
    bt_l1_31 = bt_l1_31 + (0.0014182997401803732)*bt_g0_63;
    bt_l1_32 = 0.0070156212896108627;
    bt_l1_32 = bt_l1_32 + (4.1091911384683044e-07)*bt_g0_0;
    bt_l1_32 = bt_l1_32 + (8.3301313225092599e-07)*bt_g0_1;
    bt_l1_32 = bt_l1_32 + (-0.0024481960572302341)*bt_g0_2;
    bt_l1_32 = bt_l1_32 + (-6.1839536158458941e-08)*bt_g0_3;
    bt_l1_32 = bt_l1_32 + (-1.7735352741965471e-07)*bt_g0_4;
    bt_l1_32 = bt_l1_32 + (4.5252667746353836e-07)*bt_g0_5;
    bt_l1_32 = bt_l1_32 + (5.720960416510934e-07)*bt_g0_6;
    bt_l1_32 = bt_l1_32 + (5.7345329196323291e-07)*bt_g0_7;
    bt_l1_32 = bt_l1_32 + (0.0060919970273971558)*bt_g0_8;
    bt_l1_32 = bt_l1_32 + (-5.6733841802270035e-07)*bt_g0_9;
    bt_l1_32 = bt_l1_32 + (-0.00032118795206770301)*bt_g0_10;
    bt_l1_32 = bt_l1_32 + (-1.0482604011485819e-06)*bt_g0_11;
    bt_l1_32 = bt_l1_32 + (3.598511568725371e-07)*bt_g0_12;
    bt_l1_32 = bt_l1_32 + (-0.0028173860628157854)*bt_g0_13;
    bt_l1_32 = bt_l1_32 + (-4.3657939841068583e-07)*bt_g0_14;
    bt_l1_32 = bt_l1_32 + (-3.8004245084266586e-07)*bt_g0_15;
    bt_l1_32 = bt_l1_32 + (0.00097828975412994623)*bt_g0_16;
    bt_l1_32 = bt_l1_32 + (0.0014903072733432055)*bt_g0_17;
    bt_l1_32 = bt_l1_32 + (-2.2134374830784509e-06)*bt_g0_18;
    bt_l1_32 = bt_l1_32 + (5.4755230394221144e-07)*bt_g0_19;
    bt_l1_32 = bt_l1_32 + (5.6338740250794217e-07)*bt_g0_20;
    bt_l1_32 = bt_l1_32 + (-4.0161773995350813e-07)*bt_g0_21;
    bt_l1_32 = bt_l1_32 + (0.001506286789663136)*bt_g0_22;
    bt_l1_32 = bt_l1_32 + (-9.6657842618697032e-08)*bt_g0_23;
    bt_l1_32 = bt_l1_32 + (-6.2711501414014492e-07)*bt_g0_24;
    bt_l1_32 = bt_l1_32 + (-8.1022612619108259e-08)*bt_g0_25;
    bt_l1_32 = bt_l1_32 + (-7.7196136771817692e-07)*bt_g0_26;
    bt_l1_32 = bt_l1_32 + (0.00053394294809550047)*bt_g0_27;
    bt_l1_32 = bt_l1_32 + (4.0172898252421874e-07)*bt_g0_28;
    bt_l1_32 = bt_l1_32 + (-3.0904641334927874e-06)*bt_g0_29;
    bt_l1_32 = bt_l1_32 + (4.8898647264650208e-07)*bt_g0_30;
    bt_l1_32 = bt_l1_32 + (-1.5051688251332962e-07)*bt_g0_31;
    bt_l1_32 = bt_l1_32 + (5.7894021665561013e-07)*bt_g0_32;
    bt_l1_32 = bt_l1_32 + (1.6688558162059053e-06)*bt_g0_33;
    bt_l1_32 = bt_l1_32 + (4.9144233571496443e-07)*bt_g0_34;
    bt_l1_32 = bt_l1_32 + (-4.4127440901320369e-07)*bt_g0_35;
    bt_l1_32 = bt_l1_32 + (-4.8526732143727713e-07)*bt_g0_36;
    bt_l1_32 = bt_l1_32 + (9.7578649160823261e-08)*bt_g0_37;
    bt_l1_32 = bt_l1_32 + (-5.6200900644398644e-07)*bt_g0_38;
    bt_l1_32 = bt_l1_32 + (-1.0825863228092203e-06)*bt_g0_39;
    bt_l1_32 = bt_l1_32 + (5.8718995887829806e-07)*bt_g0_40;
    bt_l1_32 = bt_l1_32 + (5.1439639037198504e-07)*bt_g0_41;
    bt_l1_32 = bt_l1_32 + (6.0628315168287372e-07)*bt_g0_42;
    bt_l1_32 = bt_l1_32 + (5.9926168205493013e-07)*bt_g0_43;
    bt_l1_32 = bt_l1_32 + (-2.1731290189563879e-07)*bt_g0_44;
    bt_l1_32 = bt_l1_32 + (-2.2657049214558356e-07)*bt_g0_45;
    bt_l1_32 = bt_l1_32 + (-5.3124608712096233e-07)*bt_g0_46;
    bt_l1_32 = bt_l1_32 + (-5.8438661199033959e-07)*bt_g0_47;
    bt_l1_32 = bt_l1_32 + (-5.8633077060221694e-07)*bt_g0_48;
    bt_l1_32 = bt_l1_32 + (3.2941295557975536e-07)*bt_g0_49;
    bt_l1_32 = bt_l1_32 + (3.828868102573324e-06)*bt_g0_50;
    bt_l1_32 = bt_l1_32 + (5.7805800679489039e-07)*bt_g0_51;
    bt_l1_32 = bt_l1_32 + (2.5169012474179908e-07)*bt_g0_52;
    bt_l1_32 = bt_l1_32 + (1.2184105457890837e-07)*bt_g0_53;
    bt_l1_32 = bt_l1_32 + (3.1932920308008761e-08)*bt_g0_54;
    bt_l1_32 = bt_l1_32 + (3.5448806556814816e-07)*bt_g0_55;
    bt_l1_32 = bt_l1_32 + (-3.6429096894607937e-07)*bt_g0_56;
    bt_l1_32 = bt_l1_32 + (-5.3612114925272181e-07)*bt_g0_57;
    bt_l1_32 = bt_l1_32 + (-0.0024408046156167984)*bt_g0_58;
    bt_l1_32 = bt_l1_32 + (-1.7394185647390259e-07)*bt_g0_59;
    bt_l1_32 = bt_l1_32 + (2.1694827410101425e-06)*bt_g0_60;
    bt_l1_32 = bt_l1_32 + (5.5550765409861924e-07)*bt_g0_61;
    bt_l1_32 = bt_l1_32 + (-3.9691352071713482e-07)*bt_g0_62;
    bt_l1_32 = bt_l1_32 + (0.0014182889135554433)*bt_g0_63;
    bt_l1_33 = 0.0070156287401914597;
    bt_l1_33 = bt_l1_33 + (4.1091971070272848e-07)*bt_g0_0;
    bt_l1_33 = bt_l1_33 + (8.3300761843929649e-07)*bt_g0_1;
    bt_l1_33 = bt_l1_33 + (-0.002448223065584898)*bt_g0_2;
    bt_l1_33 = bt_l1_33 + (-6.1838285603244003e-08)*bt_g0_3;
    bt_l1_33 = bt_l1_33 + (-1.7735628432546946e-07)*bt_g0_4;
    bt_l1_33 = bt_l1_33 + (4.5252761537994957e-07)*bt_g0_5;
    bt_l1_33 = bt_l1_33 + (5.720970648326329e-07)*bt_g0_6;
    bt_l1_33 = bt_l1_33 + (5.7345408777109697e-07)*bt_g0_7;
    bt_l1_33 = bt_l1_33 + (0.0060920226387679577)*bt_g0_8;
    bt_l1_33 = bt_l1_33 + (-5.6733887277005124e-07)*bt_g0_9;
    bt_l1_33 = bt_l1_33 + (-0.00032119220122694969)*bt_g0_10;
    bt_l1_33 = bt_l1_33 + (-1.0482470997885684e-06)*bt_g0_11;
    bt_l1_33 = bt_l1_33 + (3.5985257795800862e-07)*bt_g0_12;
    bt_l1_33 = bt_l1_33 + (-0.0028174221515655518)*bt_g0_13;
    bt_l1_33 = bt_l1_33 + (-4.3657982473632728e-07)*bt_g0_14;
    bt_l1_33 = bt_l1_33 + (-3.8004338875907706e-07)*bt_g0_15;
    bt_l1_33 = bt_l1_33 + (0.00097833143081516027)*bt_g0_16;
    bt_l1_33 = bt_l1_33 + (0.0014902794500812888)*bt_g0_17;
    bt_l1_33 = bt_l1_33 + (-2.2134352093416965e-06)*bt_g0_18;
    bt_l1_33 = bt_l1_33 + (5.4755201972511713e-07)*bt_g0_19;
    bt_l1_33 = bt_l1_33 + (5.633880846289685e-07)*bt_g0_20;
    bt_l1_33 = bt_l1_33 + (-4.0161881997846649e-07)*bt_g0_21;
    bt_l1_33 = bt_l1_33 + (0.0015062920283526182)*bt_g0_22;
    bt_l1_33 = bt_l1_33 + (-9.6660244253143901e-08)*bt_g0_23;
    bt_l1_33 = bt_l1_33 + (-6.271151846704015e-07)*bt_g0_24;
    bt_l1_33 = bt_l1_33 + (-8.1024218445691076e-08)*bt_g0_25;
    bt_l1_33 = bt_l1_33 + (-7.7196932579681743e-07)*bt_g0_26;
    bt_l1_33 = bt_l1_33 + (0.00053395784925669432)*bt_g0_27;
    bt_l1_33 = bt_l1_33 + (4.0172784565584152e-07)*bt_g0_28;
    bt_l1_33 = bt_l1_33 + (-3.0904861887393054e-06)*bt_g0_29;
    bt_l1_33 = bt_l1_33 + (4.8898738214120385e-07)*bt_g0_30;
    bt_l1_33 = bt_l1_33 + (-1.5051833202051057e-07)*bt_g0_31;
    bt_l1_33 = bt_l1_33 + (5.7894095562005532e-07)*bt_g0_32;
    bt_l1_33 = bt_l1_33 + (1.6688674122633529e-06)*bt_g0_33;
    bt_l1_33 = bt_l1_33 + (4.9144307467940962e-07)*bt_g0_34;
    bt_l1_33 = bt_l1_33 + (-4.4127529008619604e-07)*bt_g0_35;
    bt_l1_33 = bt_l1_33 + (-4.8526771934120916e-07)*bt_g0_36;
    bt_l1_33 = bt_l1_33 + (9.7580588942491886e-08)*bt_g0_37;
    bt_l1_33 = bt_l1_33 + (-5.6200968856501277e-07)*bt_g0_38;
    bt_l1_33 = bt_l1_33 + (-1.0825873459907598e-06)*bt_g0_39;
    bt_l1_33 = bt_l1_33 + (5.8719024309539236e-07)*bt_g0_40;
    bt_l1_33 = bt_l1_33 + (5.1439729986668681e-07)*bt_g0_41;
    bt_l1_33 = bt_l1_33 + (6.0628354958680575e-07)*bt_g0_42;
    bt_l1_33 = bt_l1_33 + (5.9926185258518672e-07)*bt_g0_43;
    bt_l1_33 = bt_l1_33 + (-2.1731419508341787e-07)*bt_g0_44;
    bt_l1_33 = bt_l1_33 + (-2.265692273795139e-07)*bt_g0_45;
    bt_l1_33 = bt_l1_33 + (-5.3124705345908296e-07)*bt_g0_46;
    bt_l1_33 = bt_l1_33 + (-5.8438723726794706e-07)*bt_g0_47;
    bt_l1_33 = bt_l1_33 + (-5.8633139587982441e-07)*bt_g0_48;
    bt_l1_33 = bt_l1_33 + (3.2941440508693631e-07)*bt_g0_49;
    bt_l1_33 = bt_l1_33 + (3.8288985706458334e-06)*bt_g0_50;
    bt_l1_33 = bt_l1_33 + (5.7805783626463381e-07)*bt_g0_51;
    bt_l1_33 = bt_l1_33 + (2.5168904471684073e-07)*bt_g0_52;
    bt_l1_33 = bt_l1_33 + (1.2184162301309698e-07)*bt_g0_53;
    bt_l1_33 = bt_l1_33 + (3.1934408895040178e-08)*bt_g0_54;
    bt_l1_33 = bt_l1_33 + (3.5448920243652537e-07)*bt_g0_55;
    bt_l1_33 = bt_l1_33 + (-3.642904289336002e-07)*bt_g0_56;
    bt_l1_33 = bt_l1_33 + (-5.3610887107424787e-07)*bt_g0_57;
    bt_l1_33 = bt_l1_33 + (-0.0024408430326730013)*bt_g0_58;
    bt_l1_33 = bt_l1_33 + (-1.739430786074081e-07)*bt_g0_59;
    bt_l1_33 = bt_l1_33 + (2.1694770566682564e-06)*bt_g0_60;
    bt_l1_33 = bt_l1_33 + (5.5550788147229468e-07)*bt_g0_61;
    bt_l1_33 = bt_l1_33 + (-3.9691445863354602e-07)*bt_g0_62;
    bt_l1_33 = bt_l1_33 + (0.001418279018253088)*bt_g0_63;
    bt_l1_34 = 0.0070156012661755085;
    bt_l1_34 = bt_l1_34 + (4.1091942648563418e-07)*bt_g0_0;
    bt_l1_34 = bt_l1_34 + (8.3301159747861675e-07)*bt_g0_1;
    bt_l1_34 = bt_l1_34 + (-0.0024482014123350382)*bt_g0_2;
    bt_l1_34 = bt_l1_34 + (-6.1839543263886299e-08)*bt_g0_3;
    bt_l1_34 = bt_l1_34 + (-1.7735384005845845e-07)*bt_g0_4;
    bt_l1_34 = bt_l1_34 + (4.5252690483721381e-07)*bt_g0_5;
    bt_l1_34 = bt_l1_34 + (5.7209632586818771e-07)*bt_g0_6;
    bt_l1_34 = bt_l1_34 + (5.7345351933690836e-07)*bt_g0_7;
    bt_l1_34 = bt_l1_34 + (0.0060920030809938908)*bt_g0_8;
    bt_l1_34 = bt_l1_34 + (-5.6733887277005124e-07)*bt_g0_9;
    bt_l1_34 = bt_l1_34 + (-0.00032119153183884919)*bt_g0_10;
    bt_l1_34 = bt_l1_34 + (-1.0482557399882353e-06)*bt_g0_11;
    bt_l1_34 = bt_l1_34 + (3.5985138424621255e-07)*bt_g0_12;
    bt_l1_34 = bt_l1_34 + (-0.0028173672035336494)*bt_g0_13;
    bt_l1_34 = bt_l1_34 + (-4.3657956894094241e-07)*bt_g0_14;
    bt_l1_34 = bt_l1_34 + (-3.8004273505976016e-07)*bt_g0_15;
    bt_l1_34 = bt_l1_34 + (0.00097831478342413902)*bt_g0_16;
    bt_l1_34 = bt_l1_34 + (0.0014903148403391242)*bt_g0_17;
    bt_l1_34 = bt_l1_34 + (-2.2134342998469947e-06)*bt_g0_18;
    bt_l1_34 = bt_l1_34 + (5.4755224709879258e-07)*bt_g0_19;
    bt_l1_34 = bt_l1_34 + (5.6338751619477989e-07)*bt_g0_20;
    bt_l1_34 = bt_l1_34 + (-4.0161802417060244e-07)*bt_g0_21;
    bt_l1_34 = bt_l1_34 + (0.0015063002938404679)*bt_g0_22;
    bt_l1_34 = bt_l1_34 + (-9.6658524739723362e-08)*bt_g0_23;
    bt_l1_34 = bt_l1_34 + (-6.2711512782698264e-07)*bt_g0_24;
    bt_l1_34 = bt_l1_34 + (-8.1022619724535616e-08)*bt_g0_25;
    bt_l1_34 = bt_l1_34 + (-7.7196136771817692e-07)*bt_g0_26;
    bt_l1_34 = bt_l1_34 + (0.00053394126007333398)*bt_g0_27;
    bt_l1_34 = bt_l1_34 + (4.0172898252421874e-07)*bt_g0_28;
    bt_l1_34 = bt_l1_34 + (-3.0904620871297084e-06)*bt_g0_29;
    bt_l1_34 = bt_l1_34 + (4.8898641580308322e-07)*bt_g0_30;
    bt_l1_34 = bt_l1_34 + (-1.5051698198931263e-07)*bt_g0_31;
    bt_l1_34 = bt_l1_34 + (5.7894015981219127e-07)*bt_g0_32;
    bt_l1_34 = bt_l1_34 + (1.6688555888322298e-06)*bt_g0_33;
    bt_l1_34 = bt_l1_34 + (4.9144222202812671e-07)*bt_g0_34;
    bt_l1_34 = bt_l1_34 + (-4.4127452270004142e-07)*bt_g0_35;
    bt_l1_34 = bt_l1_34 + (-4.8526754881095258e-07)*bt_g0_36;
    bt_l1_34 = bt_l1_34 + (9.7579494706678815e-08)*bt_g0_37;
    bt_l1_34 = bt_l1_34 + (-5.6200940434791846e-07)*bt_g0_38;
    bt_l1_34 = bt_l1_34 + (-1.0825840490724659e-06)*bt_g0_39;
    bt_l1_34 = bt_l1_34 + (5.8719024309539236e-07)*bt_g0_40;
    bt_l1_34 = bt_l1_34 + (5.143967314324982e-07)*bt_g0_41;
    bt_l1_34 = bt_l1_34 + (6.062833222131303e-07)*bt_g0_42;
    bt_l1_34 = bt_l1_34 + (5.9926213680228102e-07)*bt_g0_43;
    bt_l1_34 = bt_l1_34 + (-2.1731290189563879e-07)*bt_g0_44;
    bt_l1_34 = bt_l1_34 + (-2.2657064846498542e-07)*bt_g0_45;
    bt_l1_34 = bt_l1_34 + (-5.3124631449463777e-07)*bt_g0_46;
    bt_l1_34 = bt_l1_34 + (-5.8438661199033959e-07)*bt_g0_47;
    bt_l1_34 = bt_l1_34 + (-5.8633111166273011e-07)*bt_g0_48;
    bt_l1_34 = bt_l1_34 + (3.2941306926659308e-07)*bt_g0_49;
    bt_l1_34 = bt_l1_34 + (3.8288631003524642e-06)*bt_g0_50;
    bt_l1_34 = bt_l1_34 + (5.7805823416856583e-07)*bt_g0_51;
    bt_l1_34 = bt_l1_34 + (2.5169018158521794e-07)*bt_g0_52;
    bt_l1_34 = bt_l1_34 + (1.2184113984403666e-07)*bt_g0_53;
    bt_l1_34 = bt_l1_34 + (3.1932930966149797e-08)*bt_g0_54;
    bt_l1_34 = bt_l1_34 + (3.5448806556814816e-07)*bt_g0_55;
    bt_l1_34 = bt_l1_34 + (-3.6429011629479646e-07)*bt_g0_56;
    bt_l1_34 = bt_l1_34 + (-5.3611876182912965e-07)*bt_g0_57;
    bt_l1_34 = bt_l1_34 + (-0.0024408015888184309)*bt_g0_58;
    bt_l1_34 = bt_l1_34 + (-1.7394192752817617e-07)*bt_g0_59;
    bt_l1_34 = bt_l1_34 + (2.1694775114156073e-06)*bt_g0_60;
    bt_l1_34 = bt_l1_34 + (5.5550793831571355e-07)*bt_g0_61;
    bt_l1_34 = bt_l1_34 + (-3.969136912473914e-07)*bt_g0_62;
    bt_l1_34 = bt_l1_34 + (0.0014182920567691326)*bt_g0_63;
    bt_l1_35 = 0.0070156347937881947;
    bt_l1_35 = bt_l1_35 + (4.1091931279879645e-07)*bt_g0_0;
    bt_l1_35 = bt_l1_35 + (8.3301097220100928e-07)*bt_g0_1;
    bt_l1_35 = bt_l1_35 + (-0.0024482079315930605)*bt_g0_2;
    bt_l1_35 = bt_l1_35 + (-6.1839010356834478e-08)*bt_g0_3;
    bt_l1_35 = bt_l1_35 + (-1.7735487745085265e-07)*bt_g0_4;
    bt_l1_35 = bt_l1_35 + (4.5252710378917982e-07)*bt_g0_5;
    bt_l1_35 = bt_l1_35 + (5.7209661008528201e-07)*bt_g0_6;
    bt_l1_35 = bt_l1_35 + (5.7345340565007064e-07)*bt_g0_7;
    bt_l1_35 = bt_l1_35 + (0.0060920044779777527)*bt_g0_8;
    bt_l1_35 = bt_l1_35 + (-5.6733858855295694e-07)*bt_g0_9;
    bt_l1_35 = bt_l1_35 + (-0.00032119045499712229)*bt_g0_10;
    bt_l1_35 = bt_l1_35 + (-1.0482533525646431e-06)*bt_g0_11;
    bt_l1_35 = bt_l1_35 + (3.5985169688501628e-07)*bt_g0_12;
    bt_l1_35 = bt_l1_35 + (-0.0028173946775496006)*bt_g0_13;
    bt_l1_35 = bt_l1_35 + (-4.3657942683239526e-07)*bt_g0_14;
    bt_l1_35 = bt_l1_35 + (-3.8004282032488845e-07)*bt_g0_15;
    bt_l1_35 = bt_l1_35 + (0.00097829871810972691)*bt_g0_16;
    bt_l1_35 = bt_l1_35 + (0.0014902804978191853)*bt_g0_17;
    bt_l1_35 = bt_l1_35 + (-2.2134368009574246e-06)*bt_g0_18;
    bt_l1_35 = bt_l1_35 + (5.4755196288169827e-07)*bt_g0_19;
    bt_l1_35 = bt_l1_35 + (5.633878004118742e-07)*bt_g0_20;
    bt_l1_35 = bt_l1_35 + (-4.016180810140213e-07)*bt_g0_21;
    bt_l1_35 = bt_l1_35 + (0.0015062835300341249)*bt_g0_22;
    bt_l1_35 = bt_l1_35 + (-9.6659043435920466e-08)*bt_g0_23;
    bt_l1_35 = bt_l1_35 + (-6.2711484360988834e-07)*bt_g0_24;
    bt_l1_35 = bt_l1_35 + (-8.1023323161844019e-08)*bt_g0_25;
    bt_l1_35 = bt_l1_35 + (-7.719641530457011e-07)*bt_g0_26;
    bt_l1_35 = bt_l1_35 + (0.00053394184214994311)*bt_g0_27;
    bt_l1_35 = bt_l1_35 + (4.0172835724661127e-07)*bt_g0_28;
    bt_l1_35 = bt_l1_35 + (-3.0904682262189453e-06)*bt_g0_29;
    bt_l1_35 = bt_l1_35 + (4.8898681370701524e-07)*bt_g0_30;
    bt_l1_35 = bt_l1_35 + (-1.5051756463435595e-07)*bt_g0_31;
    bt_l1_35 = bt_l1_35 + (5.7894033034244785e-07)*bt_g0_32;
    bt_l1_35 = bt_l1_35 + (1.6688591131241992e-06)*bt_g0_33;
    bt_l1_35 = bt_l1_35 + (4.9144239255838329e-07)*bt_g0_34;
    bt_l1_35 = bt_l1_35 + (-4.4127483533884515e-07)*bt_g0_35;
    bt_l1_35 = bt_l1_35 + (-4.8526737828069599e-07)*bt_g0_36;
    bt_l1_35 = bt_l1_35 + (9.7579615498943895e-08)*bt_g0_37;
    bt_l1_35 = bt_l1_35 + (-5.6200946119133732e-07)*bt_g0_38;
    bt_l1_35 = bt_l1_35 + (-1.0825865501828957e-06)*bt_g0_39;
    bt_l1_35 = bt_l1_35 + (5.8719001572171692e-07)*bt_g0_40;
    bt_l1_35 = bt_l1_35 + (5.1439656090224162e-07)*bt_g0_41;
    bt_l1_35 = bt_l1_35 + (6.062833222131303e-07)*bt_g0_42;
    bt_l1_35 = bt_l1_35 + (5.9926162521151127e-07)*bt_g0_43;
    bt_l1_35 = bt_l1_35 + (-2.1731339927555382e-07)*bt_g0_44;
    bt_l1_35 = bt_l1_35 + (-2.2657002318737796e-07)*bt_g0_45;
    bt_l1_35 = bt_l1_35 + (-5.3124625765121891e-07)*bt_g0_46;
    bt_l1_35 = bt_l1_35 + (-5.8438672567717731e-07)*bt_g0_47;
    bt_l1_35 = bt_l1_35 + (-5.8633099797589239e-07)*bt_g0_48;
    bt_l1_35 = bt_l1_35 + (3.2941332506197796e-07)*bt_g0_49;
    bt_l1_35 = bt_l1_35 + (3.8288794712570962e-06)*bt_g0_50;
    bt_l1_35 = bt_l1_35 + (5.7805789310805267e-07)*bt_g0_51;
    bt_l1_35 = bt_l1_35 + (2.5168955630761047e-07)*bt_g0_52;
    bt_l1_35 = bt_l1_35 + (1.2184121089831024e-07)*bt_g0_53;
    bt_l1_35 = bt_l1_35 + (3.1933506505765763e-08)*bt_g0_54;
    bt_l1_35 = bt_l1_35 + (3.5448837820695189e-07)*bt_g0_55;
    bt_l1_35 = bt_l1_35 + (-3.6429057104214735e-07)*bt_g0_56;
    bt_l1_35 = bt_l1_35 + (-5.3611523753716028e-07)*bt_g0_57;
    bt_l1_35 = bt_l1_35 + (-0.0024408241733908653)*bt_g0_58;
    bt_l1_35 = bt_l1_35 + (-1.7394239648638177e-07)*bt_g0_59;
    bt_l1_35 = bt_l1_35 + (2.1694781935366336e-06)*bt_g0_60;
    bt_l1_35 = bt_l1_35 + (5.5550776778545696e-07)*bt_g0_61;
    bt_l1_35 = bt_l1_35 + (-3.9691380493422912e-07)*bt_g0_62;
    bt_l1_35 = bt_l1_35 + (0.0014182867016643286)*bt_g0_63;
    bt_l1_36 = 0.0070156622678041458;
    bt_l1_36 = bt_l1_36 + (4.1091817593041924e-07)*bt_g0_0;
    bt_l1_36 = bt_l1_36 + (8.3302876419111271e-07)*bt_g0_1;
    bt_l1_36 = bt_l1_36 + (-0.0024481683503836393)*bt_g0_2;
    bt_l1_36 = bt_l1_36 + (-6.1843365983804688e-08)*bt_g0_3;
    bt_l1_36 = bt_l1_36 + (-1.7734434720750869e-07)*bt_g0_4;
    bt_l1_36 = bt_l1_36 + (4.5252451741362165e-07)*bt_g0_5;
    bt_l1_36 = bt_l1_36 + (5.7209507531297277e-07)*bt_g0_6;
    bt_l1_36 = bt_l1_36 + (5.7345204140801798e-07)*bt_g0_7;
    bt_l1_36 = bt_l1_36 + (0.0060919537208974361)*bt_g0_8;
    bt_l1_36 = bt_l1_36 + (-5.6733887277005124e-07)*bt_g0_9;
    bt_l1_36 = bt_l1_36 + (-0.00032119109528139234)*bt_g0_10;
    bt_l1_36 = bt_l1_36 + (-1.04828893654485e-06)*bt_g0_11;
    bt_l1_36 = bt_l1_36 + (3.5984717783321685e-07)*bt_g0_12;
    bt_l1_36 = bt_l1_36 + (-0.002817357424646616)*bt_g0_13;
    bt_l1_36 = bt_l1_36 + (-4.3657874471136893e-07)*bt_g0_14;
    bt_l1_36 = bt_l1_36 + (-3.800400634190737e-07)*bt_g0_15;
    bt_l1_36 = bt_l1_36 + (0.00097810698207467794)*bt_g0_16;
    bt_l1_36 = bt_l1_36 + (0.00149029481690377)*bt_g0_17;
    bt_l1_36 = bt_l1_36 + (-2.2134424852993106e-06)*bt_g0_18;
    bt_l1_36 = bt_l1_36 + (5.4755378187110182e-07)*bt_g0_19;
    bt_l1_36 = bt_l1_36 + (5.6338672038691584e-07)*bt_g0_20;
    bt_l1_36 = bt_l1_36 + (-4.0161594938581402e-07)*bt_g0_21;
    bt_l1_36 = bt_l1_36 + (0.0015062820166349411)*bt_g0_22;
    bt_l1_36 = bt_l1_36 + (-9.6651994851981726e-08)*bt_g0_23;
    bt_l1_36 = bt_l1_36 + (-6.2711410464544315e-07)*bt_g0_24;
    bt_l1_36 = bt_l1_36 + (-8.1018455944104062e-08)*bt_g0_25;
    bt_l1_36 = bt_l1_36 + (-7.7193840297695715e-07)*bt_g0_26;
    bt_l1_36 = bt_l1_36 + (0.0005338860210031271)*bt_g0_27;
    bt_l1_36 = bt_l1_36 + (4.017322225990938e-07)*bt_g0_28;
    bt_l1_36 = bt_l1_36 + (-3.0903922834113473e-06)*bt_g0_29;
    bt_l1_36 = bt_l1_36 + (4.8898448312684195e-07)*bt_g0_30;
    bt_l1_36 = bt_l1_36 + (-1.5051318769110367e-07)*bt_g0_31;
    bt_l1_36 = bt_l1_36 + (5.789385113530443e-07)*bt_g0_32;
    bt_l1_36 = bt_l1_36 + (1.6688178448021063e-06)*bt_g0_33;
    bt_l1_36 = bt_l1_36 + (4.9144080094265519e-07)*bt_g0_34;
    bt_l1_36 = bt_l1_36 + (-4.4127187948106439e-07)*bt_g0_35;
    bt_l1_36 = bt_l1_36 + (-4.852666393162508e-07)*bt_g0_36;
    bt_l1_36 = bt_l1_36 + (9.7574407220690773e-08)*bt_g0_37;
    bt_l1_36 = bt_l1_36 + (-5.6200809694928466e-07)*bt_g0_38;
    bt_l1_36 = bt_l1_36 + (-1.0825787057910929e-06)*bt_g0_39;
    bt_l1_36 = bt_l1_36 + (5.8718978834804147e-07)*bt_g0_40;
    bt_l1_36 = bt_l1_36 + (5.1439462822600035e-07)*bt_g0_41;
    bt_l1_36 = bt_l1_36 + (6.0628315168287372e-07)*bt_g0_42;
    bt_l1_36 = bt_l1_36 + (5.9926168205493013e-07)*bt_g0_43;
    bt_l1_36 = bt_l1_36 + (-2.1730940602537885e-07)*bt_g0_44;
    bt_l1_36 = bt_l1_36 + (-2.2657461329345097e-07)*bt_g0_45;
    bt_l1_36 = bt_l1_36 + (-5.3124455234865309e-07)*bt_g0_46;
    bt_l1_36 = bt_l1_36 + (-5.8438570249563782e-07)*bt_g0_47;
    bt_l1_36 = bt_l1_36 + (-5.8633037269828492e-07)*bt_g0_48;
    bt_l1_36 = bt_l1_36 + (3.294097155048803e-07)*bt_g0_49;
    bt_l1_36 = bt_l1_36 + (3.828772150882287e-06)*bt_g0_50;
    bt_l1_36 = bt_l1_36 + (5.7805937103694305e-07)*bt_g0_51;
    bt_l1_36 = bt_l1_36 + (2.5169381956402503e-07)*bt_g0_52;
    bt_l1_36 = bt_l1_36 + (1.2183969033685571e-07)*bt_g0_53;
    bt_l1_36 = bt_l1_36 + (3.1928642840739485e-08)*bt_g0_54;
    bt_l1_36 = bt_l1_36 + (3.5448513813207683e-07)*bt_g0_55;
    bt_l1_36 = bt_l1_36 + (-3.6429239003155089e-07)*bt_g0_56;
    bt_l1_36 = bt_l1_36 + (-5.3615355000147247e-07)*bt_g0_57;
    bt_l1_36 = bt_l1_36 + (-0.0024407736491411924)*bt_g0_58;
    bt_l1_36 = bt_l1_36 + (-1.7393912798979727e-07)*bt_g0_59;
    bt_l1_36 = bt_l1_36 + (2.1694881979783531e-06)*bt_g0_60;
    bt_l1_36 = bt_l1_36 + (5.5550719935126835e-07)*bt_g0_61;
    bt_l1_36 = bt_l1_36 + (-3.9691138908892754e-07)*bt_g0_62;
    bt_l1_36 = bt_l1_36 + (0.0014182917075231671)*bt_g0_63;
    bt_l1_37 = 0.0070156562142074108;
    bt_l1_37 = bt_l1_37 + (4.1091908542512101e-07)*bt_g0_0;
    bt_l1_37 = bt_l1_37 + (8.330139849022089e-07)*bt_g0_1;
    bt_l1_37 = bt_l1_37 + (-0.0024482174776494503)*bt_g0_2;
    bt_l1_37 = bt_l1_37 + (-6.1839671161578735e-08)*bt_g0_3;
    bt_l1_37 = bt_l1_37 + (-1.7735294477461139e-07)*bt_g0_4;
    bt_l1_37 = bt_l1_37 + (4.5252670588524779e-07)*bt_g0_5;
    bt_l1_37 = bt_l1_37 + (5.7209621218134998e-07)*bt_g0_6;
    bt_l1_37 = bt_l1_37 + (5.7345317827639519e-07)*bt_g0_7;
    bt_l1_37 = bt_l1_37 + (0.0060920040123164654)*bt_g0_8;
    bt_l1_37 = bt_l1_37 + (-5.6733847486611921e-07)*bt_g0_9;
    bt_l1_37 = bt_l1_37 + (-0.00032119010575115681)*bt_g0_10;
    bt_l1_37 = bt_l1_37 + (-1.0482601737749064e-06)*bt_g0_11;
    bt_l1_37 = bt_l1_37 + (3.598511568725371e-07)*bt_g0_12;
    bt_l1_37 = bt_l1_37 + (-0.0028173988685011864)*bt_g0_13;
    bt_l1_37 = bt_l1_37 + (-4.3657911419359152e-07)*bt_g0_14;
    bt_l1_37 = bt_l1_37 + (-3.8004236557753757e-07)*bt_g0_15;
    bt_l1_37 = bt_l1_37 + (0.00097825867123901844)*bt_g0_16;
    bt_l1_37 = bt_l1_37 + (0.0014902660623192787)*bt_g0_17;
    bt_l1_37 = bt_l1_37 + (-2.2134379378258018e-06)*bt_g0_18;
    bt_l1_37 = bt_l1_37 + (5.4755201972511713e-07)*bt_g0_19;
    bt_l1_37 = bt_l1_37 + (5.6338734566452331e-07)*bt_g0_20;
    bt_l1_37 = bt_l1_37 + (-4.0161791048376472e-07)*bt_g0_21;
    bt_l1_37 = bt_l1_37 + (0.0015062927268445492)*bt_g0_22;
    bt_l1_37 = bt_l1_37 + (-9.6657643666731019e-08)*bt_g0_23;
    bt_l1_37 = bt_l1_37 + (-6.2711472992305062e-07)*bt_g0_24;
    bt_l1_37 = bt_l1_37 + (-8.1022534459407325e-08)*bt_g0_25;
    bt_l1_37 = bt_l1_37 + (-7.7196068559715059e-07)*bt_g0_26;
    bt_l1_37 = bt_l1_37 + (0.00053393380949273705)*bt_g0_27;
    bt_l1_37 = bt_l1_37 + (4.0172901094592817e-07)*bt_g0_28;
    bt_l1_37 = bt_l1_37 + (-3.0904554932931205e-06)*bt_g0_29;
    bt_l1_37 = bt_l1_37 + (4.8898624527282664e-07)*bt_g0_30;
    bt_l1_37 = bt_l1_37 + (-1.5051668356136361e-07)*bt_g0_31;
    bt_l1_37 = bt_l1_37 + (5.7893987559509696e-07)*bt_g0_32;
    bt_l1_37 = bt_l1_37 + (1.6688541109033395e-06)*bt_g0_33;
    bt_l1_37 = bt_l1_37 + (4.9144205149787012e-07)*bt_g0_34;
    bt_l1_37 = bt_l1_37 + (-4.4127423848294711e-07)*bt_g0_35;
    bt_l1_37 = bt_l1_37 + (-4.8526726459385827e-07)*bt_g0_36;
    bt_l1_37 = bt_l1_37 + (9.7578727320524195e-08)*bt_g0_37;
    bt_l1_37 = bt_l1_37 + (-5.6200912013082416e-07)*bt_g0_38;
    bt_l1_37 = bt_l1_37 + (-1.0825849585671676e-06)*bt_g0_39;
    bt_l1_37 = bt_l1_37 + (5.8718978834804147e-07)*bt_g0_40;
    bt_l1_37 = bt_l1_37 + (5.1439621984172845e-07)*bt_g0_41;
    bt_l1_37 = bt_l1_37 + (6.0628298115261714e-07)*bt_g0_42;
    bt_l1_37 = bt_l1_37 + (5.9926151152467355e-07)*bt_g0_43;
    bt_l1_37 = bt_l1_37 + (-2.173128166305105e-07)*bt_g0_44;
    bt_l1_37 = bt_l1_37 + (-2.2657054898900242e-07)*bt_g0_45;
    bt_l1_37 = bt_l1_37 + (-5.3124603027754347e-07)*bt_g0_46;
    bt_l1_37 = bt_l1_37 + (-5.8438638461666415e-07)*bt_g0_47;
    bt_l1_37 = bt_l1_37 + (-5.8633094113247353e-07)*bt_g0_48;
    bt_l1_37 = bt_l1_37 + (3.2941272820607992e-07)*bt_g0_49;
    bt_l1_37 = bt_l1_37 + (3.8288603718683589e-06)*bt_g0_50;
    bt_l1_37 = bt_l1_37 + (5.7805794995147153e-07)*bt_g0_51;
    bt_l1_37 = bt_l1_37 + (2.5169018158521794e-07)*bt_g0_52;
    bt_l1_37 = bt_l1_37 + (1.2184096931378008e-07)*bt_g0_53;
    bt_l1_37 = bt_l1_37 + (3.193280306845736e-08)*bt_g0_54;
    bt_l1_37 = bt_l1_37 + (3.5448795188131044e-07)*bt_g0_55;
    bt_l1_37 = bt_l1_37 + (-3.642910826329171e-07)*bt_g0_56;
    bt_l1_37 = bt_l1_37 + (-5.3612177453032928e-07)*bt_g0_57;
    bt_l1_37 = bt_l1_37 + (-0.0024408167228102684)*bt_g0_58;
    bt_l1_37 = bt_l1_37 + (-1.7394174278706487e-07)*bt_g0_59;
    bt_l1_37 = bt_l1_37 + (2.1694802398997126e-06)*bt_g0_60;
    bt_l1_37 = bt_l1_37 + (5.5550754041178152e-07)*bt_g0_61;
    bt_l1_37 = bt_l1_37 + (-3.9691357756055368e-07)*bt_g0_62;
    bt_l1_37 = bt_l1_37 + (0.0014182977611199021)*bt_g0_63;
    bt_l1_38 = 0.0093760257586836815;
    bt_l1_38 = bt_l1_38 + (3.8824309740448371e-06)*bt_g0_0;
    bt_l1_38 = bt_l1_38 + (-9.13919120648643e-06)*bt_g0_1;
    bt_l1_38 = bt_l1_38 + (0.069023281335830688)*bt_g0_2;
    bt_l1_38 = bt_l1_38 + (1.9643246105260914e-06)*bt_g0_3;
    bt_l1_38 = bt_l1_38 + (-8.898283340386115e-06)*bt_g0_4;
    bt_l1_38 = bt_l1_38 + (4.6731888687645551e-06)*bt_g0_5;
    bt_l1_38 = bt_l1_38 + (4.9642430894891731e-06)*bt_g0_6;
    bt_l1_38 = bt_l1_38 + (5.029301973991096e-06)*bt_g0_7;
    bt_l1_38 = bt_l1_38 + (-0.044945180416107178)*bt_g0_8;
    bt_l1_38 = bt_l1_38 + (-3.8396387935790699e-06)*bt_g0_9;
    bt_l1_38 = bt_l1_38 + (-0.00055941694881767035)*bt_g0_10;
    bt_l1_38 = bt_l1_38 + (4.5843105908716097e-05)*bt_g0_11;
    bt_l1_38 = bt_l1_38 + (5.62164859729819e-06)*bt_g0_12;
    bt_l1_38 = bt_l1_38 + (0.033539704978466034)*bt_g0_13;
    bt_l1_38 = bt_l1_38 + (-3.9650949474889785e-06)*bt_g0_14;
    bt_l1_38 = bt_l1_38 + (-4.2073356780747417e-06)*bt_g0_15;
    bt_l1_38 = bt_l1_38 + (-0.14263349771499634)*bt_g0_16;
    bt_l1_38 = bt_l1_38 + (0.22471654415130615)*bt_g0_17;
    bt_l1_38 = bt_l1_38 + (1.9216689906897955e-05)*bt_g0_18;
    bt_l1_38 = bt_l1_38 + (-7.466791771548742e-07)*bt_g0_19;
    bt_l1_38 = bt_l1_38 + (4.4812541091232561e-06)*bt_g0_20;
    bt_l1_38 = bt_l1_38 + (-4.1290941226179712e-06)*bt_g0_21;
    bt_l1_38 = bt_l1_38 + (0.063212096691131592)*bt_g0_22;
    bt_l1_38 = bt_l1_38 + (-6.408249191736104e-06)*bt_g0_23;
    bt_l1_38 = bt_l1_38 + (-4.70002078145626e-06)*bt_g0_24;
    bt_l1_38 = bt_l1_38 + (-3.353122565386002e-06)*bt_g0_25;
    bt_l1_38 = bt_l1_38 + (-9.8285518106422387e-06)*bt_g0_26;
    bt_l1_38 = bt_l1_38 + (0.049329318106174469)*bt_g0_27;
    bt_l1_38 = bt_l1_38 + (-6.7183628971179132e-07)*bt_g0_28;
    bt_l1_38 = bt_l1_38 + (-1.8238821212435141e-05)*bt_g0_29;
    bt_l1_38 = bt_l1_38 + (5.093979780212976e-06)*bt_g0_30;
    bt_l1_38 = bt_l1_38 + (-3.5750601909967372e-06)*bt_g0_31;
    bt_l1_38 = bt_l1_38 + (4.811925464309752e-06)*bt_g0_32;
    bt_l1_38 = bt_l1_38 + (9.3097860371926799e-06)*bt_g0_33;
    bt_l1_38 = bt_l1_38 + (-2.3710052232672751e-07)*bt_g0_34;
    bt_l1_38 = bt_l1_38 + (-4.7652374632889405e-06)*bt_g0_35;
    bt_l1_38 = bt_l1_38 + (-4.3233831092948094e-06)*bt_g0_36;
    bt_l1_38 = bt_l1_38 + (3.5472908166411798e-06)*bt_g0_37;
    bt_l1_38 = bt_l1_38 + (-4.892087872576667e-06)*bt_g0_38;
    bt_l1_38 = bt_l1_38 + (1.6752778719819617e-06)*bt_g0_39;
    bt_l1_38 = bt_l1_38 + (4.0862314563128166e-06)*bt_g0_40;
    bt_l1_38 = bt_l1_38 + (4.9252289500145707e-06)*bt_g0_41;
    bt_l1_38 = bt_l1_38 + (4.1576117837394122e-06)*bt_g0_42;
    bt_l1_38 = bt_l1_38 + (4.1447856347076595e-06)*bt_g0_43;
    bt_l1_38 = bt_l1_38 + (-3.6631042803492164e-06)*bt_g0_44;
    bt_l1_38 = bt_l1_38 + (1.3780696690446348e-06)*bt_g0_45;
    bt_l1_38 = bt_l1_38 + (-4.7823432396398857e-06)*bt_g0_46;
    bt_l1_38 = bt_l1_38 + (-4.6886561904102564e-06)*bt_g0_47;
    bt_l1_38 = bt_l1_38 + (-4.4040193643013481e-06)*bt_g0_48;
    bt_l1_38 = bt_l1_38 + (1.0539581580815138e-06)*bt_g0_49;
    bt_l1_38 = bt_l1_38 + (2.4204566216212697e-05)*bt_g0_50;
    bt_l1_38 = bt_l1_38 + (2.7361447791918181e-06)*bt_g0_51;
    bt_l1_38 = bt_l1_38 + (-1.2090891914340318e-06)*bt_g0_52;
    bt_l1_38 = bt_l1_38 + (2.232340193586424e-06)*bt_g0_53;
    bt_l1_38 = bt_l1_38 + (3.2034847663453547e-06)*bt_g0_54;
    bt_l1_38 = bt_l1_38 + (4.3442637434054632e-06)*bt_g0_55;
    bt_l1_38 = bt_l1_38 + (3.7397496726043755e-06)*bt_g0_56;
    bt_l1_38 = bt_l1_38 + (3.6186680517857894e-05)*bt_g0_57;
    bt_l1_38 = bt_l1_38 + (-0.016357706859707832)*bt_g0_58;
    bt_l1_38 = bt_l1_38 + (-2.5611318505980307e-06)*bt_g0_59;
    bt_l1_38 = bt_l1_38 + (-2.0664023395511322e-05)*bt_g0_60;
    bt_l1_38 = bt_l1_38 + (4.2670226321206428e-06)*bt_g0_61;
    bt_l1_38 = bt_l1_38 + (-4.0700410863792058e-06)*bt_g0_62;
    bt_l1_38 = bt_l1_38 + (-0.032997675240039825)*bt_g0_63;
    bt_l1_39 = 0.0070156441070139408;
    bt_l1_39 = bt_l1_39 + (4.1091885805144557e-07)*bt_g0_0;
    bt_l1_39 = bt_l1_39 + (8.3301694075998967e-07)*bt_g0_1;
    bt_l1_39 = bt_l1_39 + (-0.0024481997825205326)*bt_g0_2;
    bt_l1_39 = bt_l1_39 + (-6.184051670743429e-08)*bt_g0_3;
    bt_l1_39 = bt_l1_39 + (-1.7735180790623417e-07)*bt_g0_4;
    bt_l1_39 = bt_l1_39 + (4.5252602376422146e-07)*bt_g0_5;
    bt_l1_39 = bt_l1_39 + (5.7209581427741796e-07)*bt_g0_6;
    bt_l1_39 = bt_l1_39 + (5.7345260984220658e-07)*bt_g0_7;
    bt_l1_39 = bt_l1_39 + (0.0060919742099940777)*bt_g0_8;
    bt_l1_39 = bt_l1_39 + (-5.6733847486611921e-07)*bt_g0_9;
    bt_l1_39 = bt_l1_39 + (-0.00032119065872393548)*bt_g0_10;
    bt_l1_39 = bt_l1_39 + (-1.0482650623089285e-06)*bt_g0_11;
    bt_l1_39 = bt_l1_39 + (3.5984999158245046e-07)*bt_g0_12;
    bt_l1_39 = bt_l1_39 + (-0.0028173618484288454)*bt_g0_13;
    bt_l1_39 = bt_l1_39 + (-4.3657885839820665e-07)*bt_g0_14;
    bt_l1_39 = bt_l1_39 + (-3.8004165503480181e-07)*bt_g0_15;
    bt_l1_39 = bt_l1_39 + (0.00097823247779160738)*bt_g0_16;
    bt_l1_39 = bt_l1_39 + (0.001490284688770771)*bt_g0_17;
    bt_l1_39 = bt_l1_39 + (-2.2134340724733192e-06)*bt_g0_18;
    bt_l1_39 = bt_l1_39 + (5.4755219025537372e-07)*bt_g0_19;
    bt_l1_39 = bt_l1_39 + (5.6338711829084787e-07)*bt_g0_20;
    bt_l1_39 = bt_l1_39 + (-4.0161719994102896e-07)*bt_g0_21;
    bt_l1_39 = bt_l1_39 + (0.0015062864404171705)*bt_g0_22;
    bt_l1_39 = bt_l1_39 + (-9.6656933123995259e-08)*bt_g0_23;
    bt_l1_39 = bt_l1_39 + (-6.2711455939279404e-07)*bt_g0_24;
    bt_l1_39 = bt_l1_39 + (-8.1021710229833843e-08)*bt_g0_25;
    bt_l1_39 = bt_l1_39 + (-7.7195505809868337e-07)*bt_g0_26;
    bt_l1_39 = bt_l1_39 + (0.0005339171621017158)*bt_g0_27;
    bt_l1_39 = bt_l1_39 + (4.0172952253669791e-07)*bt_g0_28;
    bt_l1_39 = bt_l1_39 + (-3.0904441246093484e-06)*bt_g0_29;
    bt_l1_39 = bt_l1_39 + (4.8898556315180031e-07)*bt_g0_30;
    bt_l1_39 = bt_l1_39 + (-1.5051578827751655e-07)*bt_g0_31;
    bt_l1_39 = bt_l1_39 + (5.7893936400432722e-07)*bt_g0_32;
    bt_l1_39 = bt_l1_39 + (1.6688453570168349e-06)*bt_g0_33;
    bt_l1_39 = bt_l1_39 + (4.9144142622026266e-07)*bt_g0_34;
    bt_l1_39 = bt_l1_39 + (-4.4127352794021135e-07)*bt_g0_35;
    bt_l1_39 = bt_l1_39 + (-4.8526703722018283e-07)*bt_g0_36;
    bt_l1_39 = bt_l1_39 + (9.7577931512660143e-08)*bt_g0_37;
    bt_l1_39 = bt_l1_39 + (-5.6200889275714871e-07)*bt_g0_38;
    bt_l1_39 = bt_l1_39 + (-1.0825821163962246e-06)*bt_g0_39;
    bt_l1_39 = bt_l1_39 + (5.8718978834804147e-07)*bt_g0_40;
    bt_l1_39 = bt_l1_39 + (5.1439582193779643e-07)*bt_g0_41;
    bt_l1_39 = bt_l1_39 + (6.0628292430919828e-07)*bt_g0_42;
    bt_l1_39 = bt_l1_39 + (5.9926156836809241e-07)*bt_g0_43;
    bt_l1_39 = bt_l1_39 + (-2.1731202082264645e-07)*bt_g0_44;
    bt_l1_39 = bt_l1_39 + (-2.265713732185759e-07)*bt_g0_45;
    bt_l1_39 = bt_l1_39 + (-5.3124534815651714e-07)*bt_g0_46;
    bt_l1_39 = bt_l1_39 + (-5.8438627092982642e-07)*bt_g0_47;
    bt_l1_39 = bt_l1_39 + (-5.8633077060221694e-07)*bt_g0_48;
    bt_l1_39 = bt_l1_39 + (3.294119608199253e-07)*bt_g0_49;
    bt_l1_39 = bt_l1_39 + (3.8288408177322708e-06)*bt_g0_50;
    bt_l1_39 = bt_l1_39 + (5.7805817732514697e-07)*bt_g0_51;
    bt_l1_39 = bt_l1_39 + (2.516908921279537e-07)*bt_g0_52;
    bt_l1_39 = bt_l1_39 + (1.2184065667497634e-07)*bt_g0_53;
    bt_l1_39 = bt_l1_39 + (3.1931744359781078e-08)*bt_g0_54;
    bt_l1_39 = bt_l1_39 + (3.5448695712148037e-07)*bt_g0_55;
    bt_l1_39 = bt_l1_39 + (-3.6429017313821532e-07)*bt_g0_56;
    bt_l1_39 = bt_l1_39 + (-5.361279704629851e-07)*bt_g0_57;
    bt_l1_39 = bt_l1_39 + (-0.0024408041499555111)*bt_g0_58;
    bt_l1_39 = bt_l1_39 + (-1.7394108908774797e-07)*bt_g0_59;
    bt_l1_39 = bt_l1_39 + (2.1694784209103091e-06)*bt_g0_60;
    bt_l1_39 = bt_l1_39 + (5.5550719935126835e-07)*bt_g0_61;
    bt_l1_39 = bt_l1_39 + (-3.969130375480745e-07)*bt_g0_62;
    bt_l1_39 = bt_l1_39 + (0.0014182778540998697)*bt_g0_63;
    bt_l1_40 = 0.0070156771689653397;
    bt_l1_40 = bt_l1_40 + (4.109178632916155e-07)*bt_g0_0;
    bt_l1_40 = bt_l1_40 + (8.3302955999897677e-07)*bt_g0_1;
    bt_l1_40 = bt_l1_40 + (-0.0024481669533997774)*bt_g0_2;
    bt_l1_40 = bt_l1_40 + (-6.1843458354360337e-08)*bt_g0_3;
    bt_l1_40 = bt_l1_40 + (-1.7734416246639739e-07)*bt_g0_4;
    bt_l1_40 = bt_l1_40 + (4.5252386371430475e-07)*bt_g0_5;
    bt_l1_40 = bt_l1_40 + (5.720944500353653e-07)*bt_g0_6;
    bt_l1_40 = bt_l1_40 + (5.7345158666066709e-07)*bt_g0_7;
    bt_l1_40 = bt_l1_40 + (0.0060919197276234627)*bt_g0_8;
    bt_l1_40 = bt_l1_40 + (-5.6733807696218719e-07)*bt_g0_9;
    bt_l1_40 = bt_l1_40 + (-0.00032119100796990097)*bt_g0_10;
    bt_l1_40 = bt_l1_40 + (-1.0482910965947667e-06)*bt_g0_11;
    bt_l1_40 = bt_l1_40 + (3.5984700730296026e-07)*bt_g0_12;
    bt_l1_40 = bt_l1_40 + (-0.0028173353057354689)*bt_g0_13;
    bt_l1_40 = bt_l1_40 + (-4.3657817627718032e-07)*bt_g0_14;
    bt_l1_40 = bt_l1_40 + (-3.800394949848851e-07)*bt_g0_15;
    bt_l1_40 = bt_l1_40 + (0.00097807729616761208)*bt_g0_16;
    bt_l1_40 = bt_l1_40 + (0.0014902895782142878)*bt_g0_17;
    bt_l1_40 = bt_l1_40 + (-2.2134429400466615e-06)*bt_g0_18;
    bt_l1_40 = bt_l1_40 + (5.4755338396716979e-07)*bt_g0_19;
    bt_l1_40 = bt_l1_40 + (5.6338603826588951e-07)*bt_g0_20;
    bt_l1_40 = bt_l1_40 + (-4.0161529568649712e-07)*bt_g0_21;
    bt_l1_40 = bt_l1_40 + (0.0015062697930261493)*bt_g0_22;
    bt_l1_40 = bt_l1_40 + (-9.6652115644246805e-08)*bt_g0_23;
    bt_l1_40 = bt_l1_40 + (-6.2711342252441682e-07)*bt_g0_24;
    bt_l1_40 = bt_l1_40 + (-8.1018271202992764e-08)*bt_g0_25;
    bt_l1_40 = bt_l1_40 + (-7.7193794822960626e-07)*bt_g0_26;
    bt_l1_40 = bt_l1_40 + (0.00053387164371088147)*bt_g0_27;
    bt_l1_40 = bt_l1_40 + (4.0173188153858064e-07)*bt_g0_28;
    bt_l1_40 = bt_l1_40 + (-3.0903913739166455e-06)*bt_g0_29;
    bt_l1_40 = bt_l1_40 + (4.8898402837949106e-07)*bt_g0_30;
    bt_l1_40 = bt_l1_40 + (-1.5051300294999237e-07)*bt_g0_31;
    bt_l1_40 = bt_l1_40 + (5.7893788607543684e-07)*bt_g0_32;
    bt_l1_40 = bt_l1_40 + (1.6688162531863782e-06)*bt_g0_33;
    bt_l1_40 = bt_l1_40 + (4.9144023250846658e-07)*bt_g0_34;
    bt_l1_40 = bt_l1_40 + (-4.4127150999884179e-07)*bt_g0_35;
    bt_l1_40 = bt_l1_40 + (-4.8526612772548106e-07)*bt_g0_36;
    bt_l1_40 = bt_l1_40 + (9.7573789048510662e-08)*bt_g0_37;
    bt_l1_40 = bt_l1_40 + (-5.6200730114142061e-07)*bt_g0_38;
    bt_l1_40 = bt_l1_40 + (-1.0825782510437421e-06)*bt_g0_39;
    bt_l1_40 = bt_l1_40 + (5.8718921991385287e-07)*bt_g0_40;
    bt_l1_40 = bt_l1_40 + (5.1439417347864946e-07)*bt_g0_41;
    bt_l1_40 = bt_l1_40 + (6.0628264009210397e-07)*bt_g0_42;
    bt_l1_40 = bt_l1_40 + (5.9926111362074153e-07)*bt_g0_43;
    bt_l1_40 = bt_l1_40 + (-2.1730895127802796e-07)*bt_g0_44;
    bt_l1_40 = bt_l1_40 + (-2.2657449960661324e-07)*bt_g0_45;
    bt_l1_40 = bt_l1_40 + (-5.3124387022762676e-07)*bt_g0_46;
    bt_l1_40 = bt_l1_40 + (-5.8438502037461149e-07)*bt_g0_47;
    bt_l1_40 = bt_l1_40 + (-5.8632991795093403e-07)*bt_g0_48;
    bt_l1_40 = bt_l1_40 + (3.2940889127530681e-07)*bt_g0_49;
    bt_l1_40 = bt_l1_40 + (3.8287666939140763e-06)*bt_g0_50;
    bt_l1_40 = bt_l1_40 + (5.7805891628959216e-07)*bt_g0_51;
    bt_l1_40 = bt_l1_40 + (2.5169347850351187e-07)*bt_g0_52;
    bt_l1_40 = bt_l1_40 + (1.2183942033061612e-07)*bt_g0_53;
    bt_l1_40 = bt_l1_40 + (3.1928365729072539e-08)*bt_g0_54;
    bt_l1_40 = bt_l1_40 + (3.5448465496301651e-07)*bt_g0_55;
    bt_l1_40 = bt_l1_40 + (-3.6429199212761887e-07)*bt_g0_56;
    bt_l1_40 = bt_l1_40 + (-5.3615417527907994e-07)*bt_g0_57;
    bt_l1_40 = bt_l1_40 + (-0.0024407648015767336)*bt_g0_58;
    bt_l1_40 = bt_l1_40 + (-1.7393878692928411e-07)*bt_g0_59;
    bt_l1_40 = bt_l1_40 + (2.1694881979783531e-06)*bt_g0_60;
    bt_l1_40 = bt_l1_40 + (5.5550646038682316e-07)*bt_g0_61;
    bt_l1_40 = bt_l1_40 + (-3.9691099118499551e-07)*bt_g0_62;
    bt_l1_40 = bt_l1_40 + (0.0014182645827531815)*bt_g0_63;
    bt_l1_41 = 0.0070156492292881012;
    bt_l1_41 = bt_l1_41 + (4.1091928437708702e-07)*bt_g0_0;
    bt_l1_41 = bt_l1_41 + (8.3300835740374168e-07)*bt_g0_1;
    bt_l1_41 = bt_l1_41 + (-0.0024482270237058401)*bt_g0_2;
    bt_l1_41 = bt_l1_41 + (-6.1838370868372294e-08)*bt_g0_3;
    bt_l1_41 = bt_l1_41 + (-1.7735578694555443e-07)*bt_g0_4;
    bt_l1_41 = bt_l1_41 + (4.5252750169311184e-07)*bt_g0_5;
    bt_l1_41 = bt_l1_41 + (5.7209661008528201e-07)*bt_g0_6;
    bt_l1_41 = bt_l1_41 + (5.734537467105838e-07)*bt_g0_7;
    bt_l1_41 = bt_l1_41 + (0.0060920086689293385)*bt_g0_8;
    bt_l1_41 = bt_l1_41 + (-5.673386453963758e-07)*bt_g0_9;
    bt_l1_41 = bt_l1_41 + (-0.00032119077513925731)*bt_g0_10;
    bt_l1_41 = bt_l1_41 + (-1.0482503967068624e-06)*bt_g0_11;
    bt_l1_41 = bt_l1_41 + (3.5985212321065774e-07)*bt_g0_12;
    bt_l1_41 = bt_l1_41 + (-0.0028174207545816898)*bt_g0_13;
    bt_l1_41 = bt_l1_41 + (-4.3657954051923298e-07)*bt_g0_14;
    bt_l1_41 = bt_l1_41 + (-3.8004330349394877e-07)*bt_g0_15;
    bt_l1_41 = bt_l1_41 + (0.00097829767037183046)*bt_g0_16;
    bt_l1_41 = bt_l1_41 + (0.0014902648981660604)*bt_g0_17;
    bt_l1_41 = bt_l1_41 + (-2.2134352093416965e-06)*bt_g0_18;
    bt_l1_41 = bt_l1_41 + (5.4755167866460397e-07)*bt_g0_19;
    bt_l1_41 = bt_l1_41 + (5.6338757303819875e-07)*bt_g0_20;
    bt_l1_41 = bt_l1_41 + (-4.016184504962439e-07)*bt_g0_21;
    bt_l1_41 = bt_l1_41 + (0.001506278058513999)*bt_g0_22;
    bt_l1_41 = bt_l1_41 + (-9.6659917403485451e-08)*bt_g0_23;
    bt_l1_41 = bt_l1_41 + (-6.2711507098356378e-07)*bt_g0_24;
    bt_l1_41 = bt_l1_41 + (-8.1023998177442991e-08)*bt_g0_25;
    bt_l1_41 = bt_l1_41 + (-7.7196813208502135e-07)*bt_g0_26;
    bt_l1_41 = bt_l1_41 + (0.0005339448107406497)*bt_g0_27;
    bt_l1_41 = bt_l1_41 + (4.0172795934267924e-07)*bt_g0_28;
    bt_l1_41 = bt_l1_41 + (-3.0904773211659631e-06)*bt_g0_29;
    bt_l1_41 = bt_l1_41 + (4.8898721161094727e-07)*bt_g0_30;
    bt_l1_41 = bt_l1_41 + (-1.505180762251257e-07)*bt_g0_31;
    bt_l1_41 = bt_l1_41 + (5.7894044402928557e-07)*bt_g0_32;
    bt_l1_41 = bt_l1_41 + (1.6688652522134362e-06)*bt_g0_33;
    bt_l1_41 = bt_l1_41 + (4.9144267677547759e-07)*bt_g0_34;
    bt_l1_41 = bt_l1_41 + (-4.4127509113423002e-07)*bt_g0_35;
    bt_l1_41 = bt_l1_41 + (-4.8526754881095258e-07)*bt_g0_36;
    bt_l1_41 = bt_l1_41 + (9.758001340287592e-08)*bt_g0_37;
    bt_l1_41 = bt_l1_41 + (-5.6200968856501277e-07)*bt_g0_38;
    bt_l1_41 = bt_l1_41 + (-1.0825873459907598e-06)*bt_g0_39;
    bt_l1_41 = bt_l1_41 + (5.8719001572171692e-07)*bt_g0_40;
    bt_l1_41 = bt_l1_41 + (5.1439690196275478e-07)*bt_g0_41;
    bt_l1_41 = bt_l1_41 + (6.0628326536971144e-07)*bt_g0_42;
    bt_l1_41 = bt_l1_41 + (5.9926156836809241e-07)*bt_g0_43;
    bt_l1_41 = bt_l1_41 + (-2.1731389665546885e-07)*bt_g0_44;
    bt_l1_41 = bt_l1_41 + (-2.265693126446422e-07)*bt_g0_45;
    bt_l1_41 = bt_l1_41 + (-5.3124648502489435e-07)*bt_g0_46;
    bt_l1_41 = bt_l1_41 + (-5.8438683936401503e-07)*bt_g0_47;
    bt_l1_41 = bt_l1_41 + (-5.8633099797589239e-07)*bt_g0_48;
    bt_l1_41 = bt_l1_41 + (3.2941386507445714e-07)*bt_g0_49;
    bt_l1_41 = bt_l1_41 + (3.828892204182921e-06)*bt_g0_50;
    bt_l1_41 = bt_l1_41 + (5.7805783626463381e-07)*bt_g0_51;
    bt_l1_41 = bt_l1_41 + (2.5168907313855016e-07)*bt_g0_52;
    bt_l1_41 = bt_l1_41 + (1.218413672177121e-07)*bt_g0_53;
    bt_l1_41 = bt_l1_41 + (3.193425612835199e-08)*bt_g0_54;
    bt_l1_41 = bt_l1_41 + (3.5448869084575563e-07)*bt_g0_55;
    bt_l1_41 = bt_l1_41 + (-3.6429054262043792e-07)*bt_g0_56;
    bt_l1_41 = bt_l1_41 + (-5.3611051953339484e-07)*bt_g0_57;
    bt_l1_41 = bt_l1_41 + (-0.0024408416356891394)*bt_g0_58;
    bt_l1_41 = bt_l1_41 + (-1.739427091251855e-07)*bt_g0_59;
    bt_l1_41 = bt_l1_41 + (2.1694777387892827e-06)*bt_g0_60;
    bt_l1_41 = bt_l1_41 + (5.5550765409861924e-07)*bt_g0_61;
    bt_l1_41 = bt_l1_41 + (-3.9691425968158001e-07)*bt_g0_62;
    bt_l1_41 = bt_l1_41 + (0.001418282394297421)*bt_g0_63;
    bt_l1_42 = 0.0070156124420464039;
    bt_l1_42 = bt_l1_42 + (4.1091976754614734e-07)*bt_g0_0;
    bt_l1_42 = bt_l1_42 + (8.3300602682356839e-07)*bt_g0_1;
    bt_l1_42 = bt_l1_42 + (-0.0024482316803187132)*bt_g0_2;
    bt_l1_42 = bt_l1_42 + (-6.1838179021833639e-08)*bt_g0_3;
    bt_l1_42 = bt_l1_42 + (-1.7735685275965807e-07)*bt_g0_4;
    bt_l1_42 = bt_l1_42 + (4.5252761537994957e-07)*bt_g0_5;
    bt_l1_42 = bt_l1_42 + (5.7209678061553859e-07)*bt_g0_6;
    bt_l1_42 = bt_l1_42 + (5.7345368986716494e-07)*bt_g0_7;
    bt_l1_42 = bt_l1_42 + (0.0060920193791389465)*bt_g0_8;
    bt_l1_42 = bt_l1_42 + (-5.6733875908321352e-07)*bt_g0_9;
    bt_l1_42 = bt_l1_42 + (-0.00032119028037413955)*bt_g0_10;
    bt_l1_42 = bt_l1_42 + (-1.0482484640306211e-06)*bt_g0_11;
    bt_l1_42 = bt_l1_42 + (3.5985240742775204e-07)*bt_g0_12;
    bt_l1_42 = bt_l1_42 + (-0.0028174065519124269)*bt_g0_13;
    bt_l1_42 = bt_l1_42 + (-4.3657982473632728e-07)*bt_g0_14;
    bt_l1_42 = bt_l1_42 + (-3.800436161327525e-07)*bt_g0_15;
    bt_l1_42 = bt_l1_42 + (0.00097834609914571047)*bt_g0_16;
    bt_l1_42 = bt_l1_42 + (0.0014903012197464705)*bt_g0_17;
    bt_l1_42 = bt_l1_42 + (-2.2134311166155385e-06)*bt_g0_18;
    bt_l1_42 = bt_l1_42 + (5.4755167866460397e-07)*bt_g0_19;
    bt_l1_42 = bt_l1_42 + (5.6338802778554964e-07)*bt_g0_20;
    bt_l1_42 = bt_l1_42 + (-4.0161870629162877e-07)*bt_g0_21;
    bt_l1_42 = bt_l1_42 + (0.0015062927268445492)*bt_g0_22;
    bt_l1_42 = bt_l1_42 + (-9.666054268109292e-08)*bt_g0_23;
    bt_l1_42 = bt_l1_42 + (-6.2711507098356378e-07)*bt_g0_24;
    bt_l1_42 = bt_l1_42 + (-8.1024275289109937e-08)*bt_g0_25;
    bt_l1_42 = bt_l1_42 + (-7.7196955317049287e-07)*bt_g0_26;
    bt_l1_42 = bt_l1_42 + (0.00053395587019622326)*bt_g0_27;
    bt_l1_42 = bt_l1_42 + (4.0172790249926038e-07)*bt_g0_28;
    bt_l1_42 = bt_l1_42 + (-3.0904850518709281e-06)*bt_g0_29;
    bt_l1_42 = bt_l1_42 + (4.8898755267146043e-07)*bt_g0_30;
    bt_l1_42 = bt_l1_42 + (-1.5051838886392943e-07)*bt_g0_31;
    bt_l1_42 = bt_l1_42 + (5.7894067140296102e-07)*bt_g0_32;
    bt_l1_42 = bt_l1_42 + (1.6688694586264319e-06)*bt_g0_33;
    bt_l1_42 = bt_l1_42 + (4.9144273361889645e-07)*bt_g0_34;
    bt_l1_42 = bt_l1_42 + (-4.4127526166448661e-07)*bt_g0_35;
    bt_l1_42 = bt_l1_42 + (-4.8526788987146574e-07)*bt_g0_36;
    bt_l1_42 = bt_l1_42 + (9.7581164482107852e-08)*bt_g0_37;
    bt_l1_42 = bt_l1_42 + (-5.6200963172159391e-07)*bt_g0_38;
    bt_l1_42 = bt_l1_42 + (-1.0825858680618694e-06)*bt_g0_39;
    bt_l1_42 = bt_l1_42 + (5.8719007256513578e-07)*bt_g0_40;
    bt_l1_42 = bt_l1_42 + (5.1439712933643023e-07)*bt_g0_41;
    bt_l1_42 = bt_l1_42 + (6.0628337905654917e-07)*bt_g0_42;
    bt_l1_42 = bt_l1_42 + (5.9926168205493013e-07)*bt_g0_43;
    bt_l1_42 = bt_l1_42 + (-2.1731418087256316e-07)*bt_g0_44;
    bt_l1_42 = bt_l1_42 + (-2.2656919895780447e-07)*bt_g0_45;
    bt_l1_42 = bt_l1_42 + (-5.312469966156641e-07)*bt_g0_46;
    bt_l1_42 = bt_l1_42 + (-5.8438706673769047e-07)*bt_g0_47;
    bt_l1_42 = bt_l1_42 + (-5.8633122534956783e-07)*bt_g0_48;
    bt_l1_42 = bt_l1_42 + (3.2941434824351745e-07)*bt_g0_49;
    bt_l1_42 = bt_l1_42 + (3.8288994801405352e-06)*bt_g0_50;
    bt_l1_42 = bt_l1_42 + (5.7805760889095836e-07)*bt_g0_51;
    bt_l1_42 = bt_l1_42 + (2.5168884576487471e-07)*bt_g0_52;
    bt_l1_42 = bt_l1_42 + (1.2184170827822527e-07)*bt_g0_53;
    bt_l1_42 = bt_l1_42 + (3.1934558109014688e-08)*bt_g0_54;
    bt_l1_42 = bt_l1_42 + (3.5448917401481594e-07)*bt_g0_55;
    bt_l1_42 = bt_l1_42 + (-3.6428934890864184e-07)*bt_g0_56;
    bt_l1_42 = bt_l1_42 + (-5.3610762051903293e-07)*bt_g0_57;
    bt_l1_42 = bt_l1_42 + (-0.0024408339522778988)*bt_g0_58;
    bt_l1_42 = bt_l1_42 + (-1.7394299334227981e-07)*bt_g0_59;
    bt_l1_42 = bt_l1_42 + (2.1694743281841511e-06)*bt_g0_60;
    bt_l1_42 = bt_l1_42 + (5.555077109420381e-07)*bt_g0_61;
    bt_l1_42 = bt_l1_42 + (-3.9691431652499887e-07)*bt_g0_62;
    bt_l1_42 = bt_l1_42 + (0.0014182834420353174)*bt_g0_63;
    bt_l1_43 = 0.0070156003348529339;
    bt_l1_43 = bt_l1_43 + (4.1091911384683044e-07)*bt_g0_0;
    bt_l1_43 = bt_l1_43 + (8.3301273434699397e-07)*bt_g0_1;
    bt_l1_43 = bt_l1_43 + (-0.0024481776636093855)*bt_g0_2;
    bt_l1_43 = bt_l1_43 + (-6.1839308784783498e-08)*bt_g0_3;
    bt_l1_43 = bt_l1_43 + (-1.7735415269726218e-07)*bt_g0_4;
    bt_l1_43 = bt_l1_43 + (4.5252676272866665e-07)*bt_g0_5;
    bt_l1_43 = bt_l1_43 + (5.7209632586818771e-07)*bt_g0_6;
    bt_l1_43 = bt_l1_43 + (5.7345300774613861e-07)*bt_g0_7;
    bt_l1_43 = bt_l1_43 + (0.0060920072719454765)*bt_g0_8;
    bt_l1_43 = bt_l1_43 + (-5.6733875908321352e-07)*bt_g0_9;
    bt_l1_43 = bt_l1_43 + (-0.00032119054230861366)*bt_g0_10;
    bt_l1_43 = bt_l1_43 + (-1.0482581274118274e-06)*bt_g0_11;
    bt_l1_43 = bt_l1_43 + (3.5985124213766539e-07)*bt_g0_12;
    bt_l1_43 = bt_l1_43 + (-0.0028173534665256739)*bt_g0_13;
    bt_l1_43 = bt_l1_43 + (-4.365792847238481e-07)*bt_g0_14;
    bt_l1_43 = bt_l1_43 + (-3.8004259295121301e-07)*bt_g0_15;
    bt_l1_43 = bt_l1_43 + (0.00097833247855305672)*bt_g0_16;
    bt_l1_43 = bt_l1_43 + (0.0014903178671374917)*bt_g0_17;
    bt_l1_43 = bt_l1_43 + (-2.2134379378258018e-06)*bt_g0_18;
    bt_l1_43 = bt_l1_43 + (5.4755184919486055e-07)*bt_g0_19;
    bt_l1_43 = bt_l1_43 + (5.6338740250794217e-07)*bt_g0_20;
    bt_l1_43 = bt_l1_43 + (-4.0161793890547415e-07)*bt_g0_21;
    bt_l1_43 = bt_l1_43 + (0.0015062895836308599)*bt_g0_22;
    bt_l1_43 = bt_l1_43 + (-9.6658787640535593e-08)*bt_g0_23;
    bt_l1_43 = bt_l1_43 + (-6.2711467307963176e-07)*bt_g0_24;
    bt_l1_43 = bt_l1_43 + (-8.1023095788168575e-08)*bt_g0_25;
    bt_l1_43 = bt_l1_43 + (-7.719618224655278e-07)*bt_g0_26;
    bt_l1_43 = bt_l1_43 + (0.00053394021233543754)*bt_g0_27;
    bt_l1_43 = bt_l1_43 + (4.0172864146370557e-07)*bt_g0_28;
    bt_l1_43 = bt_l1_43 + (-3.0904632239980856e-06)*bt_g0_29;
    bt_l1_43 = bt_l1_43 + (4.8898652948992094e-07)*bt_g0_30;
    bt_l1_43 = bt_l1_43 + (-1.5051718094127864e-07)*bt_g0_31;
    bt_l1_43 = bt_l1_43 + (5.7893987559509696e-07)*bt_g0_32;
    bt_l1_43 = bt_l1_43 + (1.6688570667611202e-06)*bt_g0_33;
    bt_l1_43 = bt_l1_43 + (4.9144222202812671e-07)*bt_g0_34;
    bt_l1_43 = bt_l1_43 + (-4.4127457954346028e-07)*bt_g0_35;
    bt_l1_43 = bt_l1_43 + (-4.8526732143727713e-07)*bt_g0_36;
    bt_l1_43 = bt_l1_43 + (9.7579004432191141e-08)*bt_g0_37;
    bt_l1_43 = bt_l1_43 + (-5.6200923381766188e-07)*bt_g0_38;
    bt_l1_43 = bt_l1_43 + (-1.0825868912434089e-06)*bt_g0_39;
    bt_l1_43 = bt_l1_43 + (5.871899020348792e-07)*bt_g0_40;
    bt_l1_43 = bt_l1_43 + (5.1439639037198504e-07)*bt_g0_41;
    bt_l1_43 = bt_l1_43 + (6.0628337905654917e-07)*bt_g0_42;
    bt_l1_43 = bt_l1_43 + (5.9926151152467355e-07)*bt_g0_43;
    bt_l1_43 = bt_l1_43 + (-2.1731315769102366e-07)*bt_g0_44;
    bt_l1_43 = bt_l1_43 + (-2.265702505610534e-07)*bt_g0_45;
    bt_l1_43 = bt_l1_43 + (-5.3124608712096233e-07)*bt_g0_46;
    bt_l1_43 = bt_l1_43 + (-5.8438644146008301e-07)*bt_g0_47;
    bt_l1_43 = bt_l1_43 + (-5.8633099797589239e-07)*bt_g0_48;
    bt_l1_43 = bt_l1_43 + (3.2941292715804593e-07)*bt_g0_49;
    bt_l1_43 = bt_l1_43 + (3.8288758332782891e-06)*bt_g0_50;
    bt_l1_43 = bt_l1_43 + (5.7805794995147153e-07)*bt_g0_51;
    bt_l1_43 = bt_l1_43 + (2.5168975525957649e-07)*bt_g0_52;
    bt_l1_43 = bt_l1_43 + (1.2184104036805365e-07)*bt_g0_53;
    bt_l1_43 = bt_l1_43 + (3.1933140576256847e-08)*bt_g0_54;
    bt_l1_43 = bt_l1_43 + (3.5448812241156702e-07)*bt_g0_55;
    bt_l1_43 = bt_l1_43 + (-3.6429096894607937e-07)*bt_g0_56;
    bt_l1_43 = bt_l1_43 + (-5.3611842076861649e-07)*bt_g0_57;
    bt_l1_43 = bt_l1_43 + (-0.0024407836608588696)*bt_g0_58;
    bt_l1_43 = bt_l1_43 + (-1.7394209805843275e-07)*bt_g0_59;
    bt_l1_43 = bt_l1_43 + (2.1694806946470635e-06)*bt_g0_60;
    bt_l1_43 = bt_l1_43 + (5.5550736988152494e-07)*bt_g0_61;
    bt_l1_43 = bt_l1_43 + (-3.9691357756055368e-07)*bt_g0_62;
    bt_l1_43 = bt_l1_43 + (0.0014182997401803732)*bt_g0_63;
    bt_l1_44 = 0.007015750277787447;
    bt_l1_44 = bt_l1_44 + (4.1091669800152886e-07)*bt_g0_0;
    bt_l1_44 = bt_l1_44 + (8.330447371918126e-07)*bt_g0_1;
    bt_l1_44 = bt_l1_44 + (-0.0024481380823999643)*bt_g0_2;
    bt_l1_44 = bt_l1_44 + (-6.1845845777952491e-08)*bt_g0_3;
    bt_l1_44 = bt_l1_44 + (-1.7733663071339834e-07)*bt_g0_4;
    bt_l1_44 = bt_l1_44 + (4.5252193103806349e-07)*bt_g0_5;
    bt_l1_44 = bt_l1_44 + (5.7209274473279947e-07)*bt_g0_6;
    bt_l1_44 = bt_l1_44 + (5.7344993820152013e-07)*bt_g0_7;
    bt_l1_44 = bt_l1_44 + (0.0060918633826076984)*bt_g0_8;
    bt_l1_44 = bt_l1_44 + (-5.6733773590167402e-07)*bt_g0_9;
    bt_l1_44 = bt_l1_44 + (-0.00032118684612214565)*bt_g0_10;
    bt_l1_44 = bt_l1_44 + (-1.0483209962330875e-06)*bt_g0_11;
    bt_l1_44 = bt_l1_44 + (3.5984385249321349e-07)*bt_g0_12;
    bt_l1_44 = bt_l1_44 + (-0.0028173467144370079)*bt_g0_13;
    bt_l1_44 = bt_l1_44 + (-4.365770394088031e-07)*bt_g0_14;
    bt_l1_44 = bt_l1_44 + (-3.8003733493496838e-07)*bt_g0_15;
    bt_l1_44 = bt_l1_44 + (0.00097790302243083715)*bt_g0_16;
    bt_l1_44 = bt_l1_44 + (0.0014902615221217275)*bt_g0_17;
    bt_l1_44 = bt_l1_44 + (-2.2134579467092408e-06)*bt_g0_18;
    bt_l1_44 = bt_l1_44 + (5.4755435030529043e-07)*bt_g0_19;
    bt_l1_44 = bt_l1_44 + (5.6338473086725571e-07)*bt_g0_20;
    bt_l1_44 = bt_l1_44 + (-4.0161324932341813e-07)*bt_g0_21;
    bt_l1_44 = bt_l1_44 + (0.0015062614111229777)*bt_g0_22;
    bt_l1_44 = bt_l1_44 + (-9.6646317615523003e-08)*bt_g0_23;
    bt_l1_44 = bt_l1_44 + (-6.271122856560396e-07)*bt_g0_24;
    bt_l1_44 = bt_l1_44 + (-8.1015244290938426e-08)*bt_g0_25;
    bt_l1_44 = bt_l1_44 + (-7.7192356684463448e-07)*bt_g0_26;
    bt_l1_44 = bt_l1_44 + (0.00053382973419502378)*bt_g0_27;
    bt_l1_44 = bt_l1_44 + (4.0173378579311247e-07)*bt_g0_28;
    bt_l1_44 = bt_l1_44 + (-3.0903472634236095e-06)*bt_g0_29;
    bt_l1_44 = bt_l1_44 + (4.8898198201641208e-07)*bt_g0_30;
    bt_l1_44 = bt_l1_44 + (-1.5050999024879275e-07)*bt_g0_31;
    bt_l1_44 = bt_l1_44 + (5.7893618077287101e-07)*bt_g0_32;
    bt_l1_44 = bt_l1_44 + (1.6687946526872111e-06)*bt_g0_33;
    bt_l1_44 = bt_l1_44 + (4.9143960723085911e-07)*bt_g0_34;
    bt_l1_44 = bt_l1_44 + (-4.4126912257524964e-07)*bt_g0_35;
    bt_l1_44 = bt_l1_44 + (-4.8526493401368498e-07)*bt_g0_36;
    bt_l1_44 = bt_l1_44 + (9.7569198942437652e-08)*bt_g0_37;
    bt_l1_44 = bt_l1_44 + (-5.6200639164671884e-07)*bt_g0_38;
    bt_l1_44 = bt_l1_44 + (-1.0825783647305798e-06)*bt_g0_39;
    bt_l1_44 = bt_l1_44 + (5.8718825357573223e-07)*bt_g0_40;
    bt_l1_44 = bt_l1_44 + (5.1439218395898934e-07)*bt_g0_41;
    bt_l1_44 = bt_l1_44 + (6.0628184428423992e-07)*bt_g0_42;
    bt_l1_44 = bt_l1_44 + (5.9926026096945861e-07)*bt_g0_43;
    bt_l1_44 = bt_l1_44 + (-2.1730642174588866e-07)*bt_g0_44;
    bt_l1_44 = bt_l1_44 + (-2.265770717713167e-07)*bt_g0_45;
    bt_l1_44 = bt_l1_44 + (-5.3124182386454777e-07)*bt_g0_46;
    bt_l1_44 = bt_l1_44 + (-5.8438376981939655e-07)*bt_g0_47;
    bt_l1_44 = bt_l1_44 + (-5.8632878108255682e-07)*bt_g0_48;
    bt_l1_44 = bt_l1_44 + (3.2940613436949207e-07)*bt_g0_49;
    bt_l1_44 = bt_l1_44 + (3.8287116694846191e-06)*bt_g0_50;
    bt_l1_44 = bt_l1_44 + (5.7805931419352419e-07)*bt_g0_51;
    bt_l1_44 = bt_l1_44 + (2.516957522402663e-07)*bt_g0_52;
    bt_l1_44 = bt_l1_44 + (1.2183787134745216e-07)*bt_g0_53;
    bt_l1_44 = bt_l1_44 + (3.1925395660437061e-08)*bt_g0_54;
    bt_l1_44 = bt_l1_44 + (3.5448235280455265e-07)*bt_g0_55;
    bt_l1_44 = bt_l1_44 + (-3.6429591432352026e-07)*bt_g0_56;
    bt_l1_44 = bt_l1_44 + (-5.3618293804902351e-07)*bt_g0_57;
    bt_l1_44 = bt_l1_44 + (-0.0024407596793025732)*bt_g0_58;
    bt_l1_44 = bt_l1_44 + (-1.7393676898791455e-07)*bt_g0_59;
    bt_l1_44 = bt_l1_44 + (2.1695063878723886e-06)*bt_g0_60;
    bt_l1_44 = bt_l1_44 + (5.5550543720528367e-07)*bt_g0_61;
    bt_l1_44 = bt_l1_44 + (-3.9690905850875424e-07)*bt_g0_62;
    bt_l1_44 = bt_l1_44 + (0.0014182566665112972)*bt_g0_63;
    bt_l1_45 = -0.036861144006252289;
    bt_l1_45 = bt_l1_45 + (7.1371641752193682e-06)*bt_g0_0;
    bt_l1_45 = bt_l1_45 + (-1.4194994264471461e-06)*bt_g0_1;
    bt_l1_45 = bt_l1_45 + (-0.051009774208068848)*bt_g0_2;
    bt_l1_45 = bt_l1_45 + (-1.4139731092654984e-06)*bt_g0_3;
    bt_l1_45 = bt_l1_45 + (-4.4417747631086968e-06)*bt_g0_4;
    bt_l1_45 = bt_l1_45 + (7.4069416768907104e-06)*bt_g0_5;
    bt_l1_45 = bt_l1_45 + (9.3548624136019498e-06)*bt_g0_6;
    bt_l1_45 = bt_l1_45 + (9.376714842801448e-06)*bt_g0_7;
    bt_l1_45 = bt_l1_45 + (-0.1933513730764389)*bt_g0_8;
    bt_l1_45 = bt_l1_45 + (-9.0057528723264113e-06)*bt_g0_9;
    bt_l1_45 = bt_l1_45 + (0.044969551265239716)*bt_g0_10;
    bt_l1_45 = bt_l1_45 + (6.1722658983853762e-08)*bt_g0_11;
    bt_l1_45 = bt_l1_45 + (5.7688657761900686e-06)*bt_g0_12;
    bt_l1_45 = bt_l1_45 + (0.24017368257045746)*bt_g0_13;
    bt_l1_45 = bt_l1_45 + (-7.5906496022071224e-06)*bt_g0_14;
    bt_l1_45 = bt_l1_45 + (-6.1203277255117428e-06)*bt_g0_15;
    bt_l1_45 = bt_l1_45 + (0.077192492783069611)*bt_g0_16;
    bt_l1_45 = bt_l1_45 + (-0.0076911645010113716)*bt_g0_17;
    bt_l1_45 = bt_l1_45 + (8.2540454968693666e-06)*bt_g0_18;
    bt_l1_45 = bt_l1_45 + (6.544457846757723e-06)*bt_g0_19;
    bt_l1_45 = bt_l1_45 + (9.0767434812732972e-06)*bt_g0_20;
    bt_l1_45 = bt_l1_45 + (-6.5112094489450101e-06)*bt_g0_21;
    bt_l1_45 = bt_l1_45 + (-0.024157555773854256)*bt_g0_22;
    bt_l1_45 = bt_l1_45 + (-2.9848501981177833e-06)*bt_g0_23;
    bt_l1_45 = bt_l1_45 + (-9.7646152426023036e-06)*bt_g0_24;
    bt_l1_45 = bt_l1_45 + (-1.0406488399894442e-06)*bt_g0_25;
    bt_l1_45 = bt_l1_45 + (5.6480243983969558e-06)*bt_g0_26;
    bt_l1_45 = bt_l1_45 + (-0.046667654067277908)*bt_g0_27;
    bt_l1_45 = bt_l1_45 + (5.9166022765566595e-06)*bt_g0_28;
    bt_l1_45 = bt_l1_45 + (2.3154285372584127e-05)*bt_g0_29;
    bt_l1_45 = bt_l1_45 + (8.3030099631287158e-06)*bt_g0_30;
    bt_l1_45 = bt_l1_45 + (-2.2026902115612756e-06)*bt_g0_31;
    bt_l1_45 = bt_l1_45 + (8.8267061073565856e-06)*bt_g0_32;
    bt_l1_45 = bt_l1_45 + (-1.224838342750445e-05)*bt_g0_33;
    bt_l1_45 = bt_l1_45 + (2.9581754006358096e-06)*bt_g0_34;
    bt_l1_45 = bt_l1_45 + (-7.2246230047312565e-06)*bt_g0_35;
    bt_l1_45 = bt_l1_45 + (-8.3691256804740988e-06)*bt_g0_36;
    bt_l1_45 = bt_l1_45 + (4.0225195334642194e-06)*bt_g0_37;
    bt_l1_45 = bt_l1_45 + (-9.1154170149820857e-06)*bt_g0_38;
    bt_l1_45 = bt_l1_45 + (6.5365961745555978e-06)*bt_g0_39;
    bt_l1_45 = bt_l1_45 + (9.1576721388264559e-06)*bt_g0_40;
    bt_l1_45 = bt_l1_45 + (8.4256016634753905e-06)*bt_g0_41;
    bt_l1_45 = bt_l1_45 + (9.4140868895919994e-06)*bt_g0_42;
    bt_l1_45 = bt_l1_45 + (9.3199605544214137e-06)*bt_g0_43;
    bt_l1_45 = bt_l1_45 + (-3.2520013064640807e-06)*bt_g0_44;
    bt_l1_45 = bt_l1_45 + (-3.8633215808658861e-06)*bt_g0_45;
    bt_l1_45 = bt_l1_45 + (-8.4703615357284434e-06)*bt_g0_46;
    bt_l1_45 = bt_l1_45 + (-9.312377187598031e-06)*bt_g0_47;
    bt_l1_45 = bt_l1_45 + (-9.2412856247392483e-06)*bt_g0_48;
    bt_l1_45 = bt_l1_45 + (2.8905299132020446e-06)*bt_g0_49;
    bt_l1_45 = bt_l1_45 + (-3.0759296350879595e-05)*bt_g0_50;
    bt_l1_45 = bt_l1_45 + (7.6518072091857903e-06)*bt_g0_51;
    bt_l1_45 = bt_l1_45 + (4.1613689063524362e-06)*bt_g0_52;
    bt_l1_45 = bt_l1_45 + (2.3560726276627975e-06)*bt_g0_53;
    bt_l1_45 = bt_l1_45 + (2.5162512429233175e-07)*bt_g0_54;
    bt_l1_45 = bt_l1_45 + (5.7112079048238229e-06)*bt_g0_55;
    bt_l1_45 = bt_l1_45 + (4.2693309296737425e-06)*bt_g0_56;
    bt_l1_45 = bt_l1_45 + (2.9690893370570848e-06)*bt_g0_57;
    bt_l1_45 = bt_l1_45 + (-0.018729694187641144)*bt_g0_58;
    bt_l1_45 = bt_l1_45 + (-2.2521669507113984e-06)*bt_g0_59;
    bt_l1_45 = bt_l1_45 + (-7.8968650996102951e-06)*bt_g0_60;
    bt_l1_45 = bt_l1_45 + (8.8858732851804234e-06)*bt_g0_61;
    bt_l1_45 = bt_l1_45 + (-6.3777824834687635e-06)*bt_g0_62;
    bt_l1_45 = bt_l1_45 + (-0.0033883866854012012)*bt_g0_63;
    bt_l1_46 = 0.0070156645961105824;
    bt_l1_46 = bt_l1_46 + (4.1091828961725696e-07)*bt_g0_0;
    bt_l1_46 = bt_l1_46 + (8.3302728626222233e-07)*bt_g0_1;
    bt_l1_46 = bt_l1_46 + (-0.0024481713771820068)*bt_g0_2;
    bt_l1_46 = bt_l1_46 + (-6.1842897025599086e-08)*bt_g0_3;
    bt_l1_46 = bt_l1_46 + (-1.7734555513015948e-07)*bt_g0_4;
    bt_l1_46 = bt_l1_46 + (4.5252471636558766e-07)*bt_g0_5;
    bt_l1_46 = bt_l1_46 + (5.7209507531297277e-07)*bt_g0_6;
    bt_l1_46 = bt_l1_46 + (5.734521550948557e-07)*bt_g0_7;
    bt_l1_46 = bt_l1_46 + (0.00609193230047822)*bt_g0_8;
    bt_l1_46 = bt_l1_46 + (-5.6733875908321352e-07)*bt_g0_9;
    bt_l1_46 = bt_l1_46 + (-0.00032119231764227152)*bt_g0_10;
    bt_l1_46 = bt_l1_46 + (-1.0482854122528806e-06)*bt_g0_11;
    bt_l1_46 = bt_l1_46 + (3.5984780311082432e-07)*bt_g0_12;
    bt_l1_46 = bt_l1_46 + (-0.0028173474129289389)*bt_g0_13;
    bt_l1_46 = bt_l1_46 + (-4.3657865944624064e-07)*bt_g0_14;
    bt_l1_46 = bt_l1_46 + (-3.8004026237103972e-07)*bt_g0_15;
    bt_l1_46 = bt_l1_46 + (0.00097811839077621698)*bt_g0_16;
    bt_l1_46 = bt_l1_46 + (0.0014902851544320583)*bt_g0_17;
    bt_l1_46 = bt_l1_46 + (-2.2134415758046089e-06)*bt_g0_18;
    bt_l1_46 = bt_l1_46 + (5.4755338396716979e-07)*bt_g0_19;
    bt_l1_46 = bt_l1_46 + (5.633867772303347e-07)*bt_g0_20;
    bt_l1_46 = bt_l1_46 + (-4.0161594938581402e-07)*bt_g0_21;
    bt_l1_46 = bt_l1_46 + (0.0015062831807881594)*bt_g0_22;
    bt_l1_46 = bt_l1_46 + (-9.6653081982367439e-08)*bt_g0_23;
    bt_l1_46 = bt_l1_46 + (-6.2711404780202429e-07)*bt_g0_24;
    bt_l1_46 = bt_l1_46 + (-8.1019074116284173e-08)*bt_g0_25;
    bt_l1_46 = bt_l1_46 + (-7.7194249570311513e-07)*bt_g0_26;
    bt_l1_46 = bt_l1_46 + (0.00053388334345072508)*bt_g0_27;
    bt_l1_46 = bt_l1_46 + (4.0173148363464861e-07)*bt_g0_28;
    bt_l1_46 = bt_l1_46 + (-3.0904006962373387e-06)*bt_g0_29;
    bt_l1_46 = bt_l1_46 + (4.8898459681367967e-07)*bt_g0_30;
    bt_l1_46 = bt_l1_46 + (-1.5051355717332626e-07)*bt_g0_31;
    bt_l1_46 = bt_l1_46 + (5.7893856819646317e-07)*bt_g0_32;
    bt_l1_46 = bt_l1_46 + (1.668822847022966e-06)*bt_g0_33;
    bt_l1_46 = bt_l1_46 + (4.9144068725581747e-07)*bt_g0_34;
    bt_l1_46 = bt_l1_46 + (-4.4127219211986812e-07)*bt_g0_35;
    bt_l1_46 = bt_l1_46 + (-4.8526652562941308e-07)*bt_g0_36;
    bt_l1_46 = bt_l1_46 + (9.7575060920007672e-08)*bt_g0_37;
    bt_l1_46 = bt_l1_46 + (-5.6200815379270352e-07)*bt_g0_38;
    bt_l1_46 = bt_l1_46 + (-1.082580297406821e-06)*bt_g0_39;
    bt_l1_46 = bt_l1_46 + (5.8718973150462261e-07)*bt_g0_40;
    bt_l1_46 = bt_l1_46 + (5.1439462822600035e-07)*bt_g0_41;
    bt_l1_46 = bt_l1_46 + (6.0628315168287372e-07)*bt_g0_42;
    bt_l1_46 = bt_l1_46 + (5.9926162521151127e-07)*bt_g0_43;
    bt_l1_46 = bt_l1_46 + (-2.173097328750373e-07)*bt_g0_44;
    bt_l1_46 = bt_l1_46 + (-2.2657390275071521e-07)*bt_g0_45;
    bt_l1_46 = bt_l1_46 + (-5.312443818183965e-07)*bt_g0_46;
    bt_l1_46 = bt_l1_46 + (-5.8438536143512465e-07)*bt_g0_47;
    bt_l1_46 = bt_l1_46 + (-5.8633048638512264e-07)*bt_g0_48;
    bt_l1_46 = bt_l1_46 + (3.2940988603513688e-07)*bt_g0_49;
    bt_l1_46 = bt_l1_46 + (3.82878397431341e-06)*bt_g0_50;
    bt_l1_46 = bt_l1_46 + (5.7805914366326761e-07)*bt_g0_51;
    bt_l1_46 = bt_l1_46 + (2.5169316586470813e-07)*bt_g0_52;
    bt_l1_46 = bt_l1_46 + (1.2183983244540286e-07)*bt_g0_53;
    bt_l1_46 = bt_l1_46 + (3.1929193511359699e-08)*bt_g0_54;
    bt_l1_46 = bt_l1_46 + (3.5448522339720512e-07)*bt_g0_55;
    bt_l1_46 = bt_l1_46 + (-3.642920205493283e-07)*bt_g0_56;
    bt_l1_46 = bt_l1_46 + (-5.3614832040693727e-07)*bt_g0_57;
    bt_l1_46 = bt_l1_46 + (-0.0024407715536653996)*bt_g0_58;
    bt_l1_46 = bt_l1_46 + (-1.7393946905031044e-07)*bt_g0_59;
    bt_l1_46 = bt_l1_46 + (2.1694875158573268e-06)*bt_g0_60;
    bt_l1_46 = bt_l1_46 + (5.5550725619468722e-07)*bt_g0_61;
    bt_l1_46 = bt_l1_46 + (-3.9691175857115013e-07)*bt_g0_62;
    bt_l1_46 = bt_l1_46 + (0.0014182720333337784)*bt_g0_63;
    bt_l1_47 = 0.0070156222209334373;
    bt_l1_47 = bt_l1_47 + (4.1091936964221532e-07)*bt_g0_0;
    bt_l1_47 = bt_l1_47 + (8.3301307540750713e-07)*bt_g0_1;
    bt_l1_47 = bt_l1_47 + (-0.0024482051376253366)*bt_g0_2;
    bt_l1_47 = bt_l1_47 + (-6.1839550369313656e-08)*bt_g0_3;
    bt_l1_47 = bt_l1_47 + (-1.7735344215452642e-07)*bt_g0_4;
    bt_l1_47 = bt_l1_47 + (4.5252679115037608e-07)*bt_g0_5;
    bt_l1_47 = bt_l1_47 + (5.7209643955502543e-07)*bt_g0_6;
    bt_l1_47 = bt_l1_47 + (5.734534624934895e-07)*bt_g0_7;
    bt_l1_47 = bt_l1_47 + (0.0060920161195099354)*bt_g0_8;
    bt_l1_47 = bt_l1_47 + (-5.6733887277005124e-07)*bt_g0_9;
    bt_l1_47 = bt_l1_47 + (-0.00032118940725922585)*bt_g0_10;
    bt_l1_47 = bt_l1_47 + (-1.048257900038152e-06)*bt_g0_11;
    bt_l1_47 = bt_l1_47 + (3.5985121371595596e-07)*bt_g0_12;
    bt_l1_47 = bt_l1_47 + (-0.0028173897881060839)*bt_g0_13;
    bt_l1_47 = bt_l1_47 + (-4.3657951209752355e-07)*bt_g0_14;
    bt_l1_47 = bt_l1_47 + (-3.800426782163413e-07)*bt_g0_15;
    bt_l1_47 = bt_l1_47 + (0.00097829813603311777)*bt_g0_16;
    bt_l1_47 = bt_l1_47 + (0.0014902986586093903)*bt_g0_17;
    bt_l1_47 = bt_l1_47 + (-2.2134361188363982e-06)*bt_g0_18;
    bt_l1_47 = bt_l1_47 + (5.4755241762904916e-07)*bt_g0_19;
    bt_l1_47 = bt_l1_47 + (5.6338757303819875e-07)*bt_g0_20;
    bt_l1_47 = bt_l1_47 + (-4.0161813785744016e-07)*bt_g0_21;
    bt_l1_47 = bt_l1_47 + (0.0015063013415783644)*bt_g0_22;
    bt_l1_47 = bt_l1_47 + (-9.6657849724124389e-08)*bt_g0_23;
    bt_l1_47 = bt_l1_47 + (-6.271151846704015e-07)*bt_g0_24;
    bt_l1_47 = bt_l1_47 + (-8.1022804465646914e-08)*bt_g0_25;
    bt_l1_47 = bt_l1_47 + (-7.7196085612740717e-07)*bt_g0_26;
    bt_l1_47 = bt_l1_47 + (0.00053394591668620706)*bt_g0_27;
    bt_l1_47 = bt_l1_47 + (4.0172892568079988e-07)*bt_g0_28;
    bt_l1_47 = bt_l1_47 + (-3.0904639061191119e-06)*bt_g0_29;
    bt_l1_47 = bt_l1_47 + (4.889865863333398e-07)*bt_g0_30;
    bt_l1_47 = bt_l1_47 + (-1.5051706725444092e-07)*bt_g0_31;
    bt_l1_47 = bt_l1_47 + (5.7894050087270443e-07)*bt_g0_32;
    bt_l1_47 = bt_l1_47 + (1.6688563846400939e-06)*bt_g0_33;
    bt_l1_47 = bt_l1_47 + (4.9144233571496443e-07)*bt_g0_34;
    bt_l1_47 = bt_l1_47 + (-4.4127463638687914e-07)*bt_g0_35;
    bt_l1_47 = bt_l1_47 + (-4.8526743512411485e-07)*bt_g0_36;
    bt_l1_47 = bt_l1_47 + (9.7579231805866584e-08)*bt_g0_37;
    bt_l1_47 = bt_l1_47 + (-5.6200912013082416e-07)*bt_g0_38;
    bt_l1_47 = bt_l1_47 + (-1.0825855270013562e-06)*bt_g0_39;
    bt_l1_47 = bt_l1_47 + (5.8719029993881122e-07)*bt_g0_40;
    bt_l1_47 = bt_l1_47 + (5.1439678827591706e-07)*bt_g0_41;
    bt_l1_47 = bt_l1_47 + (6.0628337905654917e-07)*bt_g0_42;
    bt_l1_47 = bt_l1_47 + (5.9926207995886216e-07)*bt_g0_43;
    bt_l1_47 = bt_l1_47 + (-2.1731304400418594e-07)*bt_g0_44;
    bt_l1_47 = bt_l1_47 + (-2.2657054898900242e-07)*bt_g0_45;
    bt_l1_47 = bt_l1_47 + (-5.3124642818147549e-07)*bt_g0_46;
    bt_l1_47 = bt_l1_47 + (-5.8438661199033959e-07)*bt_g0_47;
    bt_l1_47 = bt_l1_47 + (-5.8633111166273011e-07)*bt_g0_48;
    bt_l1_47 = bt_l1_47 + (3.2941312611001194e-07)*bt_g0_49;
    bt_l1_47 = bt_l1_47 + (3.8288662835839204e-06)*bt_g0_50;
    bt_l1_47 = bt_l1_47 + (5.7805812048172811e-07)*bt_g0_51;
    bt_l1_47 = bt_l1_47 + (2.5169021000692737e-07)*bt_g0_52;
    bt_l1_47 = bt_l1_47 + (1.2184113984403666e-07)*bt_g0_53;
    bt_l1_47 = bt_l1_47 + (3.1933026889419125e-08)*bt_g0_54;
    bt_l1_47 = bt_l1_47 + (3.5448806556814816e-07)*bt_g0_55;
    bt_l1_47 = bt_l1_47 + (-3.6429059946385678e-07)*bt_g0_56;
    bt_l1_47 = bt_l1_47 + (-5.3612012607118231e-07)*bt_g0_57;
    bt_l1_47 = bt_l1_47 + (-0.0024408041499555111)*bt_g0_58;
    bt_l1_47 = bt_l1_47 + (-1.7394197016074031e-07)*bt_g0_59;
    bt_l1_47 = bt_l1_47 + (2.1694802398997126e-06)*bt_g0_60;
    bt_l1_47 = bt_l1_47 + (5.5550805200255127e-07)*bt_g0_61;
    bt_l1_47 = bt_l1_47 + (-3.9691371966910083e-07)*bt_g0_62;
    bt_l1_47 = bt_l1_47 + (0.0014182970626279712)*bt_g0_63;
    bt_l1_48 = 0.00701570650562644;
    bt_l1_48 = bt_l1_48 + (4.1091800540016266e-07)*bt_g0_0;
    bt_l1_48 = bt_l1_48 + (8.3302677467145259e-07)*bt_g0_1;
    bt_l1_48 = bt_l1_48 + (-0.0024481960572302341)*bt_g0_2;
    bt_l1_48 = bt_l1_48 + (-6.1842492016239703e-08)*bt_g0_3;
    bt_l1_48 = bt_l1_48 + (-1.773462230403311e-07)*bt_g0_4;
    bt_l1_48 = bt_l1_48 + (4.5252463110045937e-07)*bt_g0_5;
    bt_l1_48 = bt_l1_48 + (5.7209484793929732e-07)*bt_g0_6;
    bt_l1_48 = bt_l1_48 + (5.7345198456459912e-07)*bt_g0_7;
    bt_l1_48 = bt_l1_48 + (0.0060919281095266342)*bt_g0_8;
    bt_l1_48 = bt_l1_48 + (-5.6733830433586263e-07)*bt_g0_9;
    bt_l1_48 = bt_l1_48 + (-0.00032118783565238118)*bt_g0_10;
    bt_l1_48 = bt_l1_48 + (-1.0482835932634771e-06)*bt_g0_11;
    bt_l1_48 = bt_l1_48 + (3.5984780311082432e-07)*bt_g0_12;
    bt_l1_48 = bt_l1_48 + (-0.0028173765167593956)*bt_g0_13;
    bt_l1_48 = bt_l1_48 + (-4.3657840365085576e-07)*bt_g0_14;
    bt_l1_48 = bt_l1_48 + (-3.8004034763616801e-07)*bt_g0_15;
    bt_l1_48 = bt_l1_48 + (0.00097809219732880592)*bt_g0_16;
    bt_l1_48 = bt_l1_48 + (0.0014902505790814757)*bt_g0_17;
    bt_l1_48 = bt_l1_48 + (-2.2134447590360651e-06)*bt_g0_18;
    bt_l1_48 = bt_l1_48 + (5.4755298606323777e-07)*bt_g0_19;
    bt_l1_48 = bt_l1_48 + (5.6338626563956495e-07)*bt_g0_20;
    bt_l1_48 = bt_l1_48 + (-4.016158356989763e-07)*bt_g0_21;
    bt_l1_48 = bt_l1_48 + (0.0015062835300341249)*bt_g0_22;
    bt_l1_48 = bt_l1_48 + (-9.6653309356042882e-08)*bt_g0_23;
    bt_l1_48 = bt_l1_48 + (-6.271135930546734e-07)*bt_g0_24;
    bt_l1_48 = bt_l1_48 + (-8.1019564390771848e-08)*bt_g0_25;
    bt_l1_48 = bt_l1_48 + (-7.7194454206619412e-07)*bt_g0_26;
    bt_l1_48 = bt_l1_48 + (0.0005338890478014946)*bt_g0_27;
    bt_l1_48 = bt_l1_48 + (4.0173111415242602e-07)*bt_g0_28;
    bt_l1_48 = bt_l1_48 + (-3.0904079721949529e-06)*bt_g0_29;
    bt_l1_48 = bt_l1_48 + (4.8898448312684195e-07)*bt_g0_30;
    bt_l1_48 = bt_l1_48 + (-1.5051391244469414e-07)*bt_g0_31;
    bt_l1_48 = bt_l1_48 + (5.7893822713595e-07)*bt_g0_32;
    bt_l1_48 = bt_l1_48 + (1.6688278492438258e-06)*bt_g0_33;
    bt_l1_48 = bt_l1_48 + (4.9144080094265519e-07)*bt_g0_34;
    bt_l1_48 = bt_l1_48 + (-4.4127199316790211e-07)*bt_g0_35;
    bt_l1_48 = bt_l1_48 + (-4.8526624141231878e-07)*bt_g0_36;
    bt_l1_48 = bt_l1_48 + (9.757471275406715e-08)*bt_g0_37;
    bt_l1_48 = bt_l1_48 + (-5.6200792641902808e-07)*bt_g0_38;
    bt_l1_48 = bt_l1_48 + (-1.0825808658410097e-06)*bt_g0_39;
    bt_l1_48 = bt_l1_48 + (5.8718910622701515e-07)*bt_g0_40;
    bt_l1_48 = bt_l1_48 + (5.1439451453916263e-07)*bt_g0_41;
    bt_l1_48 = bt_l1_48 + (6.0628286746577942e-07)*bt_g0_42;
    bt_l1_48 = bt_l1_48 + (5.9926088624706608e-07)*bt_g0_43;
    bt_l1_48 = bt_l1_48 + (-2.1731018762238818e-07)*bt_g0_44;
    bt_l1_48 = bt_l1_48 + (-2.2657332010567188e-07)*bt_g0_45;
    bt_l1_48 = bt_l1_48 + (-5.3124421128813992e-07)*bt_g0_46;
    bt_l1_48 = bt_l1_48 + (-5.8438502037461149e-07)*bt_g0_47;
    bt_l1_48 = bt_l1_48 + (-5.8632980426409631e-07)*bt_g0_48;
    bt_l1_48 = bt_l1_48 + (3.2940994287855574e-07)*bt_g0_49;
    bt_l1_48 = bt_l1_48 + (3.8287926145130768e-06)*bt_g0_50;
    bt_l1_48 = bt_l1_48 + (5.7805880260275444e-07)*bt_g0_51;
    bt_l1_48 = bt_l1_48 + (2.5169262585222896e-07)*bt_g0_52;
    bt_l1_48 = bt_l1_48 + (1.2183971875856514e-07)*bt_g0_53;
    bt_l1_48 = bt_l1_48 + (3.1929587862578046e-08)*bt_g0_54;
    bt_l1_48 = bt_l1_48 + (3.5448553603600885e-07)*bt_g0_55;
    bt_l1_48 = bt_l1_48 + (-3.6429250371838862e-07)*bt_g0_56;
    bt_l1_48 = bt_l1_48 + (-5.361461035136017e-07)*bt_g0_57;
    bt_l1_48 = bt_l1_48 + (-0.0024408034514635801)*bt_g0_58;
    bt_l1_48 = bt_l1_48 + (-1.7393961115885759e-07)*bt_g0_59;
    bt_l1_48 = bt_l1_48 + (2.1694900169677567e-06)*bt_g0_60;
    bt_l1_48 = bt_l1_48 + (5.5550651723024203e-07)*bt_g0_61;
    bt_l1_48 = bt_l1_48 + (-3.9691147435405583e-07)*bt_g0_62;
    bt_l1_48 = bt_l1_48 + (0.0014182716840878129)*bt_g0_63;
    bt_l1_49 = 0.0070156268775463104;
    bt_l1_49 = bt_l1_49 + (4.1091922753366816e-07)*bt_g0_0;
    bt_l1_49 = bt_l1_49 + (8.3301216591280536e-07)*bt_g0_1;
    bt_l1_49 = bt_l1_49 + (-0.0024481986183673143)*bt_g0_2;
    bt_l1_49 = bt_l1_49 + (-6.183933010106557e-08)*bt_g0_3;
    bt_l1_49 = bt_l1_49 + (-1.7735389690187731e-07)*bt_g0_4;
    bt_l1_49 = bt_l1_49 + (4.5252701852405153e-07)*bt_g0_5;
    bt_l1_49 = bt_l1_49 + (5.7209655324186315e-07)*bt_g0_6;
    bt_l1_49 = bt_l1_49 + (5.7345334880665177e-07)*bt_g0_7;
    bt_l1_49 = bt_l1_49 + (0.0060920063406229019)*bt_g0_8;
    bt_l1_49 = bt_l1_49 + (-5.6733858855295694e-07)*bt_g0_9;
    bt_l1_49 = bt_l1_49 + (-0.00032119077513925731)*bt_g0_10;
    bt_l1_49 = bt_l1_49 + (-1.0482572179171257e-06)*bt_g0_11;
    bt_l1_49 = bt_l1_49 + (3.5985161161988799e-07)*bt_g0_12;
    bt_l1_49 = bt_l1_49 + (-0.0028173890896141529)*bt_g0_13;
    bt_l1_49 = bt_l1_49 + (-4.3657934156726697e-07)*bt_g0_14;
    bt_l1_49 = bt_l1_49 + (-3.8004262137292244e-07)*bt_g0_15;
    bt_l1_49 = bt_l1_49 + (0.00097829604055732489)*bt_g0_16;
    bt_l1_49 = bt_l1_49 + (0.0014902936527505517)*bt_g0_17;
    bt_l1_49 = bt_l1_49 + (-2.2134368009574246e-06)*bt_g0_18;
    bt_l1_49 = bt_l1_49 + (5.4755179235144169e-07)*bt_g0_19;
    bt_l1_49 = bt_l1_49 + (5.6338762988161761e-07)*bt_g0_20;
    bt_l1_49 = bt_l1_49 + (-4.0161802417060244e-07)*bt_g0_21;
    bt_l1_49 = bt_l1_49 + (0.0015062863240018487)*bt_g0_22;
    bt_l1_49 = bt_l1_49 + (-9.6658453685449786e-08)*bt_g0_23;
    bt_l1_49 = bt_l1_49 + (-6.2711472992305062e-07)*bt_g0_24;
    bt_l1_49 = bt_l1_49 + (-8.1023145526160079e-08)*bt_g0_25;
    bt_l1_49 = bt_l1_49 + (-7.7196250458655413e-07)*bt_g0_26;
    bt_l1_49 = bt_l1_49 + (0.00053394021233543754)*bt_g0_27;
    bt_l1_49 = bt_l1_49 + (4.0172872672883386e-07)*bt_g0_28;
    bt_l1_49 = bt_l1_49 + (-3.0904639061191119e-06)*bt_g0_29;
    bt_l1_49 = bt_l1_49 + (4.8898664317675866e-07)*bt_g0_30;
    bt_l1_49 = bt_l1_49 + (-1.5051735147153522e-07)*bt_g0_31;
    bt_l1_49 = bt_l1_49 + (5.7894033034244785e-07)*bt_g0_32;
    bt_l1_49 = bt_l1_49 + (1.668855929892743e-06)*bt_g0_33;
    bt_l1_49 = bt_l1_49 + (4.9144267677547759e-07)*bt_g0_34;
    bt_l1_49 = bt_l1_49 + (-4.41274693230298e-07)*bt_g0_35;
    bt_l1_49 = bt_l1_49 + (-4.8526743512411485e-07)*bt_g0_36;
    bt_l1_49 = bt_l1_49 + (9.7579182067875081e-08)*bt_g0_37;
    bt_l1_49 = bt_l1_49 + (-5.620093475044996e-07)*bt_g0_38;
    bt_l1_49 = bt_l1_49 + (-1.0825866638697335e-06)*bt_g0_39;
    bt_l1_49 = bt_l1_49 + (5.8718984519146034e-07)*bt_g0_40;
    bt_l1_49 = bt_l1_49 + (5.1439650405882276e-07)*bt_g0_41;
    bt_l1_49 = bt_l1_49 + (6.0628309483945486e-07)*bt_g0_42;
    bt_l1_49 = bt_l1_49 + (5.9926168205493013e-07)*bt_g0_43;
    bt_l1_49 = bt_l1_49 + (-2.1731322874529724e-07)*bt_g0_44;
    bt_l1_49 = bt_l1_49 + (-2.2657022213934397e-07)*bt_g0_45;
    bt_l1_49 = bt_l1_49 + (-5.3124625765121891e-07)*bt_g0_46;
    bt_l1_49 = bt_l1_49 + (-5.8438661199033959e-07)*bt_g0_47;
    bt_l1_49 = bt_l1_49 + (-5.8633105481931125e-07)*bt_g0_48;
    bt_l1_49 = bt_l1_49 + (3.2941292715804593e-07)*bt_g0_49;
    bt_l1_49 = bt_l1_49 + (3.8288703763100784e-06)*bt_g0_50;
    bt_l1_49 = bt_l1_49 + (5.7805794995147153e-07)*bt_g0_51;
    bt_l1_49 = bt_l1_49 + (2.5168984052470478e-07)*bt_g0_52;
    bt_l1_49 = bt_l1_49 + (1.2184115405489138e-07)*bt_g0_53;
    bt_l1_49 = bt_l1_49 + (3.1933261368521926e-08)*bt_g0_54;
    bt_l1_49 = bt_l1_49 + (3.5448834978524246e-07)*bt_g0_55;
    bt_l1_49 = bt_l1_49 + (-3.6429128158488311e-07)*bt_g0_56;
    bt_l1_49 = bt_l1_49 + (-5.3611785233442788e-07)*bt_g0_57;
    bt_l1_49 = bt_l1_49 + (-0.0024408118333667517)*bt_g0_58;
    bt_l1_49 = bt_l1_49 + (-1.7394215490185161e-07)*bt_g0_59;
    bt_l1_49 = bt_l1_49 + (2.1694797851523617e-06)*bt_g0_60;
    bt_l1_49 = bt_l1_49 + (5.555077109420381e-07)*bt_g0_61;
    bt_l1_49 = bt_l1_49 + (-3.9691371966910083e-07)*bt_g0_62;
    bt_l1_49 = bt_l1_49 + (0.0014182771556079388)*bt_g0_63;
    bt_l1_50 = 0.0070156143046915531;
    bt_l1_50 = bt_l1_50 + (4.1091919911195873e-07)*bt_g0_0;
    bt_l1_50 = bt_l1_50 + (8.3301125641810359e-07)*bt_g0_1;
    bt_l1_50 = bt_l1_50 + (-0.0024482032749801874)*bt_g0_2;
    bt_l1_50 = bt_l1_50 + (-6.1839216414227849e-08)*bt_g0_3;
    bt_l1_50 = bt_l1_50 + (-1.7735418111897161e-07)*bt_g0_4;
    bt_l1_50 = bt_l1_50 + (4.5252696168063267e-07)*bt_g0_5;
    bt_l1_50 = bt_l1_50 + (5.7209643955502543e-07)*bt_g0_6;
    bt_l1_50 = bt_l1_50 + (5.7345334880665177e-07)*bt_g0_7;
    bt_l1_50 = bt_l1_50 + (0.0060920044779777527)*bt_g0_8;
    bt_l1_50 = bt_l1_50 + (-5.6733858855295694e-07)*bt_g0_9;
    bt_l1_50 = bt_l1_50 + (-0.00032118905801326036)*bt_g0_10;
    bt_l1_50 = bt_l1_50 + (-1.0482551715540467e-06)*bt_g0_11;
    bt_l1_50 = bt_l1_50 + (3.598515263547597e-07)*bt_g0_12;
    bt_l1_50 = bt_l1_50 + (-0.0028173814062029123)*bt_g0_13;
    bt_l1_50 = bt_l1_50 + (-4.3657942683239526e-07)*bt_g0_14;
    bt_l1_50 = bt_l1_50 + (-3.8004273505976016e-07)*bt_g0_15;
    bt_l1_50 = bt_l1_50 + (0.0009783146670088172)*bt_g0_16;
    bt_l1_50 = bt_l1_50 + (0.001490308903157711)*bt_g0_17;
    bt_l1_50 = bt_l1_50 + (-2.2134368009574246e-06)*bt_g0_18;
    bt_l1_50 = bt_l1_50 + (5.4755190603827941e-07)*bt_g0_19;
    bt_l1_50 = bt_l1_50 + (5.6338740250794217e-07)*bt_g0_20;
    bt_l1_50 = bt_l1_50 + (-4.0161816627914959e-07)*bt_g0_21;
    bt_l1_50 = bt_l1_50 + (0.0015062969177961349)*bt_g0_22;
    bt_l1_50 = bt_l1_50 + (-9.665879474596295e-08)*bt_g0_23;
    bt_l1_50 = bt_l1_50 + (-6.2711484360988834e-07)*bt_g0_24;
    bt_l1_50 = bt_l1_50 + (-8.1023124209878006e-08)*bt_g0_25;
    bt_l1_50 = bt_l1_50 + (-7.7196381198518793e-07)*bt_g0_26;
    bt_l1_50 = bt_l1_50 + (0.00053394405404105783)*bt_g0_27;
    bt_l1_50 = bt_l1_50 + (4.0172849935515842e-07)*bt_g0_28;
    bt_l1_50 = bt_l1_50 + (-3.0904684535926208e-06)*bt_g0_29;
    bt_l1_50 = bt_l1_50 + (4.8898675686359638e-07)*bt_g0_30;
    bt_l1_50 = bt_l1_50 + (-1.5051725199555221e-07)*bt_g0_31;
    bt_l1_50 = bt_l1_50 + (5.7894027349902899e-07)*bt_g0_32;
    bt_l1_50 = bt_l1_50 + (1.6688601363057387e-06)*bt_g0_33;
    bt_l1_50 = bt_l1_50 + (4.9144244940180215e-07)*bt_g0_34;
    bt_l1_50 = bt_l1_50 + (-4.4127455112175085e-07)*bt_g0_35;
    bt_l1_50 = bt_l1_50 + (-4.8526737828069599e-07)*bt_g0_36;
    bt_l1_50 = bt_l1_50 + (9.7579210489584511e-08)*bt_g0_37;
    bt_l1_50 = bt_l1_50 + (-5.6200900644398644e-07)*bt_g0_38;
    bt_l1_50 = bt_l1_50 + (-1.0825859817487071e-06)*bt_g0_39;
    bt_l1_50 = bt_l1_50 + (5.8718973150462261e-07)*bt_g0_40;
    bt_l1_50 = bt_l1_50 + (5.1439656090224162e-07)*bt_g0_41;
    bt_l1_50 = bt_l1_50 + (6.06283037996036e-07)*bt_g0_42;
    bt_l1_50 = bt_l1_50 + (5.9926151152467355e-07)*bt_g0_43;
    bt_l1_50 = bt_l1_50 + (-2.1731318611273309e-07)*bt_g0_44;
    bt_l1_50 = bt_l1_50 + (-2.2657015108507039e-07)*bt_g0_45;
    bt_l1_50 = bt_l1_50 + (-5.3124608712096233e-07)*bt_g0_46;
    bt_l1_50 = bt_l1_50 + (-5.8438661199033959e-07)*bt_g0_47;
    bt_l1_50 = bt_l1_50 + (-5.863308274456358e-07)*bt_g0_48;
    bt_l1_50 = bt_l1_50 + (3.2941318295343081e-07)*bt_g0_49;
    bt_l1_50 = bt_l1_50 + (3.8288776522676926e-06)*bt_g0_50;
    bt_l1_50 = bt_l1_50 + (5.7805789310805267e-07)*bt_g0_51;
    bt_l1_50 = bt_l1_50 + (2.5168969841615763e-07)*bt_g0_52;
    bt_l1_50 = bt_l1_50 + (1.2184111142232723e-07)*bt_g0_53;
    bt_l1_50 = bt_l1_50 + (3.1933289790231356e-08)*bt_g0_54;
    bt_l1_50 = bt_l1_50 + (3.5448837820695189e-07)*bt_g0_55;
    bt_l1_50 = bt_l1_50 + (-3.6429065630727564e-07)*bt_g0_56;
    bt_l1_50 = bt_l1_50 + (-5.3611711336998269e-07)*bt_g0_57;
    bt_l1_50 = bt_l1_50 + (-0.0024408067110925913)*bt_g0_58;
    bt_l1_50 = bt_l1_50 + (-1.7394215490185161e-07)*bt_g0_59;
    bt_l1_50 = bt_l1_50 + (2.1694797851523617e-06)*bt_g0_60;
    bt_l1_50 = bt_l1_50 + (5.555077109420381e-07)*bt_g0_61;
    bt_l1_50 = bt_l1_50 + (-3.9691357756055368e-07)*bt_g0_62;
    bt_l1_50 = bt_l1_50 + (0.001418284373357892)*bt_g0_63;
    bt_l1_51 = 0.0070156692527234554;
    bt_l1_51 = bt_l1_51 + (4.1091820435212867e-07)*bt_g0_0;
    bt_l1_51 = bt_l1_51 + (8.3302228404136258e-07)*bt_g0_1;
    bt_l1_51 = bt_l1_51 + (-0.0024481713771820068)*bt_g0_2;
    bt_l1_51 = bt_l1_51 + (-6.1841305409870984e-08)*bt_g0_3;
    bt_l1_51 = bt_l1_51 + (-1.773489373135817e-07)*bt_g0_4;
    bt_l1_51 = bt_l1_51 + (4.525250290043914e-07)*bt_g0_5;
    bt_l1_51 = bt_l1_51 + (5.7209484793929732e-07)*bt_g0_6;
    bt_l1_51 = bt_l1_51 + (5.7345181403434253e-07)*bt_g0_7;
    bt_l1_51 = bt_l1_51 + (0.0060919411480426788)*bt_g0_8;
    bt_l1_51 = bt_l1_51 + (-5.6733790643193061e-07)*bt_g0_9;
    bt_l1_51 = bt_l1_51 + (-0.00032118844683282077)*bt_g0_10;
    bt_l1_51 = bt_l1_51 + (-1.0482763173058629e-06)*bt_g0_11;
    bt_l1_51 = bt_l1_51 + (3.5984885471407324e-07)*bt_g0_12;
    bt_l1_51 = bt_l1_51 + (-0.0028173564933240414)*bt_g0_13;
    bt_l1_51 = bt_l1_51 + (-4.3657828996401804e-07)*bt_g0_14;
    bt_l1_51 = bt_l1_51 + (-3.8004066027497174e-07)*bt_g0_15;
    bt_l1_51 = bt_l1_51 + (0.00097816367633640766)*bt_g0_16;
    bt_l1_51 = bt_l1_51 + (0.0014902834082022309)*bt_g0_17;
    bt_l1_51 = bt_l1_51 + (-2.2134424852993106e-06)*bt_g0_18;
    bt_l1_51 = bt_l1_51 + (5.4755241762904916e-07)*bt_g0_19;
    bt_l1_51 = bt_l1_51 + (5.6338626563956495e-07)*bt_g0_20;
    bt_l1_51 = bt_l1_51 + (-4.0161629044632718e-07)*bt_g0_21;
    bt_l1_51 = bt_l1_51 + (0.0015062614111229777)*bt_g0_22;
    bt_l1_51 = bt_l1_51 + (-9.6655007553181349e-08)*bt_g0_23;
    bt_l1_51 = bt_l1_51 + (-6.2711387727176771e-07)*bt_g0_24;
    bt_l1_51 = bt_l1_51 + (-8.1020601783166057e-08)*bt_g0_25;
    bt_l1_51 = bt_l1_51 + (-7.7195130643303855e-07)*bt_g0_26;
    bt_l1_51 = bt_l1_51 + (0.0005338951013982296)*bt_g0_27;
    bt_l1_51 = bt_l1_51 + (4.0173009097088652e-07)*bt_g0_28;
    bt_l1_51 = bt_l1_51 + (-3.0904288905730937e-06)*bt_g0_29;
    bt_l1_51 = bt_l1_51 + (4.8898471050051739e-07)*bt_g0_30;
    bt_l1_51 = bt_l1_51 + (-1.5051497825879778e-07)*bt_g0_31;
    bt_l1_51 = bt_l1_51 + (5.7893834082278772e-07)*bt_g0_32;
    bt_l1_51 = bt_l1_51 + (1.668838763180247e-06)*bt_g0_33;
    bt_l1_51 = bt_l1_51 + (4.9144119884658721e-07)*bt_g0_34;
    bt_l1_51 = bt_l1_51 + (-4.4127261844550958e-07)*bt_g0_35;
    bt_l1_51 = bt_l1_51 + (-4.8526641194257536e-07)*bt_g0_36;
    bt_l1_51 = bt_l1_51 + (9.757575014646136e-08)*bt_g0_37;
    bt_l1_51 = bt_l1_51 + (-5.6200809694928466e-07)*bt_g0_38;
    bt_l1_51 = bt_l1_51 + (-1.0825831395777641e-06)*bt_g0_39;
    bt_l1_51 = bt_l1_51 + (5.8718904938359628e-07)*bt_g0_40;
    bt_l1_51 = bt_l1_51 + (5.1439479875625693e-07)*bt_g0_41;
    bt_l1_51 = bt_l1_51 + (6.0628258324868511e-07)*bt_g0_42;
    bt_l1_51 = bt_l1_51 + (5.9926077256022836e-07)*bt_g0_43;
    bt_l1_51 = bt_l1_51 + (-2.1731072763486736e-07)*bt_g0_44;
    bt_l1_51 = bt_l1_51 + (-2.2657214060473052e-07)*bt_g0_45;
    bt_l1_51 = bt_l1_51 + (-5.3124460919207195e-07)*bt_g0_46;
    bt_l1_51 = bt_l1_51 + (-5.8438536143512465e-07)*bt_g0_47;
    bt_l1_51 = bt_l1_51 + (-5.8633003163777175e-07)*bt_g0_48;
    bt_l1_51 = bt_l1_51 + (3.2941042604761606e-07)*bt_g0_49;
    bt_l1_51 = bt_l1_51 + (3.8288180803647265e-06)*bt_g0_50;
    bt_l1_51 = bt_l1_51 + (5.7805817732514697e-07)*bt_g0_51;
    bt_l1_51 = bt_l1_51 + (2.5169157424898003e-07)*bt_g0_52;
    bt_l1_51 = bt_l1_51 + (1.2183983244540286e-07)*bt_g0_53;
    bt_l1_51 = bt_l1_51 + (3.1930788679801481e-08)*bt_g0_54;
    bt_l1_51 = bt_l1_51 + (3.5448593393994088e-07)*bt_g0_55;
    bt_l1_51 = bt_l1_51 + (-3.6429193528420001e-07)*bt_g0_56;
    bt_l1_51 = bt_l1_51 + (-5.3613791806128575e-07)*bt_g0_57;
    bt_l1_51 = bt_l1_51 + (-0.0024407932069152594)*bt_g0_58;
    bt_l1_51 = bt_l1_51 + (-1.7394030749073863e-07)*bt_g0_59;
    bt_l1_51 = bt_l1_51 + (2.1694870611099759e-06)*bt_g0_60;
    bt_l1_51 = bt_l1_51 + (5.5550663091707975e-07)*bt_g0_61;
    bt_l1_51 = bt_l1_51 + (-3.9691207120995387e-07)*bt_g0_62;
    bt_l1_51 = bt_l1_51 + (0.0014182600425556302)*bt_g0_63;
    bt_l1_52 = 0.0070157037116587162;
    bt_l1_52 = bt_l1_52 + (4.1091686853178544e-07)*bt_g0_0;
    bt_l1_52 = bt_l1_52 + (8.3304303188924678e-07)*bt_g0_1;
    bt_l1_52 = bt_l1_52 + (-0.0024481352884322405)*bt_g0_2;
    bt_l1_52 = bt_l1_52 + (-6.1846193943893013e-08)*bt_g0_3;
    bt_l1_52 = bt_l1_52 + (-1.7733698598476622e-07)*bt_g0_4;
    bt_l1_52 = bt_l1_52 + (4.5252224367686722e-07)*bt_g0_5;
    bt_l1_52 = bt_l1_52 + (5.7209337001040694e-07)*bt_g0_6;
    bt_l1_52 = bt_l1_52 + (5.7345033610545215e-07)*bt_g0_7;
    bt_l1_52 = bt_l1_52 + (0.0060918843373656273)*bt_g0_8;
    bt_l1_52 = bt_l1_52 + (-5.6733790643193061e-07)*bt_g0_9;
    bt_l1_52 = bt_l1_52 + (-0.00032118958188220859)*bt_g0_10;
    bt_l1_52 = bt_l1_52 + (-1.0483181540621445e-06)*bt_g0_11;
    bt_l1_52 = bt_l1_52 + (3.5984396618005121e-07)*bt_g0_12;
    bt_l1_52 = bt_l1_52 + (-0.0028173117898404598)*bt_g0_13;
    bt_l1_52 = bt_l1_52 + (-4.3657732362589741e-07)*bt_g0_14;
    bt_l1_52 = bt_l1_52 + (-3.800375338869344e-07)*bt_g0_15;
    bt_l1_52 = bt_l1_52 + (0.00097795750480145216)*bt_g0_16;
    bt_l1_52 = bt_l1_52 + (0.0014902972616255283)*bt_g0_17;
    bt_l1_52 = bt_l1_52 + (-2.2134538539830828e-06)*bt_g0_18;
    bt_l1_52 = bt_l1_52 + (5.4755480505264131e-07)*bt_g0_19;
    bt_l1_52 = bt_l1_52 + (5.6338507192776888e-07)*bt_g0_20;
    bt_l1_52 = bt_l1_52 + (-4.0161336301025585e-07)*bt_g0_21;
    bt_l1_52 = bt_l1_52 + (0.0015062837628647685)*bt_g0_22;
    bt_l1_52 = bt_l1_52 + (-9.6646523672916373e-08)*bt_g0_23;
    bt_l1_52 = bt_l1_52 + (-6.2711251302971505e-07)*bt_g0_24;
    bt_l1_52 = bt_l1_52 + (-8.1015031128117698e-08)*bt_g0_25;
    bt_l1_52 = bt_l1_52 + (-7.7192180469864979e-07)*bt_g0_26;
    bt_l1_52 = bt_l1_52 + (0.0005338419578038156)*bt_g0_27;
    bt_l1_52 = bt_l1_52 + (4.0173409843191621e-07)*bt_g0_28;
    bt_l1_52 = bt_l1_52 + (-3.0903399874659954e-06)*bt_g0_29;
    bt_l1_52 = bt_l1_52 + (4.889820957032498e-07)*bt_g0_30;
    bt_l1_52 = bt_l1_52 + (-1.5050989077280974e-07)*bt_g0_31;
    bt_l1_52 = bt_l1_52 + (5.7893635130312759e-07)*bt_g0_32;
    bt_l1_52 = bt_l1_52 + (1.6687923789504566e-06)*bt_g0_33;
    bt_l1_52 = bt_l1_52 + (4.9143949354402139e-07)*bt_g0_34;
    bt_l1_52 = bt_l1_52 + (-4.4126937837063451e-07)*bt_g0_35;
    bt_l1_52 = bt_l1_52 + (-4.8526527507419814e-07)*bt_g0_36;
    bt_l1_52 = bt_l1_52 + (9.7569497370386671e-08)*bt_g0_37;
    bt_l1_52 = bt_l1_52 + (-5.6200650533355656e-07)*bt_g0_38;
    bt_l1_52 = bt_l1_52 + (-1.0825760909938253e-06)*bt_g0_39;
    bt_l1_52 = bt_l1_52 + (5.871888788533397e-07)*bt_g0_40;
    bt_l1_52 = bt_l1_52 + (5.1439246817608364e-07)*bt_g0_41;
    bt_l1_52 = bt_l1_52 + (6.0628218534475309e-07)*bt_g0_42;
    bt_l1_52 = bt_l1_52 + (5.9926077256022836e-07)*bt_g0_43;
    bt_l1_52 = bt_l1_52 + (-2.173062796373415e-07)*bt_g0_44;
    bt_l1_52 = bt_l1_52 + (-2.2657732756670157e-07)*bt_g0_45;
    bt_l1_52 = bt_l1_52 + (-5.3124233545531752e-07)*bt_g0_46;
    bt_l1_52 = bt_l1_52 + (-5.8438399719307199e-07)*bt_g0_47;
    bt_l1_52 = bt_l1_52 + (-5.8632900845623226e-07)*bt_g0_48;
    bt_l1_52 = bt_l1_52 + (3.2940630489974865e-07)*bt_g0_49;
    bt_l1_52 = bt_l1_52 + (3.8287021197902504e-06)*bt_g0_50;
    bt_l1_52 = bt_l1_52 + (5.7805942788036191e-07)*bt_g0_51;
    bt_l1_52 = bt_l1_52 + (2.5169609330077947e-07)*bt_g0_52;
    bt_l1_52 = bt_l1_52 + (1.2183815556454647e-07)*bt_g0_53;
    bt_l1_52 = bt_l1_52 + (3.192504394178286e-08)*bt_g0_54;
    bt_l1_52 = bt_l1_52 + (3.5448235280455265e-07)*bt_g0_55;
    bt_l1_52 = bt_l1_52 + (-3.6429469219001476e-07)*bt_g0_56;
    bt_l1_52 = bt_l1_52 + (-5.3618094852936338e-07)*bt_g0_57;
    bt_l1_52 = bt_l1_52 + (-0.0024407282471656799)*bt_g0_58;
    bt_l1_52 = bt_l1_52 + (-1.7393661266851268e-07)*bt_g0_59;
    bt_l1_52 = bt_l1_52 + (2.1695016130252043e-06)*bt_g0_60;
    bt_l1_52 = bt_l1_52 + (5.555058351092157e-07)*bt_g0_61;
    bt_l1_52 = bt_l1_52 + (-3.9690917219559196e-07)*bt_g0_62;
    bt_l1_52 = bt_l1_52 + (0.0014182880986481905)*bt_g0_63;
    bt_l1_53 = 0.0070156357251107693;
    bt_l1_53 = bt_l1_53 + (4.1091925595537759e-07)*bt_g0_0;
    bt_l1_53 = bt_l1_53 + (8.3300966480237548e-07)*bt_g0_1;
    bt_l1_53 = bt_l1_53 + (-0.0024482156150043011)*bt_g0_2;
    bt_l1_53 = bt_l1_53 + (-6.1838775877731678e-08)*bt_g0_3;
    bt_l1_53 = bt_l1_53 + (-1.7735540325247712e-07)*bt_g0_4;
    bt_l1_53 = bt_l1_53 + (4.5252744484969298e-07)*bt_g0_5;
    bt_l1_53 = bt_l1_53 + (5.7209666692870087e-07)*bt_g0_6;
    bt_l1_53 = bt_l1_53 + (5.7345368986716494e-07)*bt_g0_7;
    bt_l1_53 = bt_l1_53 + (0.0060920151881873608)*bt_g0_8;
    bt_l1_53 = bt_l1_53 + (-5.6733875908321352e-07)*bt_g0_9;
    bt_l1_53 = bt_l1_53 + (-0.00032119080424308777)*bt_g0_10;
    bt_l1_53 = bt_l1_53 + (-1.0482523293831036e-06)*bt_g0_11;
    bt_l1_53 = bt_l1_53 + (3.5985195268040115e-07)*bt_g0_12;
    bt_l1_53 = bt_l1_53 + (-0.0028174039907753468)*bt_g0_13;
    bt_l1_53 = bt_l1_53 + (-4.3657962578436127e-07)*bt_g0_14;
    bt_l1_53 = bt_l1_53 + (-3.8004301927685447e-07)*bt_g0_15;
    bt_l1_53 = bt_l1_53 + (0.00097830849699676037)*bt_g0_16;
    bt_l1_53 = bt_l1_53 + (0.0014902777038514614)*bt_g0_17;
    bt_l1_53 = bt_l1_53 + (-2.2134352093416965e-06)*bt_g0_18;
    bt_l1_53 = bt_l1_53 + (5.4755179235144169e-07)*bt_g0_19;
    bt_l1_53 = bt_l1_53 + (5.633878004118742e-07)*bt_g0_20;
    bt_l1_53 = bt_l1_53 + (-4.0161833680940617e-07)*bt_g0_21;
    bt_l1_53 = bt_l1_53 + (0.0015062878374010324)*bt_g0_22;
    bt_l1_53 = bt_l1_53 + (-9.6659768189510942e-08)*bt_g0_23;
    bt_l1_53 = bt_l1_53 + (-6.2711495729672606e-07)*bt_g0_24;
    bt_l1_53 = bt_l1_53 + (-8.1023671327784541e-08)*bt_g0_25;
    bt_l1_53 = bt_l1_53 + (-7.7196625625219895e-07)*bt_g0_26;
    bt_l1_53 = bt_l1_53 + (0.0005339491181075573)*bt_g0_27;
    bt_l1_53 = bt_l1_53 + (4.0172818671635468e-07)*bt_g0_28;
    bt_l1_53 = bt_l1_53 + (-3.0904748200555332e-06)*bt_g0_29;
    bt_l1_53 = bt_l1_53 + (4.8898704108069069e-07)*bt_g0_30;
    bt_l1_53 = bt_l1_53 + (-1.5051777779717668e-07)*bt_g0_31;
    bt_l1_53 = bt_l1_53 + (5.7894044402928557e-07)*bt_g0_32;
    bt_l1_53 = bt_l1_53 + (1.6688616142346291e-06)*bt_g0_33;
    bt_l1_53 = bt_l1_53 + (4.9144239255838329e-07)*bt_g0_34;
    bt_l1_53 = bt_l1_53 + (-4.4127492060397344e-07)*bt_g0_35;
    bt_l1_53 = bt_l1_53 + (-4.8526760565437144e-07)*bt_g0_36;
    bt_l1_53 = bt_l1_53 + (9.7580105773431569e-08)*bt_g0_37;
    bt_l1_53 = bt_l1_53 + (-5.6200963172159391e-07)*bt_g0_38;
    bt_l1_53 = bt_l1_53 + (-1.0825867775565712e-06)*bt_g0_39;
    bt_l1_53 = bt_l1_53 + (5.871901862519735e-07)*bt_g0_40;
    bt_l1_53 = bt_l1_53 + (5.1439690196275478e-07)*bt_g0_41;
    bt_l1_53 = bt_l1_53 + (6.0628343589996803e-07)*bt_g0_42;
    bt_l1_53 = bt_l1_53 + (5.9926162521151127e-07)*bt_g0_43;
    bt_l1_53 = bt_l1_53 + (-2.1731366928179341e-07)*bt_g0_44;
    bt_l1_53 = bt_l1_53 + (-2.2656958265088178e-07)*bt_g0_45;
    bt_l1_53 = bt_l1_53 + (-5.3124648502489435e-07)*bt_g0_46;
    bt_l1_53 = bt_l1_53 + (-5.8438683936401503e-07)*bt_g0_47;
    bt_l1_53 = bt_l1_53 + (-5.8633111166273011e-07)*bt_g0_48;
    bt_l1_53 = bt_l1_53 + (3.2941366612249112e-07)*bt_g0_49;
    bt_l1_53 = bt_l1_53 + (3.8288835639832541e-06)*bt_g0_50;
    bt_l1_53 = bt_l1_53 + (5.7805789310805267e-07)*bt_g0_51;
    bt_l1_53 = bt_l1_53 + (2.5168932893393503e-07)*bt_g0_52;
    bt_l1_53 = bt_l1_53 + (1.2184138142856682e-07)*bt_g0_53;
    bt_l1_53 = bt_l1_53 + (3.1933829802710534e-08)*bt_g0_54;
    bt_l1_53 = bt_l1_53 + (3.5448869084575563e-07)*bt_g0_55;
    bt_l1_53 = bt_l1_53 + (-3.6429054262043792e-07)*bt_g0_56;
    bt_l1_53 = bt_l1_53 + (-5.3611387329510762e-07)*bt_g0_57;
    bt_l1_53 = bt_l1_53 + (-0.0024408262688666582)*bt_g0_58;
    bt_l1_53 = bt_l1_53 + (-1.7394256701663835e-07)*bt_g0_59;
    bt_l1_53 = bt_l1_53 + (2.1694784209103091e-06)*bt_g0_60;
    bt_l1_53 = bt_l1_53 + (5.555077109420381e-07)*bt_g0_61;
    bt_l1_53 = bt_l1_53 + (-3.9691408915132342e-07)*bt_g0_62;
    bt_l1_53 = bt_l1_53 + (0.0014182861195877194)*bt_g0_63;
    bt_l1_54 = 0.0070156147703528404;
    bt_l1_54 = bt_l1_54 + (4.1091968228101905e-07)*bt_g0_0;
    bt_l1_54 = bt_l1_54 + (8.3301097220100928e-07)*bt_g0_1;
    bt_l1_54 = bt_l1_54 + (-0.0024482160806655884)*bt_g0_2;
    bt_l1_54 = bt_l1_54 + (-6.1839486420467438e-08)*bt_g0_3;
    bt_l1_54 = bt_l1_54 + (-1.7735411006469803e-07)*bt_g0_4;
    bt_l1_54 = bt_l1_54 + (4.5252707536747039e-07)*bt_g0_5;
    bt_l1_54 = bt_l1_54 + (5.7209661008528201e-07)*bt_g0_6;
    bt_l1_54 = bt_l1_54 + (5.7345368986716494e-07)*bt_g0_7;
    bt_l1_54 = bt_l1_54 + (0.0060920147225260735)*bt_g0_8;
    bt_l1_54 = bt_l1_54 + (-5.673392138305644e-07)*bt_g0_9;
    bt_l1_54 = bt_l1_54 + (-0.00032119225943461061)*bt_g0_10;
    bt_l1_54 = bt_l1_54 + (-1.0482556263013976e-06)*bt_g0_11;
    bt_l1_54 = bt_l1_54 + (3.5985141266792198e-07)*bt_g0_12;
    bt_l1_54 = bt_l1_54 + (-0.0028173862956464291)*bt_g0_13;
    bt_l1_54 = bt_l1_54 + (-4.3657979631461785e-07)*bt_g0_14;
    bt_l1_54 = bt_l1_54 + (-3.8004293401172617e-07)*bt_g0_15;
    bt_l1_54 = bt_l1_54 + (0.00097829638980329037)*bt_g0_16;
    bt_l1_54 = bt_l1_54 + (0.0014903020346537232)*bt_g0_17;
    bt_l1_54 = bt_l1_54 + (-2.213430889241863e-06)*bt_g0_18;
    bt_l1_54 = bt_l1_54 + (5.475523607856303e-07)*bt_g0_19;
    bt_l1_54 = bt_l1_54 + (5.6338791409871192e-07)*bt_g0_20;
    bt_l1_54 = bt_l1_54 + (-4.0161819470085902e-07)*bt_g0_21;
    bt_l1_54 = bt_l1_54 + (0.0015062984311953187)*bt_g0_22;
    bt_l1_54 = bt_l1_54 + (-9.6658631321133726e-08)*bt_g0_23;
    bt_l1_54 = bt_l1_54 + (-6.2711541204407695e-07)*bt_g0_24;
    bt_l1_54 = bt_l1_54 + (-8.102290394162992e-08)*bt_g0_25;
    bt_l1_54 = bt_l1_54 + (-7.7196028769321856e-07)*bt_g0_26;
    bt_l1_54 = bt_l1_54 + (0.00053394574206322432)*bt_g0_27;
    bt_l1_54 = bt_l1_54 + (4.0172909621105646e-07)*bt_g0_28;
    bt_l1_54 = bt_l1_54 + (-3.0904595860192785e-06)*bt_g0_29;
    bt_l1_54 = bt_l1_54 + (4.8898692739385297e-07)*bt_g0_30;
    bt_l1_54 = bt_l1_54 + (-1.5051713830871449e-07)*bt_g0_31;
    bt_l1_54 = bt_l1_54 + (5.7894027349902899e-07)*bt_g0_32;
    bt_l1_54 = bt_l1_54 + (1.6688543382770149e-06)*bt_g0_33;
    bt_l1_54 = bt_l1_54 + (4.9144222202812671e-07)*bt_g0_34;
    bt_l1_54 = bt_l1_54 + (-4.4127480691713572e-07)*bt_g0_35;
    bt_l1_54 = bt_l1_54 + (-4.8526788987146574e-07)*bt_g0_36;
    bt_l1_54 = bt_l1_54 + (9.7579722080354259e-08)*bt_g0_37;
    bt_l1_54 = bt_l1_54 + (-5.6200946119133732e-07)*bt_g0_38;
    bt_l1_54 = bt_l1_54 + (-1.0825832532646018e-06)*bt_g0_39;
    bt_l1_54 = bt_l1_54 + (5.8719052731248667e-07)*bt_g0_40;
    bt_l1_54 = bt_l1_54 + (5.143970156495925e-07)*bt_g0_41;
    bt_l1_54 = bt_l1_54 + (6.0628360643022461e-07)*bt_g0_42;
    bt_l1_54 = bt_l1_54 + (5.9926219364569988e-07)*bt_g0_43;
    bt_l1_54 = bt_l1_54 + (-2.1731312926931423e-07)*bt_g0_44;
    bt_l1_54 = bt_l1_54 + (-2.2657050635643827e-07)*bt_g0_45;
    bt_l1_54 = bt_l1_54 + (-5.312467123985698e-07)*bt_g0_46;
    bt_l1_54 = bt_l1_54 + (-5.8438695305085275e-07)*bt_g0_47;
    bt_l1_54 = bt_l1_54 + (-5.8633139587982441e-07)*bt_g0_48;
    bt_l1_54 = bt_l1_54 + (3.2941352401394397e-07)*bt_g0_49;
    bt_l1_54 = bt_l1_54 + (3.8288649193418678e-06)*bt_g0_50;
    bt_l1_54 = bt_l1_54 + (5.7805823416856583e-07)*bt_g0_51;
    bt_l1_54 = bt_l1_54 + (2.516902384286368e-07)*bt_g0_52;
    bt_l1_54 = bt_l1_54 + (1.2184149511540454e-07)*bt_g0_53;
    bt_l1_54 = bt_l1_54 + (3.1933002020423373e-08)*bt_g0_54;
    bt_l1_54 = bt_l1_54 + (3.5448826452011417e-07)*bt_g0_55;
    bt_l1_54 = bt_l1_54 + (-3.6428949101718899e-07)*bt_g0_56;
    bt_l1_54 = bt_l1_54 + (-5.3611626071869978e-07)*bt_g0_57;
    bt_l1_54 = bt_l1_54 + (-0.002440793439745903)*bt_g0_58;
    bt_l1_54 = bt_l1_54 + (-1.7394222595612518e-07)*bt_g0_59;
    bt_l1_54 = bt_l1_54 + (2.1694738734368002e-06)*bt_g0_60;
    bt_l1_54 = bt_l1_54 + (5.5550816568938899e-07)*bt_g0_61;
    bt_l1_54 = bt_l1_54 + (-3.9691377651251969e-07)*bt_g0_62;
    bt_l1_54 = bt_l1_54 + (0.001418285770341754)*bt_g0_63;
    bt_l1_55 = 0.0070156585425138474;
    bt_l1_55 = bt_l1_55 + (4.1091834646067582e-07)*bt_g0_0;
    bt_l1_55 = bt_l1_55 + (8.3302808207008638e-07)*bt_g0_1;
    bt_l1_55 = bt_l1_55 + (-0.0024481646250933409)*bt_g0_2;
    bt_l1_55 = bt_l1_55 + (-6.1843053345000953e-08)*bt_g0_3;
    bt_l1_55 = bt_l1_55 + (-1.7734569723870663e-07)*bt_g0_4;
    bt_l1_55 = bt_l1_55 + (4.5252460267874994e-07)*bt_g0_5;
    bt_l1_55 = bt_l1_55 + (5.7209507531297277e-07)*bt_g0_6;
    bt_l1_55 = bt_l1_55 + (5.7345226878169342e-07)*bt_g0_7;
    bt_l1_55 = bt_l1_55 + (0.0060919295065104961)*bt_g0_8;
    bt_l1_55 = bt_l1_55 + (-5.6733881592663238e-07)*bt_g0_9;
    bt_l1_55 = bt_l1_55 + (-0.00032119208481162786)*bt_g0_10;
    bt_l1_55 = bt_l1_55 + (-1.0482862080607447e-06)*bt_g0_11;
    bt_l1_55 = bt_l1_55 + (3.5984771784569602e-07)*bt_g0_12;
    bt_l1_55 = bt_l1_55 + (-0.0028173495084047318)*bt_g0_13;
    bt_l1_55 = bt_l1_55 + (-4.365787162896595e-07)*bt_g0_14;
    bt_l1_55 = bt_l1_55 + (-3.8004020552762086e-07)*bt_g0_15;
    bt_l1_55 = bt_l1_55 + (0.00097811513114720583)*bt_g0_16;
    bt_l1_55 = bt_l1_55 + (0.0014902910916134715)*bt_g0_17;
    bt_l1_55 = bt_l1_55 + (-2.2134406663099071e-06)*bt_g0_18;
    bt_l1_55 = bt_l1_55 + (5.4755383871452068e-07)*bt_g0_19;
    bt_l1_55 = bt_l1_55 + (5.6338683407375356e-07)*bt_g0_20;
    bt_l1_55 = bt_l1_55 + (-4.0161589254239516e-07)*bt_g0_21;
    bt_l1_55 = bt_l1_55 + (0.0015062717720866203)*bt_g0_22;
    bt_l1_55 = bt_l1_55 + (-9.6652648551298626e-08)*bt_g0_23;
    bt_l1_55 = bt_l1_55 + (-6.2711410464544315e-07)*bt_g0_24;
    bt_l1_55 = bt_l1_55 + (-8.1018832531754015e-08)*bt_g0_25;
    bt_l1_55 = bt_l1_55 + (-7.719402219663607e-07)*bt_g0_26;
    bt_l1_55 = bt_l1_55 + (0.00053388363448902965)*bt_g0_27;
    bt_l1_55 = bt_l1_55 + (4.0173196680370893e-07)*bt_g0_28;
    bt_l1_55 = bt_l1_55 + (-3.0903966035111807e-06)*bt_g0_29;
    bt_l1_55 = bt_l1_55 + (4.8898471050051739e-07)*bt_g0_30;
    bt_l1_55 = bt_l1_55 + (-1.505134008539244e-07)*bt_g0_31;
    bt_l1_55 = bt_l1_55 + (5.7893839766620658e-07)*bt_g0_32;
    bt_l1_55 = bt_l1_55 + (1.668820800659887e-06)*bt_g0_33;
    bt_l1_55 = bt_l1_55 + (4.9144085778607405e-07)*bt_g0_34;
    bt_l1_55 = bt_l1_55 + (-4.412720784330304e-07)*bt_g0_35;
    bt_l1_55 = bt_l1_55 + (-4.8526680984650739e-07)*bt_g0_36;
    bt_l1_55 = bt_l1_55 + (9.7574847757186944e-08)*bt_g0_37;
    bt_l1_55 = bt_l1_55 + (-5.6200821063612239e-07)*bt_g0_38;
    bt_l1_55 = bt_l1_55 + (-1.082579501598957e-06)*bt_g0_39;
    bt_l1_55 = bt_l1_55 + (5.871899020348792e-07)*bt_g0_40;
    bt_l1_55 = bt_l1_55 + (5.1439474191283807e-07)*bt_g0_41;
    bt_l1_55 = bt_l1_55 + (6.0628315168287372e-07)*bt_g0_42;
    bt_l1_55 = bt_l1_55 + (5.9926190942860558e-07)*bt_g0_43;
    bt_l1_55 = bt_l1_55 + (-2.1730956234478072e-07)*bt_g0_44;
    bt_l1_55 = bt_l1_55 + (-2.2657425802208309e-07)*bt_g0_45;
    bt_l1_55 = bt_l1_55 + (-5.3124472287890967e-07)*bt_g0_46;
    bt_l1_55 = bt_l1_55 + (-5.8438558880880009e-07)*bt_g0_47;
    bt_l1_55 = bt_l1_55 + (-5.8633060007196036e-07)*bt_g0_48;
    bt_l1_55 = bt_l1_55 + (3.2940994287855574e-07)*bt_g0_49;
    bt_l1_55 = bt_l1_55 + (3.8287771531031467e-06)*bt_g0_50;
    bt_l1_55 = bt_l1_55 + (5.7805931419352419e-07)*bt_g0_51;
    bt_l1_55 = bt_l1_55 + (2.5169342166009301e-07)*bt_g0_52;
    bt_l1_55 = bt_l1_55 + (1.2183981823454815e-07)*bt_g0_53;
    bt_l1_55 = bt_l1_55 + (3.1928845345419177e-08)*bt_g0_54;
    bt_l1_55 = bt_l1_55 + (3.5448516655378626e-07)*bt_g0_55;
    bt_l1_55 = bt_l1_55 + (-3.6429187844078115e-07)*bt_g0_56;
    bt_l1_55 = bt_l1_55 + (-5.3615099204762373e-07)*bt_g0_57;
    bt_l1_55 = bt_l1_55 + (-0.0024407694581896067)*bt_g0_58;
    bt_l1_55 = bt_l1_55 + (-1.7393929852005385e-07)*bt_g0_59;
    bt_l1_55 = bt_l1_55 + (2.1694861516152741e-06)*bt_g0_60;
    bt_l1_55 = bt_l1_55 + (5.5550714250784949e-07)*bt_g0_61;
    bt_l1_55 = bt_l1_55 + (-3.9691167330602184e-07)*bt_g0_62;
    bt_l1_55 = bt_l1_55 + (0.0014182872837409377)*bt_g0_63;
    bt_l1_56 = -0.014038351364433765;
    bt_l1_56 = bt_l1_56 + (3.321654730825685e-06)*bt_g0_0;
    bt_l1_56 = bt_l1_56 + (-2.2050853658583947e-06)*bt_g0_1;
    bt_l1_56 = bt_l1_56 + (-0.15660078823566437)*bt_g0_2;
    bt_l1_56 = bt_l1_56 + (-1.1497553487060941e-07)*bt_g0_3;
    bt_l1_56 = bt_l1_56 + (-8.0953723227139562e-06)*bt_g0_4;
    bt_l1_56 = bt_l1_56 + (3.717840627359692e-06)*bt_g0_5;
    bt_l1_56 = bt_l1_56 + (4.634986453311285e-06)*bt_g0_6;
    bt_l1_56 = bt_l1_56 + (4.6422928789979778e-06)*bt_g0_7;
    bt_l1_56 = bt_l1_56 + (-0.058380439877510071)*bt_g0_8;
    bt_l1_56 = bt_l1_56 + (-4.4882258407596964e-06)*bt_g0_9;
    bt_l1_56 = bt_l1_56 + (0.075277522206306458)*bt_g0_10;
    bt_l1_56 = bt_l1_56 + (1.6794041584944353e-05)*bt_g0_11;
    bt_l1_56 = bt_l1_56 + (2.9784846447000746e-06)*bt_g0_12;
    bt_l1_56 = bt_l1_56 + (0.16545292735099792)*bt_g0_13;
    bt_l1_56 = bt_l1_56 + (-3.5597799978859257e-06)*bt_g0_14;
    bt_l1_56 = bt_l1_56 + (-3.1797412702871952e-06)*bt_g0_15;
    bt_l1_56 = bt_l1_56 + (-7.9946104960981756e-05)*bt_g0_16;
    bt_l1_56 = bt_l1_56 + (0.1458447277545929)*bt_g0_17;
    bt_l1_56 = bt_l1_56 + (1.4904852832842153e-05)*bt_g0_18;
    bt_l1_56 = bt_l1_56 + (2.513665549486177e-06)*bt_g0_19;
    bt_l1_56 = bt_l1_56 + (4.5498736653826199e-06)*bt_g0_20;
    bt_l1_56 = bt_l1_56 + (-3.3538995012349915e-06)*bt_g0_21;
    bt_l1_56 = bt_l1_56 + (0.11563792824745178)*bt_g0_22;
    bt_l1_56 = bt_l1_56 + (-5.451174274639925e-06)*bt_g0_23;
    bt_l1_56 = bt_l1_56 + (-4.9465970732853748e-06)*bt_g0_24;
    bt_l1_56 = bt_l1_56 + (-9.0397935537112062e-07)*bt_g0_25;
    bt_l1_56 = bt_l1_56 + (-7.6415299190557562e-06)*bt_g0_26;
    bt_l1_56 = bt_l1_56 + (-0.083864524960517883)*bt_g0_27;
    bt_l1_56 = bt_l1_56 + (2.1295531951182056e-06)*bt_g0_28;
    bt_l1_56 = bt_l1_56 + (-1.7226017007487826e-05)*bt_g0_29;
    bt_l1_56 = bt_l1_56 + (3.9539086174045224e-06)*bt_g0_30;
    bt_l1_56 = bt_l1_56 + (-1.4199390534486156e-06)*bt_g0_31;
    bt_l1_56 = bt_l1_56 + (4.5689612306887284e-06)*bt_g0_32;
    bt_l1_56 = bt_l1_56 + (8.4135344877722673e-06)*bt_g0_33;
    bt_l1_56 = bt_l1_56 + (9.4874843625802896e-07)*bt_g0_34;
    bt_l1_56 = bt_l1_56 + (-3.6116141473030439e-06)*bt_g0_35;
    bt_l1_56 = bt_l1_56 + (-3.9351230043394025e-06)*bt_g0_36;
    bt_l1_56 = bt_l1_56 + (4.7598514356650412e-06)*bt_g0_37;
    bt_l1_56 = bt_l1_56 + (-4.4699440877593588e-06)*bt_g0_38;
    bt_l1_56 = bt_l1_56 + (5.4805996114737354e-06)*bt_g0_39;
    bt_l1_56 = bt_l1_56 + (4.6443078645097557e-06)*bt_g0_40;
    bt_l1_56 = bt_l1_56 + (4.1855441850202624e-06)*bt_g0_41;
    bt_l1_56 = bt_l1_56 + (4.7278804231609683e-06)*bt_g0_42;
    bt_l1_56 = bt_l1_56 + (4.6793306864856277e-06)*bt_g0_43;
    bt_l1_56 = bt_l1_56 + (-1.8791276943375124e-06)*bt_g0_44;
    bt_l1_56 = bt_l1_56 + (-1.1613361721174442e-06)*bt_g0_45;
    bt_l1_56 = bt_l1_56 + (-4.2999313336622436e-06)*bt_g0_46;
    bt_l1_56 = bt_l1_56 + (-4.6877585191396065e-06)*bt_g0_47;
    bt_l1_56 = bt_l1_56 + (-4.6492218643834349e-06)*bt_g0_48;
    bt_l1_56 = bt_l1_56 + (2.92749109576107e-06)*bt_g0_49;
    bt_l1_56 = bt_l1_56 + (2.7081143343821168e-05)*bt_g0_50;
    bt_l1_56 = bt_l1_56 + (4.2828560253838077e-06)*bt_g0_51;
    bt_l1_56 = bt_l1_56 + (1.2151336932220147e-06)*bt_g0_52;
    bt_l1_56 = bt_l1_56 + (1.571638676978182e-06)*bt_g0_53;
    bt_l1_56 = bt_l1_56 + (5.8338122244094848e-07)*bt_g0_54;
    bt_l1_56 = bt_l1_56 + (2.9413697575364495e-06)*bt_g0_55;
    bt_l1_56 = bt_l1_56 + (5.6134326769097243e-06)*bt_g0_56;
    bt_l1_56 = bt_l1_56 + (1.2596577107615303e-05)*bt_g0_57;
    bt_l1_56 = bt_l1_56 + (-0.053052190691232681)*bt_g0_58;
    bt_l1_56 = bt_l1_56 + (-1.5745597465866012e-06)*bt_g0_59;
    bt_l1_56 = bt_l1_56 + (-1.5119168892852031e-05)*bt_g0_60;
    bt_l1_56 = bt_l1_56 + (4.427398835105123e-06)*bt_g0_61;
    bt_l1_56 = bt_l1_56 + (-3.3092164812842384e-06)*bt_g0_62;
    bt_l1_56 = bt_l1_56 + (-0.23190663754940033)*bt_g0_63;
    bt_l1_57 = 0.0070156683214008808;
    bt_l1_57 = bt_l1_57 + (4.1091868752118899e-07)*bt_g0_0;
    bt_l1_57 = bt_l1_57 + (8.3301915765332524e-07)*bt_g0_1;
    bt_l1_57 = bt_l1_57 + (-0.002448204904794693)*bt_g0_2;
    bt_l1_57 = bt_l1_57 + (-6.1841149090469116e-08)*bt_g0_3;
    bt_l1_57 = bt_l1_57 + (-1.7735054314016452e-07)*bt_g0_4;
    bt_l1_57 = bt_l1_57 + (4.5252593849909317e-07)*bt_g0_5;
    bt_l1_57 = bt_l1_57 + (5.7209581427741796e-07)*bt_g0_6;
    bt_l1_57 = bt_l1_57 + (5.7345255299878772e-07)*bt_g0_7;
    bt_l1_57 = bt_l1_57 + (0.0060919607058167458)*bt_g0_8;
    bt_l1_57 = bt_l1_57 + (-5.6733853170953807e-07)*bt_g0_9;
    bt_l1_57 = bt_l1_57 + (-0.00032119126990437508)*bt_g0_10;
    bt_l1_57 = bt_l1_57 + (-1.0482691550350864e-06)*bt_g0_11;
    bt_l1_57 = bt_l1_57 + (3.5984942314826185e-07)*bt_g0_12;
    bt_l1_57 = bt_l1_57 + (-0.0028173765167593956)*bt_g0_13;
    bt_l1_57 = bt_l1_57 + (-4.3657888681991608e-07)*bt_g0_14;
    bt_l1_57 = bt_l1_57 + (-3.800413708177075e-07)*bt_g0_15;
    bt_l1_57 = bt_l1_57 + (0.00097818521317094564)*bt_g0_16;
    bt_l1_57 = bt_l1_57 + (0.0014902624534443021)*bt_g0_17;
    bt_l1_57 = bt_l1_57 + (-2.2134358914627228e-06)*bt_g0_18;
    bt_l1_57 = bt_l1_57 + (5.4755270184614346e-07)*bt_g0_19;
    bt_l1_57 = bt_l1_57 + (5.6338683407375356e-07)*bt_g0_20;
    bt_l1_57 = bt_l1_57 + (-4.0161683045880636e-07)*bt_g0_21;
    bt_l1_57 = bt_l1_57 + (0.0015062819002196193)*bt_g0_22;
    bt_l1_57 = bt_l1_57 + (-9.6655867309891619e-08)*bt_g0_23;
    bt_l1_57 = bt_l1_57 + (-6.2711438886253745e-07)*bt_g0_24;
    bt_l1_57 = bt_l1_57 + (-8.1020914421969792e-08)*bt_g0_25;
    bt_l1_57 = bt_l1_57 + (-7.7195193171064602e-07)*bt_g0_26;
    bt_l1_57 = bt_l1_57 + (0.00053390802349895239)*bt_g0_27;
    bt_l1_57 = bt_l1_57 + (4.0173006254917709e-07)*bt_g0_28;
    bt_l1_57 = bt_l1_57 + (-3.0904323011782253e-06)*bt_g0_29;
    bt_l1_57 = bt_l1_57 + (4.8898567683863803e-07)*bt_g0_30;
    bt_l1_57 = bt_l1_57 + (-1.5051533353016566e-07)*bt_g0_31;
    bt_l1_57 = bt_l1_57 + (5.7893919347407063e-07)*bt_g0_32;
    bt_l1_57 = bt_l1_57 + (1.6688396726749488e-06)*bt_g0_33;
    bt_l1_57 = bt_l1_57 + (4.9144131253342493e-07)*bt_g0_34;
    bt_l1_57 = bt_l1_57 + (-4.4127330056653591e-07)*bt_g0_35;
    bt_l1_57 = bt_l1_57 + (-4.8526698037676397e-07)*bt_g0_36;
    bt_l1_57 = bt_l1_57 + (9.7577263602488529e-08)*bt_g0_37;
    bt_l1_57 = bt_l1_57 + (-5.6200883591372985e-07)*bt_g0_38;
    bt_l1_57 = bt_l1_57 + (-1.0825816616488737e-06)*bt_g0_39;
    bt_l1_57 = bt_l1_57 + (5.8718973150462261e-07)*bt_g0_40;
    bt_l1_57 = bt_l1_57 + (5.1439553772070212e-07)*bt_g0_41;
    bt_l1_57 = bt_l1_57 + (6.0628309483945486e-07)*bt_g0_42;
    bt_l1_57 = bt_l1_57 + (5.9926151152467355e-07)*bt_g0_43;
    bt_l1_57 = bt_l1_57 + (-2.1731129606905597e-07)*bt_g0_44;
    bt_l1_57 = bt_l1_57 + (-2.2657222586985881e-07)*bt_g0_45;
    bt_l1_57 = bt_l1_57 + (-5.3124523446967942e-07)*bt_g0_46;
    bt_l1_57 = bt_l1_57 + (-5.8438581618247554e-07)*bt_g0_47;
    bt_l1_57 = bt_l1_57 + (-5.8633065691537922e-07)*bt_g0_48;
    bt_l1_57 = bt_l1_57 + (3.2941136396402726e-07)*bt_g0_49;
    bt_l1_57 = bt_l1_57 + (3.8288262658170424e-06)*bt_g0_50;
    bt_l1_57 = bt_l1_57 + (5.7805840469882241e-07)*bt_g0_51;
    bt_l1_57 = bt_l1_57 + (2.5169146056214231e-07)*bt_g0_52;
    bt_l1_57 = bt_l1_57 + (1.2184040087959147e-07)*bt_g0_53;
    bt_l1_57 = bt_l1_57 + (3.1931062238754748e-08)*bt_g0_54;
    bt_l1_57 = bt_l1_57 + (3.5448655921754835e-07)*bt_g0_55;
    bt_l1_57 = bt_l1_57 + (-3.6429091210266051e-07)*bt_g0_56;
    bt_l1_57 = bt_l1_57 + (-5.3613064210367156e-07)*bt_g0_57;
    bt_l1_57 = bt_l1_57 + (-0.002440812299028039)*bt_g0_58;
    bt_l1_57 = bt_l1_57 + (-1.7394087592492724e-07)*bt_g0_59;
    bt_l1_57 = bt_l1_57 + (2.1694818315154407e-06)*bt_g0_60;
    bt_l1_57 = bt_l1_57 + (5.5550731303810608e-07)*bt_g0_61;
    bt_l1_57 = bt_l1_57 + (-3.9691249753559532e-07)*bt_g0_62;
    bt_l1_57 = bt_l1_57 + (0.0014182804152369499)*bt_g0_63;
    bt_l1_58 = 0.0070155938155949116;
    bt_l1_58 = bt_l1_58 + (4.1091928437708702e-07)*bt_g0_0;
    bt_l1_58 = bt_l1_58 + (8.3301432596272207e-07)*bt_g0_1;
    bt_l1_58 = bt_l1_58 + (-0.0024481879081577063)*bt_g0_2;
    bt_l1_58 = bt_l1_58 + (-6.1840523812861647e-08)*bt_g0_3;
    bt_l1_58 = bt_l1_58 + (-1.773526747683718e-07)*bt_g0_4;
    bt_l1_58 = bt_l1_58 + (4.5252645008986292e-07)*bt_g0_5;
    bt_l1_58 = bt_l1_58 + (5.7209643955502543e-07)*bt_g0_6;
    bt_l1_58 = bt_l1_58 + (5.7345329196323291e-07)*bt_g0_7;
    bt_l1_58 = bt_l1_58 + (0.0060919858515262604)*bt_g0_8;
    bt_l1_58 = bt_l1_58 + (-5.6733898645688896e-07)*bt_g0_9;
    bt_l1_58 = bt_l1_58 + (-0.00032119365641847253)*bt_g0_10;
    bt_l1_58 = bt_l1_58 + (-1.0482608558959328e-06)*bt_g0_11;
    bt_l1_58 = bt_l1_58 + (3.5985033264296362e-07)*bt_g0_12;
    bt_l1_58 = bt_l1_58 + (-0.0028173394966870546)*bt_g0_13;
    bt_l1_58 = bt_l1_58 + (-4.3657962578436127e-07)*bt_g0_14;
    bt_l1_58 = bt_l1_58 + (-3.8004225189069984e-07)*bt_g0_15;
    bt_l1_58 = bt_l1_58 + (0.00097828684374690056)*bt_g0_16;
    bt_l1_58 = bt_l1_58 + (0.001490323687903583)*bt_g0_17;
    bt_l1_58 = bt_l1_58 + (-2.2134317987365648e-06)*bt_g0_18;
    bt_l1_58 = bt_l1_58 + (5.4755253131588688e-07)*bt_g0_19;
    bt_l1_58 = bt_l1_58 + (5.6338734566452331e-07)*bt_g0_20;
    bt_l1_58 = bt_l1_58 + (-4.0161765468837984e-07)*bt_g0_21;
    bt_l1_58 = bt_l1_58 + (0.0015062987804412842)*bt_g0_22;
    bt_l1_58 = bt_l1_58 + (-9.6657380765918788e-08)*bt_g0_23;
    bt_l1_58 = bt_l1_58 + (-6.2711495729672606e-07)*bt_g0_24;
    bt_l1_58 = bt_l1_58 + (-8.1021923392654571e-08)*bt_g0_25;
    bt_l1_58 = bt_l1_58 + (-7.7195579706312856e-07)*bt_g0_26;
    bt_l1_58 = bt_l1_58 + (0.00053392892004922032)*bt_g0_27;
    bt_l1_58 = bt_l1_58 + (4.0172977833208279e-07)*bt_g0_28;
    bt_l1_58 = bt_l1_58 + (-3.0904423056199448e-06)*bt_g0_29;
    bt_l1_58 = bt_l1_58 + (4.8898613158598891e-07)*bt_g0_30;
    bt_l1_58 = bt_l1_58 + (-1.5051604407290142e-07)*bt_g0_31;
    bt_l1_58 = bt_l1_58 + (5.7893987559509696e-07)*bt_g0_32;
    bt_l1_58 = bt_l1_58 + (1.6688460391378612e-06)*bt_g0_33;
    bt_l1_58 = bt_l1_58 + (4.9144148306368152e-07)*bt_g0_34;
    bt_l1_58 = bt_l1_58 + (-4.4127398268756224e-07)*bt_g0_35;
    bt_l1_58 = bt_l1_58 + (-4.8526754881095258e-07)*bt_g0_36;
    bt_l1_58 = bt_l1_58 + (9.7578826796507201e-08)*bt_g0_37;
    bt_l1_58 = bt_l1_58 + (-5.6200923381766188e-07)*bt_g0_38;
    bt_l1_58 = bt_l1_58 + (-1.082580297406821e-06)*bt_g0_39;
    bt_l1_58 = bt_l1_58 + (5.8719024309539236e-07)*bt_g0_40;
    bt_l1_58 = bt_l1_58 + (5.1439627668514731e-07)*bt_g0_41;
    bt_l1_58 = bt_l1_58 + (6.0628360643022461e-07)*bt_g0_42;
    bt_l1_58 = bt_l1_58 + (5.992620231154433e-07)*bt_g0_43;
    bt_l1_58 = bt_l1_58 + (-2.1731227661803132e-07)*bt_g0_44;
    bt_l1_58 = bt_l1_58 + (-2.2657147269455891e-07)*bt_g0_45;
    bt_l1_58 = bt_l1_58 + (-5.3124597343412461e-07)*bt_g0_46;
    bt_l1_58 = bt_l1_58 + (-5.8438638461666415e-07)*bt_g0_47;
    bt_l1_58 = bt_l1_58 + (-5.8633122534956783e-07)*bt_g0_48;
    bt_l1_58 = bt_l1_58 + (3.2941247241069505e-07)*bt_g0_49;
    bt_l1_58 = bt_l1_58 + (3.8288408177322708e-06)*bt_g0_50;
    bt_l1_58 = bt_l1_58 + (5.7805840469882241e-07)*bt_g0_51;
    bt_l1_58 = bt_l1_58 + (2.5169094897137256e-07)*bt_g0_52;
    bt_l1_58 = bt_l1_58 + (1.2184101194634422e-07)*bt_g0_53;
    bt_l1_58 = bt_l1_58 + (3.1931921995465018e-08)*bt_g0_54;
    bt_l1_58 = bt_l1_58 + (3.5448749713395955e-07)*bt_g0_55;
    bt_l1_58 = bt_l1_58 + (-3.6428923522180412e-07)*bt_g0_56;
    bt_l1_58 = bt_l1_58 + (-5.3612393458024599e-07)*bt_g0_57;
    bt_l1_58 = bt_l1_58 + (-0.0024407627061009407)*bt_g0_58;
    bt_l1_58 = bt_l1_58 + (-1.7394138751569699e-07)*bt_g0_59;
    bt_l1_58 = bt_l1_58 + (2.1694738734368002e-06)*bt_g0_60;
    bt_l1_58 = bt_l1_58 + (5.5550782462887582e-07)*bt_g0_61;
    bt_l1_58 = bt_l1_58 + (-3.9691326492174994e-07)*bt_g0_62;
    bt_l1_58 = bt_l1_58 + (0.0014182885643094778)*bt_g0_63;
    bt_l1_59 = 0.0070156347937881947;
    bt_l1_59 = bt_l1_59 + (4.1091962543760019e-07)*bt_g0_0;
    bt_l1_59 = bt_l1_59 + (8.3300705000510789e-07)*bt_g0_1;
    bt_l1_59 = bt_l1_59 + (-0.0024482279550284147)*bt_g0_2;
    bt_l1_59 = bt_l1_59 + (-6.1838065334995918e-08)*bt_g0_3;
    bt_l1_59 = bt_l1_59 + (-1.7735699486820522e-07)*bt_g0_4;
    bt_l1_59 = bt_l1_59 + (4.5252775748849672e-07)*bt_g0_5;
    bt_l1_59 = bt_l1_59 + (5.7209700798921403e-07)*bt_g0_6;
    bt_l1_59 = bt_l1_59 + (5.7345420145793469e-07)*bt_g0_7;
    bt_l1_59 = bt_l1_59 + (0.0060920282267034054)*bt_g0_8;
    bt_l1_59 = bt_l1_59 + (-5.6733881592663238e-07)*bt_g0_9;
    bt_l1_59 = bt_l1_59 + (-0.00032119124080054462)*bt_g0_10;
    bt_l1_59 = bt_l1_59 + (-1.0482457355465158e-06)*bt_g0_11;
    bt_l1_59 = bt_l1_59 + (3.5985263480142748e-07)*bt_g0_12;
    bt_l1_59 = bt_l1_59 + (-0.0028174160979688168)*bt_g0_13;
    bt_l1_59 = bt_l1_59 + (-4.3657985315803671e-07)*bt_g0_14;
    bt_l1_59 = bt_l1_59 + (-3.8004358771104307e-07)*bt_g0_15;
    bt_l1_59 = bt_l1_59 + (0.00097832863684743643)*bt_g0_16;
    bt_l1_59 = bt_l1_59 + (0.0014902703696861863)*bt_g0_17;
    bt_l1_59 = bt_l1_59 + (-2.2134336177259684e-06)*bt_g0_18;
    bt_l1_59 = bt_l1_59 + (5.4755156497776625e-07)*bt_g0_19;
    bt_l1_59 = bt_l1_59 + (5.6338797094213078e-07)*bt_g0_20;
    bt_l1_59 = bt_l1_59 + (-4.0161893366530421e-07)*bt_g0_21;
    bt_l1_59 = bt_l1_59 + (0.0015062836464494467)*bt_g0_22;
    bt_l1_59 = bt_l1_59 + (-9.6660656367930642e-08)*bt_g0_23;
    bt_l1_59 = bt_l1_59 + (-6.2711535520065809e-07)*bt_g0_24;
    bt_l1_59 = bt_l1_59 + (-8.1024424503084447e-08)*bt_g0_25;
    bt_l1_59 = bt_l1_59 + (-7.719689278928854e-07)*bt_g0_26;
    bt_l1_59 = bt_l1_59 + (0.00053395598661154509)*bt_g0_27;
    bt_l1_59 = bt_l1_59 + (4.017277319690038e-07)*bt_g0_28;
    bt_l1_59 = bt_l1_59 + (-3.0904811865184456e-06)*bt_g0_29;
    bt_l1_59 = bt_l1_59 + (4.8898755267146043e-07)*bt_g0_30;
    bt_l1_59 = bt_l1_59 + (-1.5051865887016902e-07)*bt_g0_31;
    bt_l1_59 = bt_l1_59 + (5.7894095562005532e-07)*bt_g0_32;
    bt_l1_59 = bt_l1_59 + (1.6688658206476248e-06)*bt_g0_33;
    bt_l1_59 = bt_l1_59 + (4.9144273361889645e-07)*bt_g0_34;
    bt_l1_59 = bt_l1_59 + (-4.4127540377303376e-07)*bt_g0_35;
    bt_l1_59 = bt_l1_59 + (-4.8526788987146574e-07)*bt_g0_36;
    bt_l1_59 = bt_l1_59 + (9.7580731051039038e-08)*bt_g0_37;
    bt_l1_59 = bt_l1_59 + (-5.6200985909526935e-07)*bt_g0_38;
    bt_l1_59 = bt_l1_59 + (-1.0825865501828957e-06)*bt_g0_39;
    bt_l1_59 = bt_l1_59 + (5.8719012940855464e-07)*bt_g0_40;
    bt_l1_59 = bt_l1_59 + (5.1439718617984909e-07)*bt_g0_41;
    bt_l1_59 = bt_l1_59 + (6.0628349274338689e-07)*bt_g0_42;
    bt_l1_59 = bt_l1_59 + (5.9926185258518672e-07)*bt_g0_43;
    bt_l1_59 = bt_l1_59 + (-2.1731439403538388e-07)*bt_g0_44;
    bt_l1_59 = bt_l1_59 + (-2.265691279035309e-07)*bt_g0_45;
    bt_l1_59 = bt_l1_59 + (-5.312469966156641e-07)*bt_g0_46;
    bt_l1_59 = bt_l1_59 + (-5.8438712358110934e-07)*bt_g0_47;
    bt_l1_59 = bt_l1_59 + (-5.8633133903640555e-07)*bt_g0_48;
    bt_l1_59 = bt_l1_59 + (3.294144903520646e-07)*bt_g0_49;
    bt_l1_59 = bt_l1_59 + (3.8288981158984825e-06)*bt_g0_50;
    bt_l1_59 = bt_l1_59 + (5.7805794995147153e-07)*bt_g0_51;
    bt_l1_59 = bt_l1_59 + (2.5168878892145585e-07)*bt_g0_52;
    bt_l1_59 = bt_l1_59 + (1.2184166564566112e-07)*bt_g0_53;
    bt_l1_59 = bt_l1_59 + (3.1934693112134482e-08)*bt_g0_54;
    bt_l1_59 = bt_l1_59 + (3.5448908874968765e-07)*bt_g0_55;
    bt_l1_59 = bt_l1_59 + (-3.6428988892112102e-07)*bt_g0_56;
    bt_l1_59 = bt_l1_59 + (-5.3610705208484433e-07)*bt_g0_57;
    bt_l1_59 = bt_l1_59 + (-0.002440829761326313)*bt_g0_58;
    bt_l1_59 = bt_l1_59 + (-1.7394322071595525e-07)*bt_g0_59;
    bt_l1_59 = bt_l1_59 + (2.1694756924262038e-06)*bt_g0_60;
    bt_l1_59 = bt_l1_59 + (5.5550805200255127e-07)*bt_g0_61;
    bt_l1_59 = bt_l1_59 + (-3.9691457232038374e-07)*bt_g0_62;
    bt_l1_59 = bt_l1_59 + (0.0014182887971401215)*bt_g0_63;
    bt_l1_60 = 0.057249613106250763;
    bt_l1_60 = bt_l1_60 + (3.0141050046950113e-06)*bt_g0_0;
    bt_l1_60 = bt_l1_60 + (1.7292642951360904e-05)*bt_g0_1;
    bt_l1_60 = bt_l1_60 + (0.11723722517490387)*bt_g0_2;
    bt_l1_60 = bt_l1_60 + (-8.1718405908759451e-07)*bt_g0_3;
    bt_l1_60 = bt_l1_60 + (6.9797579271835275e-06)*bt_g0_4;
    bt_l1_60 = bt_l1_60 + (3.5919765650760382e-06)*bt_g0_5;
    bt_l1_60 = bt_l1_60 + (4.5182600842963438e-06)*bt_g0_6;
    bt_l1_60 = bt_l1_60 + (4.5490032789530233e-06)*bt_g0_7;
    bt_l1_60 = bt_l1_60 + (-0.045524623245000839)*bt_g0_8;
    bt_l1_60 = bt_l1_60 + (-4.2608808143995702e-06)*bt_g0_9;
    bt_l1_60 = bt_l1_60 + (-0.021900191903114319)*bt_g0_10;
    bt_l1_60 = bt_l1_60 + (-2.8078942705178633e-05)*bt_g0_11;
    bt_l1_60 = bt_l1_60 + (1.6448110500277835e-06)*bt_g0_12;
    bt_l1_60 = bt_l1_60 + (0.0075078601948916912)*bt_g0_13;
    bt_l1_60 = bt_l1_60 + (-3.3315855034743436e-06)*bt_g0_14;
    bt_l1_60 = bt_l1_60 + (-3.0371004413609626e-06)*bt_g0_15;
    bt_l1_60 = bt_l1_60 + (-0.25222468376159668)*bt_g0_16;
    bt_l1_60 = bt_l1_60 + (0.11289578676223755)*bt_g0_17;
    bt_l1_60 = bt_l1_60 + (-2.2432503101299517e-05)*bt_g0_18;
    bt_l1_60 = bt_l1_60 + (3.5664827464643167e-06)*bt_g0_19;
    bt_l1_60 = bt_l1_60 + (4.3037393879785668e-06)*bt_g0_20;
    bt_l1_60 = bt_l1_60 + (-3.235031726944726e-06)*bt_g0_21;
    bt_l1_60 = bt_l1_60 + (0.062492229044437408)*bt_g0_22;
    bt_l1_60 = bt_l1_60 + (4.927142526867101e-06)*bt_g0_23;
    bt_l1_60 = bt_l1_60 + (-4.650182745535858e-06)*bt_g0_24;
    bt_l1_60 = bt_l1_60 + (-2.1119087989518448e-07)*bt_g0_25;
    bt_l1_60 = bt_l1_60 + (1.2123704436817206e-05)*bt_g0_26;
    bt_l1_60 = bt_l1_60 + (0.068552002310752869)*bt_g0_27;
    bt_l1_60 = bt_l1_60 + (3.3510866614960833e-06)*bt_g0_28;
    bt_l1_60 = bt_l1_60 + (3.6532474041450769e-05)*bt_g0_29;
    bt_l1_60 = bt_l1_60 + (3.8315592973958701e-06)*bt_g0_30;
    bt_l1_60 = bt_l1_60 + (-7.945563424982538e-07)*bt_g0_31;
    bt_l1_60 = bt_l1_60 + (4.3438362808956299e-06)*bt_g0_32;
    bt_l1_60 = bt_l1_60 + (-1.8845386875909753e-05)*bt_g0_33;
    bt_l1_60 = bt_l1_60 + (1.8197416693510604e-06)*bt_g0_34;
    bt_l1_60 = bt_l1_60 + (-3.5557470710045891e-06)*bt_g0_35;
    bt_l1_60 = bt_l1_60 + (-3.699620265251724e-06)*bt_g0_36;
    bt_l1_60 = bt_l1_60 + (-4.5529404815169983e-06)*bt_g0_37;
    bt_l1_60 = bt_l1_60 + (-4.242893737682607e-06)*bt_g0_38;
    bt_l1_60 = bt_l1_60 + (-3.035538611584343e-06)*bt_g0_39;
    bt_l1_60 = bt_l1_60 + (4.3914947127632331e-06)*bt_g0_40;
    bt_l1_60 = bt_l1_60 + (4.162803634244483e-06)*bt_g0_41;
    bt_l1_60 = bt_l1_60 + (4.3822064981213771e-06)*bt_g0_42;
    bt_l1_60 = bt_l1_60 + (4.2967762965417933e-06)*bt_g0_43;
    bt_l1_60 = bt_l1_60 + (-1.6306017869283096e-06)*bt_g0_44;
    bt_l1_60 = bt_l1_60 + (-2.1508533336600522e-06)*bt_g0_45;
    bt_l1_60 = bt_l1_60 + (-4.3162995098100509e-06)*bt_g0_46;
    bt_l1_60 = bt_l1_60 + (-4.4820180846727453e-06)*bt_g0_47;
    bt_l1_60 = bt_l1_60 + (-4.3728837226808537e-06)*bt_g0_48;
    bt_l1_60 = bt_l1_60 + (-1.5875565395617741e-06)*bt_g0_49;
    bt_l1_60 = bt_l1_60 + (-5.2529041568050161e-05)*bt_g0_50;
    bt_l1_60 = bt_l1_60 + (3.5243501770310104e-06)*bt_g0_51;
    bt_l1_60 = bt_l1_60 + (2.4399926132900873e-06)*bt_g0_52;
    bt_l1_60 = bt_l1_60 + (-2.7791821821665508e-07)*bt_g0_53;
    bt_l1_60 = bt_l1_60 + (-3.0723089139428339e-07)*bt_g0_54;
    bt_l1_60 = bt_l1_60 + (2.8085964913771022e-06)*bt_g0_55;
    bt_l1_60 = bt_l1_60 + (-4.8341598812839948e-06)*bt_g0_56;
    bt_l1_60 = bt_l1_60 + (-2.6033227186417207e-05)*bt_g0_57;
    bt_l1_60 = bt_l1_60 + (0.10506676137447357)*bt_g0_58;
    bt_l1_60 = bt_l1_60 + (-1.4369046539286501e-06)*bt_g0_59;
    bt_l1_60 = bt_l1_60 + (2.3351845811703242e-05)*bt_g0_60;
    bt_l1_60 = bt_l1_60 + (4.1810612856352236e-06)*bt_g0_61;
    bt_l1_60 = bt_l1_60 + (-3.226119588362053e-06)*bt_g0_62;
    bt_l1_60 = bt_l1_60 + (0.13351918756961823)*bt_g0_63;
    bt_l1_61 = 0.0070156184956431389;
    bt_l1_61 = bt_l1_61 + (4.1091897173828329e-07)*bt_g0_0;
    bt_l1_61 = bt_l1_61 + (8.3301011954972637e-07)*bt_g0_1;
    bt_l1_61 = bt_l1_61 + (-0.0024482053704559803)*bt_g0_2;
    bt_l1_61 = bt_l1_61 + (-6.1838953513415618e-08)*bt_g0_3;
    bt_l1_61 = bt_l1_61 + (-1.7735500534854509e-07)*bt_g0_4;
    bt_l1_61 = bt_l1_61 + (4.5252639324644406e-07)*bt_g0_5;
    bt_l1_61 = bt_l1_61 + (5.7209592796425568e-07)*bt_g0_6;
    bt_l1_61 = bt_l1_61 + (5.7345295090271975e-07)*bt_g0_7;
    bt_l1_61 = bt_l1_61 + (0.0060919881798326969)*bt_g0_8;
    bt_l1_61 = bt_l1_61 + (-5.6733790643193061e-07)*bt_g0_9;
    bt_l1_61 = bt_l1_61 + (-0.0003211915900465101)*bt_g0_10;
    bt_l1_61 = bt_l1_61 + (-1.0482534662514809e-06)*bt_g0_11;
    bt_l1_61 = bt_l1_61 + (3.5985127055937483e-07)*bt_g0_12;
    bt_l1_61 = bt_l1_61 + (-0.0028173527680337429)*bt_g0_13;
    bt_l1_61 = bt_l1_61 + (-4.3657894366333494e-07)*bt_g0_14;
    bt_l1_61 = bt_l1_61 + (-3.80042393999247e-07)*bt_g0_15;
    bt_l1_61 = bt_l1_61 + (0.00097831664606928825)*bt_g0_16;
    bt_l1_61 = bt_l1_61 + (0.0014902995899319649)*bt_g0_17;
    bt_l1_61 = bt_l1_61 + (-2.2134322534839157e-06)*bt_g0_18;
    bt_l1_61 = bt_l1_61 + (5.4755122391725308e-07)*bt_g0_19;
    bt_l1_61 = bt_l1_61 + (5.6338700460401014e-07)*bt_g0_20;
    bt_l1_61 = bt_l1_61 + (-4.016177115317987e-07)*bt_g0_21;
    bt_l1_61 = bt_l1_61 + (0.0015062845777720213)*bt_g0_22;
    bt_l1_61 = bt_l1_61 + (-9.6659441339852492e-08)*bt_g0_23;
    bt_l1_61 = bt_l1_61 + (-6.2711416148886201e-07)*bt_g0_24;
    bt_l1_61 = bt_l1_61 + (-8.1023138420732721e-08)*bt_g0_25;
    bt_l1_61 = bt_l1_61 + (-7.7196528991407831e-07)*bt_g0_26;
    bt_l1_61 = bt_l1_61 + (0.00053393084090203047)*bt_g0_27;
    bt_l1_61 = bt_l1_61 + (4.0172798776438867e-07)*bt_g0_28;
    bt_l1_61 = bt_l1_61 + (-3.090469590460998e-06)*bt_g0_29;
    bt_l1_61 = bt_l1_61 + (4.8898641580308322e-07)*bt_g0_30;
    bt_l1_61 = bt_l1_61 + (-1.5051725199555221e-07)*bt_g0_31;
    bt_l1_61 = bt_l1_61 + (5.7893964822142152e-07)*bt_g0_32;
    bt_l1_61 = bt_l1_61 + (1.6688595678715501e-06)*bt_g0_33;
    bt_l1_61 = bt_l1_61 + (4.9144176728077582e-07)*bt_g0_34;
    bt_l1_61 = bt_l1_61 + (-4.412743237480754e-07)*bt_g0_35;
    bt_l1_61 = bt_l1_61 + (-4.8526703722018283e-07)*bt_g0_36;
    bt_l1_61 = bt_l1_61 + (9.757927443843073e-08)*bt_g0_37;
    bt_l1_61 = bt_l1_61 + (-5.6200889275714871e-07)*bt_g0_38;
    bt_l1_61 = bt_l1_61 + (-1.0825849585671676e-06)*bt_g0_39;
    bt_l1_61 = bt_l1_61 + (5.8718927675727173e-07)*bt_g0_40;
    bt_l1_61 = bt_l1_61 + (5.1439604931147187e-07)*bt_g0_41;
    bt_l1_61 = bt_l1_61 + (6.0628264009210397e-07)*bt_g0_42;
    bt_l1_61 = bt_l1_61 + (5.9926094309048494e-07)*bt_g0_43;
    bt_l1_61 = bt_l1_61 + (-2.1731308663675009e-07)*bt_g0_44;
    bt_l1_61 = bt_l1_61 + (-2.265697816028478e-07)*bt_g0_45;
    bt_l1_61 = bt_l1_61 + (-5.3124591659070575e-07)*bt_g0_46;
    bt_l1_61 = bt_l1_61 + (-5.8438598671273212e-07)*bt_g0_47;
    bt_l1_61 = bt_l1_61 + (-5.8633042954170378e-07)*bt_g0_48;
    bt_l1_61 = bt_l1_61 + (3.2941284189291764e-07)*bt_g0_49;
    bt_l1_61 = bt_l1_61 + (3.8288794712570962e-06)*bt_g0_50;
    bt_l1_61 = bt_l1_61 + (5.7805732467386406e-07)*bt_g0_51;
    bt_l1_61 = bt_l1_61 + (2.5168935735564446e-07)*bt_g0_52;
    bt_l1_61 = bt_l1_61 + (1.2184094089207065e-07)*bt_g0_53;
    bt_l1_61 = bt_l1_61 + (3.1933581112753018e-08)*bt_g0_54;
    bt_l1_61 = bt_l1_61 + (3.5448798030301987e-07)*bt_g0_55;
    bt_l1_61 = bt_l1_61 + (-3.6429011629479646e-07)*bt_g0_56;
    bt_l1_61 = bt_l1_61 + (-5.361147827898094e-07)*bt_g0_57;
    bt_l1_61 = bt_l1_61 + (-0.0024408209137618542)*bt_g0_58;
    bt_l1_61 = bt_l1_61 + (-1.7394215490185161e-07)*bt_g0_59;
    bt_l1_61 = bt_l1_61 + (2.1694750103051774e-06)*bt_g0_60;
    bt_l1_61 = bt_l1_61 + (5.5550719935126835e-07)*bt_g0_61;
    bt_l1_61 = bt_l1_61 + (-3.9691340703029709e-07)*bt_g0_62;
    bt_l1_61 = bt_l1_61 + (0.0014182757586240768)*bt_g0_63;
    bt_l1_62 = 0.0070156194269657135;
    bt_l1_62 = bt_l1_62 + (4.1091971070272848e-07)*bt_g0_0;
    bt_l1_62 = bt_l1_62 + (8.3300204778424813e-07)*bt_g0_1;
    bt_l1_62 = bt_l1_62 + (-0.0024482335429638624)*bt_g0_2;
    bt_l1_62 = bt_l1_62 + (-6.1837013731746993e-08)*bt_g0_3;
    bt_l1_62 = bt_l1_62 + (-1.7735963808718225e-07)*bt_g0_4;
    bt_l1_62 = bt_l1_62 + (4.5252801328388159e-07)*bt_g0_5;
    bt_l1_62 = bt_l1_62 + (5.7209695114579517e-07)*bt_g0_6;
    bt_l1_62 = bt_l1_62 + (5.7345380355400266e-07)*bt_g0_7;
    bt_l1_62 = bt_l1_62 + (0.0060920258983969688)*bt_g0_8;
    bt_l1_62 = bt_l1_62 + (-5.6733836117928149e-07)*bt_g0_9;
    bt_l1_62 = bt_l1_62 + (-0.00032118958188220859)*bt_g0_10;
    bt_l1_62 = bt_l1_62 + (-1.0482383459020639e-06)*bt_g0_11;
    bt_l1_62 = bt_l1_62 + (3.5985354429612926e-07)*bt_g0_12;
    bt_l1_62 = bt_l1_62 + (-0.0028174128383398056)*bt_g0_13;
    bt_l1_62 = bt_l1_62 + (-4.3657982473632728e-07)*bt_g0_14;
    bt_l1_62 = bt_l1_62 + (-3.8004401403668453e-07)*bt_g0_15;
    bt_l1_62 = bt_l1_62 + (0.00097838975489139557)*bt_g0_16;
    bt_l1_62 = bt_l1_62 + (0.001490278635174036)*bt_g0_17;
    bt_l1_62 = bt_l1_62 + (-2.2134311166155385e-06)*bt_g0_18;
    bt_l1_62 = bt_l1_62 + (5.4755065548306447e-07)*bt_g0_19;
    bt_l1_62 = bt_l1_62 + (5.6338791409871192e-07)*bt_g0_20;
    bt_l1_62 = bt_l1_62 + (-4.0161910419556079e-07)*bt_g0_21;
    bt_l1_62 = bt_l1_62 + (0.0015062830643728375)*bt_g0_22;
    bt_l1_62 = bt_l1_62 + (-9.6662269299940817e-08)*bt_g0_23;
    bt_l1_62 = bt_l1_62 + (-6.2711524151382037e-07)*bt_g0_24;
    bt_l1_62 = bt_l1_62 + (-8.1025476106333372e-08)*bt_g0_25;
    bt_l1_62 = bt_l1_62 + (-7.7197552172947326e-07)*bt_g0_26;
    bt_l1_62 = bt_l1_62 + (0.00053396762814372778)*bt_g0_27;
    bt_l1_62 = bt_l1_62 + (4.0172659510062658e-07)*bt_g0_28;
    bt_l1_62 = bt_l1_62 + (-3.0905057428753935e-06)*bt_g0_29;
    bt_l1_62 = bt_l1_62 + (4.8898755267146043e-07)*bt_g0_30;
    bt_l1_62 = bt_l1_62 + (-1.5051945467803307e-07)*bt_g0_31;
    bt_l1_62 = bt_l1_62 + (5.7894089877663646e-07)*bt_g0_32;
    bt_l1_62 = bt_l1_62 + (1.6688785535734496e-06)*bt_g0_33;
    bt_l1_62 = bt_l1_62 + (4.914429609925719e-07)*bt_g0_34;
    bt_l1_62 = bt_l1_62 + (-4.4127588694209408e-07)*bt_g0_35;
    bt_l1_62 = bt_l1_62 + (-4.8526771934120916e-07)*bt_g0_36;
    bt_l1_62 = bt_l1_62 + (9.7582216085356777e-08)*bt_g0_37;
    bt_l1_62 = bt_l1_62 + (-5.6200968856501277e-07)*bt_g0_38;
    bt_l1_62 = bt_l1_62 + (-1.0825890512933256e-06)*bt_g0_39;
    bt_l1_62 = bt_l1_62 + (5.871899020348792e-07)*bt_g0_40;
    bt_l1_62 = bt_l1_62 + (5.1439747039694339e-07)*bt_g0_41;
    bt_l1_62 = bt_l1_62 + (6.0628320852629258e-07)*bt_g0_42;
    bt_l1_62 = bt_l1_62 + (5.9926179574176786e-07)*bt_g0_43;
    bt_l1_62 = bt_l1_62 + (-2.1731516142153851e-07)*bt_g0_44;
    bt_l1_62 = bt_l1_62 + (-2.2656789155917068e-07)*bt_g0_45;
    bt_l1_62 = bt_l1_62 + (-5.3124722398933955e-07)*bt_g0_46;
    bt_l1_62 = bt_l1_62 + (-5.8438689620743389e-07)*bt_g0_47;
    bt_l1_62 = bt_l1_62 + (-5.8633105481931125e-07)*bt_g0_48;
    bt_l1_62 = bt_l1_62 + (3.2941503036454378e-07)*bt_g0_49;
    bt_l1_62 = bt_l1_62 + (3.828924036497483e-06)*bt_g0_50;
    bt_l1_62 = bt_l1_62 + (5.7805715414360748e-07)*bt_g0_51;
    bt_l1_62 = bt_l1_62 + (2.5168762363136921e-07)*bt_g0_52;
    bt_l1_62 = bt_l1_62 + (1.2184183617591771e-07)*bt_g0_53;
    bt_l1_62 = bt_l1_62 + (3.1935986299913566e-08)*bt_g0_54;
    bt_l1_62 = bt_l1_62 + (3.5448977087071398e-07)*bt_g0_55;
    bt_l1_62 = bt_l1_62 + (-3.6428917837838526e-07)*bt_g0_56;
    bt_l1_62 = bt_l1_62 + (-5.3609636552209849e-07)*bt_g0_57;
    bt_l1_62 = bt_l1_62 + (-0.0024408556055277586)*bt_g0_58;
    bt_l1_62 = bt_l1_62 + (-1.7394388862612686e-07)*bt_g0_59;
    bt_l1_62 = bt_l1_62 + (2.1694720544473967e-06)*bt_g0_60;
    bt_l1_62 = bt_l1_62 + (5.555077109420381e-07)*bt_g0_61;
    bt_l1_62 = bt_l1_62 + (-3.9691479969405918e-07)*bt_g0_62;
    bt_l1_62 = bt_l1_62 + (0.0014182885643094778)*bt_g0_63;
    bt_l1_63 = 0.0070156827569007874;
    bt_l1_63 = bt_l1_63 + (4.1091783486990607e-07)*bt_g0_0;
    bt_l1_63 = bt_l1_63 + (8.3302961684239563e-07)*bt_g0_1;
    bt_l1_63 = bt_l1_63 + (-0.0024481501895934343)*bt_g0_2;
    bt_l1_63 = bt_l1_63 + (-6.1842790444188722e-08)*bt_g0_3;
    bt_l1_63 = bt_l1_63 + (-1.7734475932229543e-07)*bt_g0_4;
    bt_l1_63 = bt_l1_63 + (4.5252417635310849e-07)*bt_g0_5;
    bt_l1_63 = bt_l1_63 + (5.7209433634852758e-07)*bt_g0_6;
    bt_l1_63 = bt_l1_63 + (5.7345135928699165e-07)*bt_g0_7;
    bt_l1_63 = bt_l1_63 + (0.0060919271782040596)*bt_g0_8;
    bt_l1_63 = bt_l1_63 + (-5.6733802011876833e-07)*bt_g0_9;
    bt_l1_63 = bt_l1_63 + (-0.0003211915900465101)*bt_g0_10;
    bt_l1_63 = bt_l1_63 + (-1.0482895049790386e-06)*bt_g0_11;
    bt_l1_63 = bt_l1_63 + (3.5984729152005457e-07)*bt_g0_12;
    bt_l1_63 = bt_l1_63 + (-0.0028173441532999277)*bt_g0_13;
    bt_l1_63 = bt_l1_63 + (-4.3657814785547089e-07)*bt_g0_14;
    bt_l1_63 = bt_l1_63 + (-3.8003992131052655e-07)*bt_g0_15;
    bt_l1_63 = bt_l1_63 + (0.00097810209263116121)*bt_g0_16;
    bt_l1_63 = bt_l1_63 + (0.0014902802649885416)*bt_g0_17;
    bt_l1_63 = bt_l1_63 + (-2.2134474875201704e-06)*bt_g0_18;
    bt_l1_63 = bt_l1_63 + (5.4755292921981891e-07)*bt_g0_19;
    bt_l1_63 = bt_l1_63 + (5.6338626563956495e-07)*bt_g0_20;
    bt_l1_63 = bt_l1_63 + (-4.016154662167537e-07)*bt_g0_21;
    bt_l1_63 = bt_l1_63 + (0.0015062695601955056)*bt_g0_22;
    bt_l1_63 = bt_l1_63 + (-9.6652328807067533e-08)*bt_g0_23;
    bt_l1_63 = bt_l1_63 + (-6.2711353621125454e-07)*bt_g0_24;
    bt_l1_63 = bt_l1_63 + (-8.1018860953463445e-08)*bt_g0_25;
    bt_l1_63 = bt_l1_63 + (-7.7194226832943968e-07)*bt_g0_26;
    bt_l1_63 = bt_l1_63 + (0.00053387443767860532)*bt_g0_27;
    bt_l1_63 = bt_l1_63 + (4.0173136994781089e-07)*bt_g0_28;
    bt_l1_63 = bt_l1_63 + (-3.0904047889634967e-06)*bt_g0_29;
    bt_l1_63 = bt_l1_63 + (4.889839715360722e-07)*bt_g0_30;
    bt_l1_63 = bt_l1_63 + (-1.505135003299074e-07)*bt_g0_31;
    bt_l1_63 = bt_l1_63 + (5.7893782923201798e-07)*bt_g0_32;
    bt_l1_63 = bt_l1_63 + (1.6688233017703169e-06)*bt_g0_33;
    bt_l1_63 = bt_l1_63 + (4.9144068725581747e-07)*bt_g0_34;
    bt_l1_63 = bt_l1_63 + (-4.4127131104687578e-07)*bt_g0_35;
    bt_l1_63 = bt_l1_63 + (-4.8526595719522447e-07)*bt_g0_36;
    bt_l1_63 = bt_l1_63 + (9.7573703783382371e-08)*bt_g0_37;
    bt_l1_63 = bt_l1_63 + (-5.6200758535851492e-07)*bt_g0_38;
    bt_l1_63 = bt_l1_63 + (-1.0825816616488737e-06)*bt_g0_39;
    bt_l1_63 = bt_l1_63 + (5.8718882200992084e-07)*bt_g0_40;
    bt_l1_63 = bt_l1_63 + (5.1439423032206832e-07)*bt_g0_41;
    bt_l1_63 = bt_l1_63 + (6.0628252640526625e-07)*bt_g0_42;
    bt_l1_63 = bt_l1_63 + (5.9926082940364722e-07)*bt_g0_43;
    bt_l1_63 = bt_l1_63 + (-2.1730943444708828e-07)*bt_g0_44;
    bt_l1_63 = bt_l1_63 + (-2.2657373222045862e-07)*bt_g0_45;
    bt_l1_63 = bt_l1_63 + (-5.3124392707104562e-07)*bt_g0_46;
    bt_l1_63 = bt_l1_63 + (-5.8438502037461149e-07)*bt_g0_47;
    bt_l1_63 = bt_l1_63 + (-5.8632969057725859e-07)*bt_g0_48;
    bt_l1_63 = bt_l1_63 + (3.294090618055634e-07)*bt_g0_49;
    bt_l1_63 = bt_l1_63 + (3.8287871575448662e-06)*bt_g0_50;
    bt_l1_63 = bt_l1_63 + (5.7805868891591672e-07)*bt_g0_51;
    bt_l1_63 = bt_l1_63 + (2.5169276796077611e-07)*bt_g0_52;
    bt_l1_63 = bt_l1_63 + (1.2183936348719726e-07)*bt_g0_53;
    bt_l1_63 = bt_l1_63 + (3.1929122457086123e-08)*bt_g0_54;
    bt_l1_63 = bt_l1_63 + (3.5448491075840138e-07)*bt_g0_55;
    bt_l1_63 = bt_l1_63 + (-3.6429335636967153e-07)*bt_g0_56;
    bt_l1_63 = bt_l1_63 + (-5.3615093520420487e-07)*bt_g0_57;
    bt_l1_63 = bt_l1_63 + (-0.0024407778400927782)*bt_g0_58;
    bt_l1_63 = bt_l1_63 + (-1.7393924167663499e-07)*bt_g0_59;
    bt_l1_63 = bt_l1_63 + (2.1694918359571602e-06)*bt_g0_60;
    bt_l1_63 = bt_l1_63 + (5.555064035434043e-07)*bt_g0_61;
    bt_l1_63 = bt_l1_63 + (-3.9691116171525209e-07)*bt_g0_62;
    bt_l1_63 = bt_l1_63 + (0.0014182687737047672)*bt_g0_63;
    bt1_mean = (bt_l1_0 + bt_l1_1 + bt_l1_2 + bt_l1_3 + bt_l1_4 + bt_l1_5 + bt_l1_6 + bt_l1_7 + bt_l1_8 + bt_l1_9 + bt_l1_10 + bt_l1_11 + bt_l1_12 + bt_l1_13 + bt_l1_14 + bt_l1_15 + bt_l1_16 + bt_l1_17 + bt_l1_18 + bt_l1_19 + bt_l1_20 + bt_l1_21 + bt_l1_22 + bt_l1_23 + bt_l1_24 + bt_l1_25 + bt_l1_26 + bt_l1_27 + bt_l1_28 + bt_l1_29 + bt_l1_30 + bt_l1_31 + bt_l1_32 + bt_l1_33 + bt_l1_34 + bt_l1_35 + bt_l1_36 + bt_l1_37 + bt_l1_38 + bt_l1_39 + bt_l1_40 + bt_l1_41 + bt_l1_42 + bt_l1_43 + bt_l1_44 + bt_l1_45 + bt_l1_46 + bt_l1_47 + bt_l1_48 + bt_l1_49 + bt_l1_50 + bt_l1_51 + bt_l1_52 + bt_l1_53 + bt_l1_54 + bt_l1_55 + bt_l1_56 + bt_l1_57 + bt_l1_58 + bt_l1_59 + bt_l1_60 + bt_l1_61 + bt_l1_62 + bt_l1_63) / 64;
    bt1_var = (((bt_l1_0) - bt1_mean)*((bt_l1_0) - bt1_mean) + ((bt_l1_1) - bt1_mean)*((bt_l1_1) - bt1_mean) + ((bt_l1_2) - bt1_mean)*((bt_l1_2) - bt1_mean) + ((bt_l1_3) - bt1_mean)*((bt_l1_3) - bt1_mean) + ((bt_l1_4) - bt1_mean)*((bt_l1_4) - bt1_mean) + ((bt_l1_5) - bt1_mean)*((bt_l1_5) - bt1_mean) + ((bt_l1_6) - bt1_mean)*((bt_l1_6) - bt1_mean) + ((bt_l1_7) - bt1_mean)*((bt_l1_7) - bt1_mean) + ((bt_l1_8) - bt1_mean)*((bt_l1_8) - bt1_mean) + ((bt_l1_9) - bt1_mean)*((bt_l1_9) - bt1_mean) + ((bt_l1_10) - bt1_mean)*((bt_l1_10) - bt1_mean) + ((bt_l1_11) - bt1_mean)*((bt_l1_11) - bt1_mean) + ((bt_l1_12) - bt1_mean)*((bt_l1_12) - bt1_mean) + ((bt_l1_13) - bt1_mean)*((bt_l1_13) - bt1_mean) + ((bt_l1_14) - bt1_mean)*((bt_l1_14) - bt1_mean) + ((bt_l1_15) - bt1_mean)*((bt_l1_15) - bt1_mean) + ((bt_l1_16) - bt1_mean)*((bt_l1_16) - bt1_mean) + ((bt_l1_17) - bt1_mean)*((bt_l1_17) - bt1_mean) + ((bt_l1_18) - bt1_mean)*((bt_l1_18) - bt1_mean) + ((bt_l1_19) - bt1_mean)*((bt_l1_19) - bt1_mean) + ((bt_l1_20) - bt1_mean)*((bt_l1_20) - bt1_mean) + ((bt_l1_21) - bt1_mean)*((bt_l1_21) - bt1_mean) + ((bt_l1_22) - bt1_mean)*((bt_l1_22) - bt1_mean) + ((bt_l1_23) - bt1_mean)*((bt_l1_23) - bt1_mean) + ((bt_l1_24) - bt1_mean)*((bt_l1_24) - bt1_mean) + ((bt_l1_25) - bt1_mean)*((bt_l1_25) - bt1_mean) + ((bt_l1_26) - bt1_mean)*((bt_l1_26) - bt1_mean) + ((bt_l1_27) - bt1_mean)*((bt_l1_27) - bt1_mean) + ((bt_l1_28) - bt1_mean)*((bt_l1_28) - bt1_mean) + ((bt_l1_29) - bt1_mean)*((bt_l1_29) - bt1_mean) + ((bt_l1_30) - bt1_mean)*((bt_l1_30) - bt1_mean) + ((bt_l1_31) - bt1_mean)*((bt_l1_31) - bt1_mean) + ((bt_l1_32) - bt1_mean)*((bt_l1_32) - bt1_mean) + ((bt_l1_33) - bt1_mean)*((bt_l1_33) - bt1_mean) + ((bt_l1_34) - bt1_mean)*((bt_l1_34) - bt1_mean) + ((bt_l1_35) - bt1_mean)*((bt_l1_35) - bt1_mean) + ((bt_l1_36) - bt1_mean)*((bt_l1_36) - bt1_mean) + ((bt_l1_37) - bt1_mean)*((bt_l1_37) - bt1_mean) + ((bt_l1_38) - bt1_mean)*((bt_l1_38) - bt1_mean) + ((bt_l1_39) - bt1_mean)*((bt_l1_39) - bt1_mean) + ((bt_l1_40) - bt1_mean)*((bt_l1_40) - bt1_mean) + ((bt_l1_41) - bt1_mean)*((bt_l1_41) - bt1_mean) + ((bt_l1_42) - bt1_mean)*((bt_l1_42) - bt1_mean) + ((bt_l1_43) - bt1_mean)*((bt_l1_43) - bt1_mean) + ((bt_l1_44) - bt1_mean)*((bt_l1_44) - bt1_mean) + ((bt_l1_45) - bt1_mean)*((bt_l1_45) - bt1_mean) + ((bt_l1_46) - bt1_mean)*((bt_l1_46) - bt1_mean) + ((bt_l1_47) - bt1_mean)*((bt_l1_47) - bt1_mean) + ((bt_l1_48) - bt1_mean)*((bt_l1_48) - bt1_mean) + ((bt_l1_49) - bt1_mean)*((bt_l1_49) - bt1_mean) + ((bt_l1_50) - bt1_mean)*((bt_l1_50) - bt1_mean) + ((bt_l1_51) - bt1_mean)*((bt_l1_51) - bt1_mean) + ((bt_l1_52) - bt1_mean)*((bt_l1_52) - bt1_mean) + ((bt_l1_53) - bt1_mean)*((bt_l1_53) - bt1_mean) + ((bt_l1_54) - bt1_mean)*((bt_l1_54) - bt1_mean) + ((bt_l1_55) - bt1_mean)*((bt_l1_55) - bt1_mean) + ((bt_l1_56) - bt1_mean)*((bt_l1_56) - bt1_mean) + ((bt_l1_57) - bt1_mean)*((bt_l1_57) - bt1_mean) + ((bt_l1_58) - bt1_mean)*((bt_l1_58) - bt1_mean) + ((bt_l1_59) - bt1_mean)*((bt_l1_59) - bt1_mean) + ((bt_l1_60) - bt1_mean)*((bt_l1_60) - bt1_mean) + ((bt_l1_61) - bt1_mean)*((bt_l1_61) - bt1_mean) + ((bt_l1_62) - bt1_mean)*((bt_l1_62) - bt1_mean) + ((bt_l1_63) - bt1_mean)*((bt_l1_63) - bt1_mean)) / 64;
    bt_n1_0 = (((bt_l1_0) - bt1_mean) / sqrt(bt1_var + ln_eps)) * (0.43833088874816895) + (0.062989331781864166);
    bt_n1_1 = (((bt_l1_1) - bt1_mean) / sqrt(bt1_var + ln_eps)) * (-2.722721319514676e-06) + (2.3134803086577449e-06);
    bt_n1_2 = (((bt_l1_2) - bt1_mean) / sqrt(bt1_var + ln_eps)) * (-4.1868519474519417e-05) + (-6.8071843998041004e-05);
    bt_n1_3 = (((bt_l1_3) - bt1_mean) / sqrt(bt1_var + ln_eps)) * (1.2694630413534469e-06) + (-9.9462624802981736e-07);
    bt_n1_4 = (((bt_l1_4) - bt1_mean) / sqrt(bt1_var + ln_eps)) * (-2.559881693287025e-07) + (1.8884149710629572e-07);
    bt_n1_5 = (((bt_l1_5) - bt1_mean) / sqrt(bt1_var + ln_eps)) * (5.8390991597434549e-08) + (-2.87898274109466e-08);
    bt_n1_6 = (((bt_l1_6) - bt1_mean) / sqrt(bt1_var + ln_eps)) * (-1.1856399195764311e-10) + (-2.4945729076158996e-12);
    bt_n1_7 = (((bt_l1_7) - bt1_mean) / sqrt(bt1_var + ln_eps)) * (3.8199577829800546e-05) + (2.0869203581241891e-05);
    bt_n1_8 = (((bt_l1_8) - bt1_mean) / sqrt(bt1_var + ln_eps)) * (-5.9090030646302694e-08) + (-3.0094739145170024e-08);
    bt_n1_9 = (((bt_l1_9) - bt1_mean) / sqrt(bt1_var + ln_eps)) * (8.6581621872028336e-07) + (-9.1272596591807087e-07);
    bt_n1_10 = (((bt_l1_10) - bt1_mean) / sqrt(bt1_var + ln_eps)) * (0.47746774554252625) + (0.01582329161465168);
    bt_n1_11 = (((bt_l1_11) - bt1_mean) / sqrt(bt1_var + ln_eps)) * (4.3637740532176394e-08) + (-2.5301224226836894e-08);
    bt_n1_12 = (((bt_l1_12) - bt1_mean) / sqrt(bt1_var + ln_eps)) * (-8.0862278650783992e-08) + (3.2434552821314355e-08);
    bt_n1_13 = (((bt_l1_13) - bt1_mean) / sqrt(bt1_var + ln_eps)) * (-4.2455110815353692e-05) + (-6.4856954850256443e-05);
    bt_n1_14 = (((bt_l1_14) - bt1_mean) / sqrt(bt1_var + ln_eps)) * (-3.5764976928476244e-05) + (4.6395193749049213e-06);
    bt_n1_15 = (((bt_l1_15) - bt1_mean) / sqrt(bt1_var + ln_eps)) * (4.8545888375883806e-07) + (5.0901462600450031e-07);
    bt_n1_16 = (((bt_l1_16) - bt1_mean) / sqrt(bt1_var + ln_eps)) * (-3.177935923304176e-07) + (-5.9099403415530105e-07);
    bt_n1_17 = (((bt_l1_17) - bt1_mean) / sqrt(bt1_var + ln_eps)) * (5.6398812375846319e-06) + (-4.9305845095659606e-07);
    bt_n1_18 = (((bt_l1_18) - bt1_mean) / sqrt(bt1_var + ln_eps)) * (0.26239114999771118) + (-0.017119703814387321);
    bt_n1_19 = (((bt_l1_19) - bt1_mean) / sqrt(bt1_var + ln_eps)) * (3.9158391018645489e-07) + (6.038474111846881e-07);
    bt_n1_20 = (((bt_l1_20) - bt1_mean) / sqrt(bt1_var + ln_eps)) * (4.9215344688491314e-07) + (-3.2452535947413708e-07);
    bt_n1_21 = (((bt_l1_21) - bt1_mean) / sqrt(bt1_var + ln_eps)) * (-7.4790918347389379e-08) + (4.7267421088292849e-09);
    bt_n1_22 = (((bt_l1_22) - bt1_mean) / sqrt(bt1_var + ln_eps)) * (-9.5736048422168096e-08) + (3.2993092702326976e-08);
    bt_n1_23 = (((bt_l1_23) - bt1_mean) / sqrt(bt1_var + ln_eps)) * (-1.0975639064270126e-08) + (9.3442071857907649e-09);
    bt_n1_24 = (((bt_l1_24) - bt1_mean) / sqrt(bt1_var + ln_eps)) * (0.420562744140625) + (0.021477127447724342);
    bt_n1_25 = (((bt_l1_25) - bt1_mean) / sqrt(bt1_var + ln_eps)) * (-9.4899473879195284e-07) + (-9.2335005774657475e-07);
    bt_n1_26 = (((bt_l1_26) - bt1_mean) / sqrt(bt1_var + ln_eps)) * (-2.2410556994145736e-05) + (2.466132355039008e-05);
    bt_n1_27 = (((bt_l1_27) - bt1_mean) / sqrt(bt1_var + ln_eps)) * (2.0172021777398186e-06) + (5.4477635558214388e-07);
    bt_n1_28 = (((bt_l1_28) - bt1_mean) / sqrt(bt1_var + ln_eps)) * (0.45080873370170593) + (0.10499045997858047);
    bt_n1_29 = (((bt_l1_29) - bt1_mean) / sqrt(bt1_var + ln_eps)) * (-8.67826827288809e-07) + (4.5943332338538312e-07);
    bt_n1_30 = (((bt_l1_30) - bt1_mean) / sqrt(bt1_var + ln_eps)) * (3.1269684086510097e-07) + (5.135791525390232e-07);
    bt_n1_31 = (((bt_l1_31) - bt1_mean) / sqrt(bt1_var + ln_eps)) * (3.1729856520001931e-09) + (-2.1029883612300182e-08);
    bt_n1_32 = (((bt_l1_32) - bt1_mean) / sqrt(bt1_var + ln_eps)) * (-4.3307954911142588e-07) + (4.0696062342249206e-07);
    bt_n1_33 = (((bt_l1_33) - bt1_mean) / sqrt(bt1_var + ln_eps)) * (-5.2194030786267831e-07) + (-8.1884894598260871e-07);
    bt_n1_34 = (((bt_l1_34) - bt1_mean) / sqrt(bt1_var + ln_eps)) * (1.1076440387114417e-07) + (7.770150745045612e-08);
    bt_n1_35 = (((bt_l1_35) - bt1_mean) / sqrt(bt1_var + ln_eps)) * (1.3520071888706298e-06) + (5.5878551563637302e-08);
    bt_n1_36 = (((bt_l1_36) - bt1_mean) / sqrt(bt1_var + ln_eps)) * (-9.1842257461394183e-06) + (5.4715542319172528e-06);
    bt_n1_37 = (((bt_l1_37) - bt1_mean) / sqrt(bt1_var + ln_eps)) * (-1.0083599022436829e-07) + (-1.6135996361299476e-07);
    bt_n1_38 = (((bt_l1_38) - bt1_mean) / sqrt(bt1_var + ln_eps)) * (0.4449104368686676) + (0.086646847426891327);
    bt_n1_39 = (((bt_l1_39) - bt1_mean) / sqrt(bt1_var + ln_eps)) * (7.3044930104515515e-08) + (2.0427252778176808e-08);
    bt_n1_40 = (((bt_l1_40) - bt1_mean) / sqrt(bt1_var + ln_eps)) * (8.4509466091731156e-08) + (8.161820375107709e-08);
    bt_n1_41 = (((bt_l1_41) - bt1_mean) / sqrt(bt1_var + ln_eps)) * (8.7013927441148553e-07) + (-4.7944399739208166e-07);
    bt_n1_42 = (((bt_l1_42) - bt1_mean) / sqrt(bt1_var + ln_eps)) * (8.1409916674601845e-06) + (1.6334560370978579e-07);
    bt_n1_43 = (((bt_l1_43) - bt1_mean) / sqrt(bt1_var + ln_eps)) * (-7.8881123855012447e-09) + (-4.2693097945800673e-09);
    bt_n1_44 = (((bt_l1_44) - bt1_mean) / sqrt(bt1_var + ln_eps)) * (2.2245357556016643e-08) + (-1.0767061908723008e-08);
    bt_n1_45 = (((bt_l1_45) - bt1_mean) / sqrt(bt1_var + ln_eps)) * (0.33717283606529236) + (0.012797089293599129);
    bt_n1_46 = (((bt_l1_46) - bt1_mean) / sqrt(bt1_var + ln_eps)) * (-2.9074288931951742e-07) + (-6.4092311902186339e-08);
    bt_n1_47 = (((bt_l1_47) - bt1_mean) / sqrt(bt1_var + ln_eps)) * (6.630615700942144e-08) + (-1.0392467997277777e-09);
    bt_n1_48 = (((bt_l1_48) - bt1_mean) / sqrt(bt1_var + ln_eps)) * (-5.0375462024021544e-08) + (-7.7133627485181933e-08);
    bt_n1_49 = (((bt_l1_49) - bt1_mean) / sqrt(bt1_var + ln_eps)) * (-5.9484411840671214e-10) + (6.3609249423279834e-08);
    bt_n1_50 = (((bt_l1_50) - bt1_mean) / sqrt(bt1_var + ln_eps)) * (3.7627927440553322e-07) + (-2.0040984338720591e-07);
    bt_n1_51 = (((bt_l1_51) - bt1_mean) / sqrt(bt1_var + ln_eps)) * (-7.5973460411660199e-08) + (2.2737292937335951e-08);
    bt_n1_52 = (((bt_l1_52) - bt1_mean) / sqrt(bt1_var + ln_eps)) * (4.9867588813867769e-07) + (-3.5749971516452206e-07);
    bt_n1_53 = (((bt_l1_53) - bt1_mean) / sqrt(bt1_var + ln_eps)) * (-1.8973199985339306e-05) + (1.3714777196582872e-05);
    bt_n1_54 = (((bt_l1_54) - bt1_mean) / sqrt(bt1_var + ln_eps)) * (-1.0356774510000832e-05) + (1.4202437341737095e-05);
    bt_n1_55 = (((bt_l1_55) - bt1_mean) / sqrt(bt1_var + ln_eps)) * (-1.117694182539708e-06) + (1.656661652305047e-07);
    bt_n1_56 = (((bt_l1_56) - bt1_mean) / sqrt(bt1_var + ln_eps)) * (0.44736999273300171) + (-0.0063701942563056946);
    bt_n1_57 = (((bt_l1_57) - bt1_mean) / sqrt(bt1_var + ln_eps)) * (-5.5080340644053649e-06) + (-1.9173203327227384e-06);
    bt_n1_58 = (((bt_l1_58) - bt1_mean) / sqrt(bt1_var + ln_eps)) * (1.9057546523981728e-05) + (7.148631993914023e-06);
    bt_n1_59 = (((bt_l1_59) - bt1_mean) / sqrt(bt1_var + ln_eps)) * (6.6057644687589345e-08) + (-1.2111684988269644e-08);
    bt_n1_60 = (((bt_l1_60) - bt1_mean) / sqrt(bt1_var + ln_eps)) * (0.41363182663917542) + (0.043201535940170288);
    bt_n1_61 = (((bt_l1_61) - bt1_mean) / sqrt(bt1_var + ln_eps)) * (-5.3310964176489506e-07) + (-5.5567593193472931e-08);
    bt_n1_62 = (((bt_l1_62) - bt1_mean) / sqrt(bt1_var + ln_eps)) * (-2.1492269297596067e-05) + (-1.4035993444849737e-05);
    bt_n1_63 = (((bt_l1_63) - bt1_mean) / sqrt(bt1_var + ln_eps)) * (-2.0950319594703615e-05) + (2.2736101527698338e-05);
    bt_g1_0 = gelu_approx(bt_n1_0);
    bt_g1_1 = gelu_approx(bt_n1_1);
    bt_g1_2 = gelu_approx(bt_n1_2);
    bt_g1_3 = gelu_approx(bt_n1_3);
    bt_g1_4 = gelu_approx(bt_n1_4);
    bt_g1_5 = gelu_approx(bt_n1_5);
    bt_g1_6 = gelu_approx(bt_n1_6);
    bt_g1_7 = gelu_approx(bt_n1_7);
    bt_g1_8 = gelu_approx(bt_n1_8);
    bt_g1_9 = gelu_approx(bt_n1_9);
    bt_g1_10 = gelu_approx(bt_n1_10);
    bt_g1_11 = gelu_approx(bt_n1_11);
    bt_g1_12 = gelu_approx(bt_n1_12);
    bt_g1_13 = gelu_approx(bt_n1_13);
    bt_g1_14 = gelu_approx(bt_n1_14);
    bt_g1_15 = gelu_approx(bt_n1_15);
    bt_g1_16 = gelu_approx(bt_n1_16);
    bt_g1_17 = gelu_approx(bt_n1_17);
    bt_g1_18 = gelu_approx(bt_n1_18);
    bt_g1_19 = gelu_approx(bt_n1_19);
    bt_g1_20 = gelu_approx(bt_n1_20);
    bt_g1_21 = gelu_approx(bt_n1_21);
    bt_g1_22 = gelu_approx(bt_n1_22);
    bt_g1_23 = gelu_approx(bt_n1_23);
    bt_g1_24 = gelu_approx(bt_n1_24);
    bt_g1_25 = gelu_approx(bt_n1_25);
    bt_g1_26 = gelu_approx(bt_n1_26);
    bt_g1_27 = gelu_approx(bt_n1_27);
    bt_g1_28 = gelu_approx(bt_n1_28);
    bt_g1_29 = gelu_approx(bt_n1_29);
    bt_g1_30 = gelu_approx(bt_n1_30);
    bt_g1_31 = gelu_approx(bt_n1_31);
    bt_g1_32 = gelu_approx(bt_n1_32);
    bt_g1_33 = gelu_approx(bt_n1_33);
    bt_g1_34 = gelu_approx(bt_n1_34);
    bt_g1_35 = gelu_approx(bt_n1_35);
    bt_g1_36 = gelu_approx(bt_n1_36);
    bt_g1_37 = gelu_approx(bt_n1_37);
    bt_g1_38 = gelu_approx(bt_n1_38);
    bt_g1_39 = gelu_approx(bt_n1_39);
    bt_g1_40 = gelu_approx(bt_n1_40);
    bt_g1_41 = gelu_approx(bt_n1_41);
    bt_g1_42 = gelu_approx(bt_n1_42);
    bt_g1_43 = gelu_approx(bt_n1_43);
    bt_g1_44 = gelu_approx(bt_n1_44);
    bt_g1_45 = gelu_approx(bt_n1_45);
    bt_g1_46 = gelu_approx(bt_n1_46);
    bt_g1_47 = gelu_approx(bt_n1_47);
    bt_g1_48 = gelu_approx(bt_n1_48);
    bt_g1_49 = gelu_approx(bt_n1_49);
    bt_g1_50 = gelu_approx(bt_n1_50);
    bt_g1_51 = gelu_approx(bt_n1_51);
    bt_g1_52 = gelu_approx(bt_n1_52);
    bt_g1_53 = gelu_approx(bt_n1_53);
    bt_g1_54 = gelu_approx(bt_n1_54);
    bt_g1_55 = gelu_approx(bt_n1_55);
    bt_g1_56 = gelu_approx(bt_n1_56);
    bt_g1_57 = gelu_approx(bt_n1_57);
    bt_g1_58 = gelu_approx(bt_n1_58);
    bt_g1_59 = gelu_approx(bt_n1_59);
    bt_g1_60 = gelu_approx(bt_n1_60);
    bt_g1_61 = gelu_approx(bt_n1_61);
    bt_g1_62 = gelu_approx(bt_n1_62);
    bt_g1_63 = gelu_approx(bt_n1_63);
    hv_0 = 0.018489383161067963;
    hv_0 = hv_0 + (-0.083132363855838776)*bt_g1_0;
    hv_0 = hv_0 + (-2.2792314666730817e-06)*bt_g1_1;
    hv_0 = hv_0 + (-5.8966663345927373e-05)*bt_g1_2;
    hv_0 = hv_0 + (1.0630344604578568e-06)*bt_g1_3;
    hv_0 = hv_0 + (-1.9743730206300825e-07)*bt_g1_4;
    hv_0 = hv_0 + (3.8919210965104867e-08)*bt_g1_5;
    hv_0 = hv_0 + (-9.2039383059461244e-11)*bt_g1_6;
    hv_0 = hv_0 + (4.7348577936645597e-05)*bt_g1_7;
    hv_0 = hv_0 + (4.9812939550974988e-08)*bt_g1_8;
    hv_0 = hv_0 + (8.4129675315125496e-07)*bt_g1_9;
    hv_0 = hv_0 + (-0.094812870025634766)*bt_g1_10;
    hv_0 = hv_0 + (3.0067329959138078e-08)*bt_g1_11;
    hv_0 = hv_0 + (1.6685854475895212e-08)*bt_g1_12;
    hv_0 = hv_0 + (-5.7839384680846706e-05)*bt_g1_13;
    hv_0 = hv_0 + (-4.7940266085788608e-05)*bt_g1_14;
    hv_0 = hv_0 + (-4.2927382537527592e-07)*bt_g1_15;
    hv_0 = hv_0 + (2.7784383860307571e-07)*bt_g1_16;
    hv_0 = hv_0 + (4.9273580771114212e-06)*bt_g1_17;
    hv_0 = hv_0 + (-0.025400865823030472)*bt_g1_18;
    hv_0 = hv_0 + (-4.6069558834460622e-07)*bt_g1_19;
    hv_0 = hv_0 + (3.7522963225455896e-07)*bt_g1_20;
    hv_0 = hv_0 + (3.1973211633840037e-08)*bt_g1_21;
    hv_0 = hv_0 + (-6.7598769248888857e-08)*bt_g1_22;
    hv_0 = hv_0 + (-1.24395134193378e-08)*bt_g1_23;
    hv_0 = hv_0 + (-0.1045992374420166)*bt_g1_24;
    hv_0 = hv_0 + (-7.1243931643039105e-07)*bt_g1_25;
    hv_0 = hv_0 + (-2.5730789275257848e-05)*bt_g1_26;
    hv_0 = hv_0 + (1.8445057321514469e-06)*bt_g1_27;
    hv_0 = hv_0 + (-0.080593116581439972)*bt_g1_28;
    hv_0 = hv_0 + (-1.3443659554468468e-06)*bt_g1_29;
    hv_0 = hv_0 + (-3.0392507710530481e-07)*bt_g1_30;
    hv_0 = hv_0 + (3.694265160447685e-08)*bt_g1_31;
    hv_0 = hv_0 + (-3.8595464957325021e-07)*bt_g1_32;
    hv_0 = hv_0 + (8.7754295918784919e-07)*bt_g1_33;
    hv_0 = hv_0 + (4.88532130304975e-08)*bt_g1_34;
    hv_0 = hv_0 + (1.0244392569802585e-06)*bt_g1_35;
    hv_0 = hv_0 + (-7.3803762461466249e-06)*bt_g1_36;
    hv_0 = hv_0 + (-4.0592244232584562e-08)*bt_g1_37;
    hv_0 = hv_0 + (-0.068275310099124908)*bt_g1_38;
    hv_0 = hv_0 + (-3.6704278727484052e-08)*bt_g1_39;
    hv_0 = hv_0 + (8.594668088335311e-09)*bt_g1_40;
    hv_0 = hv_0 + (1.0803329359987401e-06)*bt_g1_41;
    hv_0 = hv_0 + (6.7968317125632893e-06)*bt_g1_42;
    hv_0 = hv_0 + (-1.4102071732580157e-09)*bt_g1_43;
    hv_0 = hv_0 + (1.3080382110786104e-08)*bt_g1_44;
    hv_0 = hv_0 + (0.054830428212881088)*bt_g1_45;
    hv_0 = hv_0 + (-2.2425570023187902e-07)*bt_g1_46;
    hv_0 = hv_0 + (-1.8757519981704718e-08)*bt_g1_47;
    hv_0 = hv_0 + (1.5866584490709101e-08)*bt_g1_48;
    hv_0 = hv_0 + (-4.0441658910594924e-08)*bt_g1_49;
    hv_0 = hv_0 + (2.6055428747895348e-07)*bt_g1_50;
    hv_0 = hv_0 + (-5.0380698723984096e-08)*bt_g1_51;
    hv_0 = hv_0 + (3.9150910424723406e-07)*bt_g1_52;
    hv_0 = hv_0 + (-1.7532707715872675e-05)*bt_g1_53;
    hv_0 = hv_0 + (-1.3889928595745005e-05)*bt_g1_54;
    hv_0 = hv_0 + (-7.4372974268044345e-07)*bt_g1_55;
    hv_0 = hv_0 + (-0.092550307512283325)*bt_g1_56;
    hv_0 = hv_0 + (-3.846731942758197e-06)*bt_g1_57;
    hv_0 = hv_0 + (1.2281086128496099e-05)*bt_g1_58;
    hv_0 = hv_0 + (-2.5577699958034827e-08)*bt_g1_59;
    hv_0 = hv_0 + (0.056866992264986038)*bt_g1_60;
    hv_0 = hv_0 + (-4.2548504097794648e-07)*bt_g1_61;
    hv_0 = hv_0 + (-1.4207326785253827e-05)*bt_g1_62;
    hv_0 = hv_0 + (-2.4021530407480896e-05)*bt_g1_63;
    hv_1 = -0.016522845253348351;
    hv_1 = hv_1 + (0.043983127921819687)*bt_g1_0;
    hv_1 = hv_1 + (-8.2865575734558661e-08)*bt_g1_1;
    hv_1 = hv_1 + (0.00010596391803119332)*bt_g1_2;
    hv_1 = hv_1 + (-9.8521098834680743e-08)*bt_g1_3;
    hv_1 = hv_1 + (5.9791140927245578e-08)*bt_g1_4;
    hv_1 = hv_1 + (-4.4326441184239229e-08)*bt_g1_5;
    hv_1 = hv_1 + (1.2909937008309669e-10)*bt_g1_6;
    hv_1 = hv_1 + (-5.5074957344913855e-05)*bt_g1_7;
    hv_1 = hv_1 + (7.8360848476677347e-08)*bt_g1_8;
    hv_1 = hv_1 + (5.946206442786206e-07)*bt_g1_9;
    hv_1 = hv_1 + (0.045657951384782791)*bt_g1_10;
    hv_1 = hv_1 + (-2.5370438194727285e-08)*bt_g1_11;
    hv_1 = hv_1 + (6.848414102478273e-08)*bt_g1_12;
    hv_1 = hv_1 + (0.0001003392826532945)*bt_g1_13;
    hv_1 = hv_1 + (2.0305778889451176e-05)*bt_g1_14;
    hv_1 = hv_1 + (-3.3580290619283915e-06)*bt_g1_15;
    hv_1 = hv_1 + (3.2000689316191711e-06)*bt_g1_16;
    hv_1 = hv_1 + (-8.9235945779364556e-06)*bt_g1_17;
    hv_1 = hv_1 + (-0.085755705833435059)*bt_g1_18;
    hv_1 = hv_1 + (-3.294124098829343e-06)*bt_g1_19;
    hv_1 = hv_1 + (1.0606490832287818e-06)*bt_g1_20;
    hv_1 = hv_1 + (3.3915256381078507e-08)*bt_g1_21;
    hv_1 = hv_1 + (1.006051064678104e-07)*bt_g1_22;
    hv_1 = hv_1 + (-1.6966076543667441e-08)*bt_g1_23;
    hv_1 = hv_1 + (-0.055832050740718842)*bt_g1_24;
    hv_1 = hv_1 + (-6.5184497088921489e-07)*bt_g1_25;
    hv_1 = hv_1 + (-1.8827833628165536e-05)*bt_g1_26;
    hv_1 = hv_1 + (-6.309560944828263e-07)*bt_g1_27;
    hv_1 = hv_1 + (0.047491185367107391)*bt_g1_28;
    hv_1 = hv_1 + (2.6412628812977346e-06)*bt_g1_29;
    hv_1 = hv_1 + (-3.0348653581313556e-06)*bt_g1_30;
    hv_1 = hv_1 + (4.242577134050407e-08)*bt_g1_31;
    hv_1 = hv_1 + (-1.2336083443642565e-07)*bt_g1_32;
    hv_1 = hv_1 + (3.7014017379988218e-06)*bt_g1_33;
    hv_1 = hv_1 + (-2.958963420951477e-07)*bt_g1_34;
    hv_1 = hv_1 + (-1.4417797729038284e-06)*bt_g1_35;
    hv_1 = hv_1 + (4.033535788039444e-06)*bt_g1_36;
    hv_1 = hv_1 + (2.2591216293221805e-06)*bt_g1_37;
    hv_1 = hv_1 + (0.081986777484416962)*bt_g1_38;
    hv_1 = hv_1 + (-5.8948177894535547e-08)*bt_g1_39;
    hv_1 = hv_1 + (-2.6312903855796321e-07)*bt_g1_40;
    hv_1 = hv_1 + (-1.5543486142632901e-06)*bt_g1_41;
    hv_1 = hv_1 + (-1.3338524695427623e-05)*bt_g1_42;
    hv_1 = hv_1 + (3.609142140703625e-08)*bt_g1_43;
    hv_1 = hv_1 + (-1.7746392799722344e-08)*bt_g1_44;
    hv_1 = hv_1 + (0.0074389195069670677)*bt_g1_45;
    hv_1 = hv_1 + (4.6432151634689944e-07)*bt_g1_46;
    hv_1 = hv_1 + (-1.9534269313226105e-08)*bt_g1_47;
    hv_1 = hv_1 + (2.091402251380714e-07)*bt_g1_48;
    hv_1 = hv_1 + (-1.381081204954171e-07)*bt_g1_49;
    hv_1 = hv_1 + (-2.4638265472276544e-07)*bt_g1_50;
    hv_1 = hv_1 + (9.409912138380605e-08)*bt_g1_51;
    hv_1 = hv_1 + (-1.3706865331641893e-07)*bt_g1_52;
    hv_1 = hv_1 + (2.2519946014654124e-06)*bt_g1_53;
    hv_1 = hv_1 + (-2.343042433494702e-05)*bt_g1_54;
    hv_1 = hv_1 + (4.4315104474890177e-08)*bt_g1_55;
    hv_1 = hv_1 + (0.22751244902610779)*bt_g1_56;
    hv_1 = hv_1 + (6.8736035245819949e-06)*bt_g1_57;
    hv_1 = hv_1 + (-3.5557164665078744e-05)*bt_g1_58;
    hv_1 = hv_1 + (-4.779219509032373e-08)*bt_g1_59;
    hv_1 = hv_1 + (0.13559214770793915)*bt_g1_60;
    hv_1 = hv_1 + (6.6222474970345502e-07)*bt_g1_61;
    hv_1 = hv_1 + (4.5202552428236231e-05)*bt_g1_62;
    hv_1 = hv_1 + (-1.5235333194141276e-05)*bt_g1_63;
    hv_2 = -4.7351900889225362e-07;
    hv_2 = hv_2 + (-1.2885376236226875e-05)*bt_g1_0;
    hv_2 = hv_2 + (-1.2119950876243735e-11)*bt_g1_1;
    hv_2 = hv_2 + (7.6450408503792033e-11)*bt_g1_2;
    hv_2 = hv_2 + (4.5540828053081128e-12)*bt_g1_3;
    hv_2 = hv_2 + (-7.4934980096030834e-13)*bt_g1_4;
    hv_2 = hv_2 + (-3.6191088645907976e-13)*bt_g1_5;
    hv_2 = hv_2 + (-2.2896401707115169e-15)*bt_g1_6;
    hv_2 = hv_2 + (-1.0386909388149235e-10)*bt_g1_7;
    hv_2 = hv_2 + (3.8681501578208266e-12)*bt_g1_8;
    hv_2 = hv_2 + (4.6015786667186198e-12)*bt_g1_9;
    hv_2 = hv_2 + (-2.1725241822423413e-05)*bt_g1_10;
    hv_2 = hv_2 + (-1.1348437651843152e-13)*bt_g1_11;
    hv_2 = hv_2 + (1.4814457169678996e-12)*bt_g1_12;
    hv_2 = hv_2 + (1.8259449507951331e-10)*bt_g1_13;
    hv_2 = hv_2 + (2.2506486258011549e-11)*bt_g1_14;
    hv_2 = hv_2 + (-1.9352555669094329e-10)*bt_g1_15;
    hv_2 = hv_2 + (1.8991955230696078e-10)*bt_g1_16;
    hv_2 = hv_2 + (-1.5505792483327951e-10)*bt_g1_17;
    hv_2 = hv_2 + (1.2403185110088089e-06)*bt_g1_18;
    hv_2 = hv_2 + (-1.9110985016723703e-10)*bt_g1_19;
    hv_2 = hv_2 + (6.7883004772895106e-11)*bt_g1_20;
    hv_2 = hv_2 + (5.9762877155714045e-14)*bt_g1_21;
    hv_2 = hv_2 + (1.5562351754483394e-12)*bt_g1_22;
    hv_2 = hv_2 + (-1.7003756258918146e-12)*bt_g1_23;
    hv_2 = hv_2 + (-2.4330158794327872e-06)*bt_g1_24;
    hv_2 = hv_2 + (-2.5427607242001216e-10)*bt_g1_25;
    hv_2 = hv_2 + (-1.0849003639901156e-10)*bt_g1_26;
    hv_2 = hv_2 + (2.2356337614493071e-10)*bt_g1_27;
    hv_2 = hv_2 + (-1.4665411981695797e-05)*bt_g1_28;
    hv_2 = hv_2 + (2.0372742381979947e-10)*bt_g1_29;
    hv_2 = hv_2 + (-1.9107895821157683e-10)*bt_g1_30;
    hv_2 = hv_2 + (3.7664927600433717e-12)*bt_g1_31;
    hv_2 = hv_2 + (-2.1688438805317345e-12)*bt_g1_32;
    hv_2 = hv_2 + (1.8160072057238352e-10)*bt_g1_33;
    hv_2 = hv_2 + (-7.2147357532692524e-12)*bt_g1_34;
    hv_2 = hv_2 + (4.30770558113025e-11)*bt_g1_35;
    hv_2 = hv_2 + (-1.334528668128776e-11)*bt_g1_36;
    hv_2 = hv_2 + (1.8972957926965961e-10)*bt_g1_37;
    hv_2 = hv_2 + (9.735038474900648e-06)*bt_g1_38;
    hv_2 = hv_2 + (-2.6183920483202616e-12)*bt_g1_39;
    hv_2 = hv_2 + (-7.96107624267961e-12)*bt_g1_40;
    hv_2 = hv_2 + (-9.5961918966658288e-11)*bt_g1_41;
    hv_2 = hv_2 + (-1.5333291580876818e-10)*bt_g1_42;
    hv_2 = hv_2 + (1.6607254850822817e-12)*bt_g1_43;
    hv_2 = hv_2 + (-1.604383401306031e-13)*bt_g1_44;
    hv_2 = hv_2 + (1.493167815169727e-06)*bt_g1_45;
    hv_2 = hv_2 + (6.3034044130161337e-12)*bt_g1_46;
    hv_2 = hv_2 + (6.9051963582852927e-13)*bt_g1_47;
    hv_2 = hv_2 + (6.8510852373193654e-12)*bt_g1_48;
    hv_2 = hv_2 + (-5.2542028887436754e-12)*bt_g1_49;
    hv_2 = hv_2 + (-1.5034101350994145e-12)*bt_g1_50;
    hv_2 = hv_2 + (1.594168698958176e-12)*bt_g1_51;
    hv_2 = hv_2 + (1.4818896977575324e-12)*bt_g1_52;
    hv_2 = hv_2 + (-6.9007549674537927e-11)*bt_g1_53;
    hv_2 = hv_2 + (-4.8519754186626685e-11)*bt_g1_54;
    hv_2 = hv_2 + (-1.061460849771656e-10)*bt_g1_55;
    hv_2 = hv_2 + (2.6096984584000893e-05)*bt_g1_56;
    hv_2 = hv_2 + (-2.4584001501182229e-10)*bt_g1_57;
    hv_2 = hv_2 + (-1.8899412590478448e-10)*bt_g1_58;
    hv_2 = hv_2 + (-5.2289547474923537e-13)*bt_g1_59;
    hv_2 = hv_2 + (1.1608178283495363e-05)*bt_g1_60;
    hv_2 = hv_2 + (1.2264432633531108e-13)*bt_g1_61;
    hv_2 = hv_2 + (1.6053147700034742e-10)*bt_g1_62;
    hv_2 = hv_2 + (-9.9071084669333231e-11)*bt_g1_63;
    hv_3 = 0.1264013797044754;
    hv_3 = hv_3 + (0.31782805919647217)*bt_g1_0;
    hv_3 = hv_3 + (1.8010084659181302e-06)*bt_g1_1;
    hv_3 = hv_3 + (2.7648922696243972e-05)*bt_g1_2;
    hv_3 = hv_3 + (-8.1478850688654347e-07)*bt_g1_3;
    hv_3 = hv_3 + (1.5567177058528614e-07)*bt_g1_4;
    hv_3 = hv_3 + (-3.0406710038732854e-08)*bt_g1_5;
    hv_3 = hv_3 + (6.3023267160566832e-11)*bt_g1_6;
    hv_3 = hv_3 + (-2.6659354261937551e-05)*bt_g1_7;
    hv_3 = hv_3 + (7.3591941429640428e-08)*bt_g1_8;
    hv_3 = hv_3 + (-6.7549552795753698e-07)*bt_g1_9;
    hv_3 = hv_3 + (-0.068248160183429718)*bt_g1_10;
    hv_3 = hv_3 + (-2.4184730662568654e-08)*bt_g1_11;
    hv_3 = hv_3 + (9.370777576123146e-08)*bt_g1_12;
    hv_3 = hv_3 + (2.8116042813053355e-05)*bt_g1_13;
    hv_3 = hv_3 + (2.7528125428943895e-05)*bt_g1_14;
    hv_3 = hv_3 + (-9.4779380788168055e-07)*bt_g1_15;
    hv_3 = hv_3 + (6.1249642158145434e-07)*bt_g1_16;
    hv_3 = hv_3 + (-2.7900621262233471e-06)*bt_g1_17;
    hv_3 = hv_3 + (-0.037640128284692764)*bt_g1_18;
    hv_3 = hv_3 + (-8.1245946148555959e-07)*bt_g1_19;
    hv_3 = hv_3 + (-4.7302077632593864e-07)*bt_g1_20;
    hv_3 = hv_3 + (8.7239094170854514e-08)*bt_g1_21;
    hv_3 = hv_3 + (4.3729517784640848e-08)*bt_g1_22;
    hv_3 = hv_3 + (1.2086722733783972e-08)*bt_g1_23;
    hv_3 = hv_3 + (0.035067733377218246)*bt_g1_24;
    hv_3 = hv_3 + (4.047593904488167e-07)*bt_g1_25;
    hv_3 = hv_3 + (1.8549249944044277e-05)*bt_g1_26;
    hv_3 = hv_3 + (-1.2169597312094993e-06)*bt_g1_27;
    hv_3 = hv_3 + (-0.15917673707008362)*bt_g1_28;
    hv_3 = hv_3 + (8.8739551529215532e-07)*bt_g1_29;
    hv_3 = hv_3 + (-6.6200783521708217e-07)*bt_g1_30;
    hv_3 = hv_3 + (5.8245972489601172e-09)*bt_g1_31;
    hv_3 = hv_3 + (3.0585090371459955e-07)*bt_g1_32;
    hv_3 = hv_3 + (1.044887540047057e-06)*bt_g1_33;
    hv_3 = hv_3 + (-6.5102760515856062e-08)*bt_g1_34;
    hv_3 = hv_3 + (-7.6048002028983319e-07)*bt_g1_35;
    hv_3 = hv_3 + (5.2690197662741411e-06)*bt_g1_36;
    hv_3 = hv_3 + (3.8864558860041143e-07)*bt_g1_37;
    hv_3 = hv_3 + (0.075885340571403503)*bt_g1_38;
    hv_3 = hv_3 + (-8.7415003235946642e-08)*bt_g1_39;
    hv_3 = hv_3 + (-5.43752491921623e-08)*bt_g1_40;
    hv_3 = hv_3 + (-3.3782092145884235e-07)*bt_g1_41;
    hv_3 = hv_3 + (-4.0796153371047694e-06)*bt_g1_42;
    hv_3 = hv_3 + (-2.5022888205938898e-09)*bt_g1_43;
    hv_3 = hv_3 + (-1.1458217485937894e-08)*bt_g1_44;
    hv_3 = hv_3 + (0.029779020696878433)*bt_g1_45;
    hv_3 = hv_3 + (1.8749456387467944e-07)*bt_g1_46;
    hv_3 = hv_3 + (-7.3543610312754026e-08)*bt_g1_47;
    hv_3 = hv_3 + (2.8372220128858316e-08)*bt_g1_48;
    hv_3 = hv_3 + (1.1756184470357312e-08)*bt_g1_49;
    hv_3 = hv_3 + (-2.0171162873339199e-07)*bt_g1_50;
    hv_3 = hv_3 + (3.3094096352215274e-08)*bt_g1_51;
    hv_3 = hv_3 + (-3.0145565688144416e-07)*bt_g1_52;
    hv_3 = hv_3 + (1.2776559742633253e-05)*bt_g1_53;
    hv_3 = hv_3 + (1.1367369552317541e-05)*bt_g1_54;
    hv_3 = hv_3 + (8.0342221053797402e-07)*bt_g1_55;
    hv_3 = hv_3 + (-0.1340736448764801)*bt_g1_56;
    hv_3 = hv_3 + (3.0057638014113763e-06)*bt_g1_57;
    hv_3 = hv_3 + (-9.4081087809172459e-06)*bt_g1_58;
    hv_3 = hv_3 + (-8.0599583895946125e-08)*bt_g1_59;
    hv_3 = hv_3 + (0.24195373058319092)*bt_g1_60;
    hv_3 = hv_3 + (3.5398412023823767e-07)*bt_g1_61;
    hv_3 = hv_3 + (1.1300837286398746e-05)*bt_g1_62;
    hv_3 = hv_3 + (1.745266854413785e-05)*bt_g1_63;
    hv_4 = -0.13688421249389648;
    hv_4 = hv_4 + (-0.067278258502483368)*bt_g1_0;
    hv_4 = hv_4 + (5.1818283282045741e-06)*bt_g1_1;
    hv_4 = hv_4 + (9.3951326562091708e-05)*bt_g1_2;
    hv_4 = hv_4 + (-2.3991597117856145e-06)*bt_g1_3;
    hv_4 = hv_4 + (4.6705926592949254e-07)*bt_g1_4;
    hv_4 = hv_4 + (-9.7289216682838742e-08)*bt_g1_5;
    hv_4 = hv_4 + (2.091848638752225e-10)*bt_g1_6;
    hv_4 = hv_4 + (-9.0661131253000349e-05)*bt_g1_7;
    hv_4 = hv_4 + (7.3624441654374095e-08)*bt_g1_8;
    hv_4 = hv_4 + (-1.792559146451822e-06)*bt_g1_9;
    hv_4 = hv_4 + (0.036738444119691849)*bt_g1_10;
    hv_4 = hv_4 + (-7.5920240760751767e-08)*bt_g1_11;
    hv_4 = hv_4 + (3.9603690993317286e-08)*bt_g1_12;
    hv_4 = hv_4 + (9.7602009191177785e-05)*bt_g1_13;
    hv_4 = hv_4 + (8.6131418356671929e-05)*bt_g1_14;
    hv_4 = hv_4 + (9.9122075880586635e-07)*bt_g1_15;
    hv_4 = hv_4 + (-1.2379204008539091e-06)*bt_g1_16;
    hv_4 = hv_4 + (-7.639055183972232e-06)*bt_g1_17;
    hv_4 = hv_4 + (-0.064241483807563782)*bt_g1_18;
    hv_4 = hv_4 + (1.0530618510529166e-06)*bt_g1_19;
    hv_4 = hv_4 + (-1.4024492429598467e-06)*bt_g1_20;
    hv_4 = hv_4 + (7.8865227237656654e-08)*bt_g1_21;
    hv_4 = hv_4 + (1.4359714839429216e-07)*bt_g1_22;
    hv_4 = hv_4 + (4.3209126943111187e-08)*bt_g1_23;
    hv_4 = hv_4 + (-0.065130420029163361)*bt_g1_24;
    hv_4 = hv_4 + (4.6634704631287605e-06)*bt_g1_25;
    hv_4 = hv_4 + (4.9525719077792019e-05)*bt_g1_26;
    hv_4 = hv_4 + (-6.0033935369574465e-06)*bt_g1_27;
    hv_4 = hv_4 + (-0.13801378011703491)*bt_g1_28;
    hv_4 = hv_4 + (-6.3361841284859111e-07)*bt_g1_29;
    hv_4 = hv_4 + (1.1689772918543895e-06)*bt_g1_30;
    hv_4 = hv_4 + (-1.1260018695224971e-08)*bt_g1_31;
    hv_4 = hv_4 + (8.531392268196214e-07)*bt_g1_32;
    hv_4 = hv_4 + (-8.0451178519069799e-07)*bt_g1_33;
    hv_4 = hv_4 + (-1.1699123092512309e-07)*bt_g1_34;
    hv_4 = hv_4 + (-2.6641150725481566e-06)*bt_g1_35;
    hv_4 = hv_4 + (1.631868326512631e-05)*bt_g1_36;
    hv_4 = hv_4 + (-1.5631195537935128e-06)*bt_g1_37;
    hv_4 = hv_4 + (-0.25590494275093079)*bt_g1_38;
    hv_4 = hv_4 + (-9.6718245856663998e-08)*bt_g1_39;
    hv_4 = hv_4 + (-8.1962866715912241e-08)*bt_g1_40;
    hv_4 = hv_4 + (-2.5673116965663212e-07)*bt_g1_41;
    hv_4 = hv_4 + (-1.1721011105692014e-05)*bt_g1_42;
    hv_4 = hv_4 + (-1.0994307686473803e-08)*bt_g1_43;
    hv_4 = hv_4 + (-3.7152826593001009e-08)*bt_g1_44;
    hv_4 = hv_4 + (0.12660697102546692)*bt_g1_45;
    hv_4 = hv_4 + (4.1995895116997417e-07)*bt_g1_46;
    hv_4 = hv_4 + (-9.0198817304099066e-08)*bt_g1_47;
    hv_4 = hv_4 + (3.5426193534249251e-08)*bt_g1_48;
    hv_4 = hv_4 + (3.7707881261894727e-08)*bt_g1_49;
    hv_4 = hv_4 + (-6.4464342131032026e-07)*bt_g1_50;
    hv_4 = hv_4 + (1.0672602712702428e-07)*bt_g1_51;
    hv_4 = hv_4 + (-9.0765024651773274e-07)*bt_g1_52;
    hv_4 = hv_4 + (3.7999823689460754e-05)*bt_g1_53;
    hv_4 = hv_4 + (2.6637213522917591e-05)*bt_g1_54;
    hv_4 = hv_4 + (3.342826857988257e-06)*bt_g1_55;
    hv_4 = hv_4 + (0.10825289785861969)*bt_g1_56;
    hv_4 = hv_4 + (1.2152184353908524e-05)*bt_g1_57;
    hv_4 = hv_4 + (-3.134640064672567e-05)*bt_g1_58;
    hv_4 = hv_4 + (-5.0526612227486112e-08)*bt_g1_59;
    hv_4 = hv_4 + (-0.012600716203451157)*bt_g1_60;
    hv_4 = hv_4 + (8.6214907923931605e-07)*bt_g1_61;
    hv_4 = hv_4 + (3.7353631341829896e-05)*bt_g1_62;
    hv_4 = hv_4 + (4.7061115765245631e-05)*bt_g1_63;
    hv_5 = -0.086101740598678589;
    hv_5 = hv_5 + (-0.1154574453830719)*bt_g1_0;
    hv_5 = hv_5 + (-4.9015397962648422e-06)*bt_g1_1;
    hv_5 = hv_5 + (-0.00012856778630521148)*bt_g1_2;
    hv_5 = hv_5 + (2.3336754111369373e-06)*bt_g1_3;
    hv_5 = hv_5 + (-4.4579576297110179e-07)*bt_g1_4;
    hv_5 = hv_5 + (1.0546785489395916e-07)*bt_g1_5;
    hv_5 = hv_5 + (-2.2276343270011267e-10)*bt_g1_6;
    hv_5 = hv_5 + (0.00011063488636864349)*bt_g1_7;
    hv_5 = hv_5 + (8.6256486397928711e-09)*bt_g1_8;
    hv_5 = hv_5 + (1.5381067441921914e-06)*bt_g1_9;
    hv_5 = hv_5 + (-0.048514425754547119)*bt_g1_10;
    hv_5 = hv_5 + (7.8225710353763134e-08)*bt_g1_11;
    hv_5 = hv_5 + (9.7970165313654434e-08)*bt_g1_12;
    hv_5 = hv_5 + (-0.00012877557310275733)*bt_g1_13;
    hv_5 = hv_5 + (-0.00010519119678065181)*bt_g1_14;
    hv_5 = hv_5 + (2.9606080715893768e-06)*bt_g1_15;
    hv_5 = hv_5 + (-2.3970796974026598e-06)*bt_g1_16;
    hv_5 = hv_5 + (1.4337248103402089e-05)*bt_g1_17;
    hv_5 = hv_5 + (0.030243460088968277)*bt_g1_18;
    hv_5 = hv_5 + (2.4140167624864262e-06)*bt_g1_19;
    hv_5 = hv_5 + (-3.0493319513880124e-07)*bt_g1_20;
    hv_5 = hv_5 + (5.9498841409322267e-08)*bt_g1_21;
    hv_5 = hv_5 + (-1.8899388010140683e-07)*bt_g1_22;
    hv_5 = hv_5 + (-1.3123592879082935e-08)*bt_g1_23;
    hv_5 = hv_5 + (-0.092776723206043243)*bt_g1_24;
    hv_5 = hv_5 + (1.9546655494195875e-06)*bt_g1_25;
    hv_5 = hv_5 + (-4.57158857898321e-05)*bt_g1_26;
    hv_5 = hv_5 + (2.541364438002347e-06)*bt_g1_27;
    hv_5 = hv_5 + (-0.19595123827457428)*bt_g1_28;
    hv_5 = hv_5 + (-6.0990714700892568e-06)*bt_g1_29;
    hv_5 = hv_5 + (2.310732270416338e-06)*bt_g1_30;
    hv_5 = hv_5 + (1.0096073310705833e-08)*bt_g1_31;
    hv_5 = hv_5 + (-7.7691964861514862e-07)*bt_g1_32;
    hv_5 = hv_5 + (-2.0004029011033708e-06)*bt_g1_33;
    hv_5 = hv_5 + (2.2192416793131997e-07)*bt_g1_34;
    hv_5 = hv_5 + (2.6012767193606123e-06)*bt_g1_35;
    hv_5 = hv_5 + (-1.6977763152681291e-05)*bt_g1_36;
    hv_5 = hv_5 + (-2.2454282770922873e-06)*bt_g1_37;
    hv_5 = hv_5 + (-0.028340514749288559)*bt_g1_38;
    hv_5 = hv_5 + (-1.8708526283717219e-08)*bt_g1_39;
    hv_5 = hv_5 + (1.44560686976547e-07)*bt_g1_40;
    hv_5 = hv_5 + (3.0402995889744489e-06)*bt_g1_41;
    hv_5 = hv_5 + (2.0006038539577276e-05)*bt_g1_42;
    hv_5 = hv_5 + (-2.3640218671516777e-08)*bt_g1_43;
    hv_5 = hv_5 + (3.851674890142931e-08)*bt_g1_44;
    hv_5 = hv_5 + (0.15493825078010559)*bt_g1_45;
    hv_5 = hv_5 + (-6.8808463993264013e-07)*bt_g1_46;
    hv_5 = hv_5 + (-8.0848963079915848e-09)*bt_g1_47;
    hv_5 = hv_5 + (-4.8090289084257165e-08)*bt_g1_48;
    hv_5 = hv_5 + (-4.9783047018081561e-08)*bt_g1_49;
    hv_5 = hv_5 + (6.6993089831157704e-07)*bt_g1_50;
    hv_5 = hv_5 + (-1.5131794839362556e-07)*bt_g1_51;
    hv_5 = hv_5 + (8.9078565679301391e-07)*bt_g1_52;
    hv_5 = hv_5 + (-3.8014186429791152e-05)*bt_g1_53;
    hv_5 = hv_5 + (-1.7255091734114103e-05)*bt_g1_54;
    hv_5 = hv_5 + (-1.1270188906564726e-06)*bt_g1_55;
    hv_5 = hv_5 + (0.086881265044212341)*bt_g1_56;
    hv_5 = hv_5 + (-8.690050890436396e-06)*bt_g1_57;
    hv_5 = hv_5 + (4.0619146602693945e-05)*bt_g1_58;
    hv_5 = hv_5 + (-6.3154999452308402e-08)*bt_g1_59;
    hv_5 = hv_5 + (-0.012912524864077568)*bt_g1_60;
    hv_5 = hv_5 + (-1.2091381904610898e-06)*bt_g1_61;
    hv_5 = hv_5 + (-4.6472152462229133e-05)*bt_g1_62;
    hv_5 = hv_5 + (-4.4300169975031167e-05)*bt_g1_63;
    hv_6 = 0.0062721762806177139;
    hv_6 = hv_6 + (0.045914832502603531)*bt_g1_0;
    hv_6 = hv_6 + (-4.2780634430528153e-06)*bt_g1_1;
    hv_6 = hv_6 + (-6.720900273649022e-05)*bt_g1_2;
    hv_6 = hv_6 + (1.9449430510576349e-06)*bt_g1_3;
    hv_6 = hv_6 + (-3.8064746377131087e-07)*bt_g1_4;
    hv_6 = hv_6 + (7.7268140330488677e-08)*bt_g1_5;
    hv_6 = hv_6 + (-1.5241258255471735e-10)*bt_g1_6;
    hv_6 = hv_6 + (7.0650465204380453e-05)*bt_g1_7;
    hv_6 = hv_6 + (6.2537260703265929e-08)*bt_g1_8;
    hv_6 = hv_6 + (1.4399363408301724e-06)*bt_g1_9;
    hv_6 = hv_6 + (-0.10112057626247406)*bt_g1_10;
    hv_6 = hv_6 + (6.0320843431327376e-08)*bt_g1_11;
    hv_6 = hv_6 + (1.4158567296362889e-07)*bt_g1_12;
    hv_6 = hv_6 + (-7.1377202402800322e-05)*bt_g1_13;
    hv_6 = hv_6 + (-7.3697003244888037e-05)*bt_g1_14;
    hv_6 = hv_6 + (-6.2757845853411709e-07)*bt_g1_15;
    hv_6 = hv_6 + (6.0114632560726022e-07)*bt_g1_16;
    hv_6 = hv_6 + (6.5816288952191826e-06)*bt_g1_17;
    hv_6 = hv_6 + (-0.051991034299135208)*bt_g1_18;
    hv_6 = hv_6 + (-7.5069942795380484e-07)*bt_g1_19;
    hv_6 = hv_6 + (2.3246676050803217e-07)*bt_g1_20;
    hv_6 = hv_6 + (1.0630296287672536e-07)*bt_g1_21;
    hv_6 = hv_6 + (-1.147020043390512e-07)*bt_g1_22;
    hv_6 = hv_6 + (-2.8611099267550344e-08)*bt_g1_23;
    hv_6 = hv_6 + (-0.14733433723449707)*bt_g1_24;
    hv_6 = hv_6 + (-1.1956884691244341e-06)*bt_g1_25;
    hv_6 = hv_6 + (-4.1723040340002626e-05)*bt_g1_26;
    hv_6 = hv_6 + (2.1970365651213797e-06)*bt_g1_27;
    hv_6 = hv_6 + (0.16118337213993073)*bt_g1_28;
    hv_6 = hv_6 + (-9.1255645884302794e-07)*bt_g1_29;
    hv_6 = hv_6 + (-6.1283162722247653e-07)*bt_g1_30;
    hv_6 = hv_6 + (6.119446616104085e-10)*bt_g1_31;
    hv_6 = hv_6 + (-6.9572774918924551e-07)*bt_g1_32;
    hv_6 = hv_6 + (1.211892254104896e-06)*bt_g1_33;
    hv_6 = hv_6 + (8.5601968180526455e-08)*bt_g1_34;
    hv_6 = hv_6 + (1.5998352864698973e-06)*bt_g1_35;
    hv_6 = hv_6 + (-1.3574755939771421e-05)*bt_g1_36;
    hv_6 = hv_6 + (2.5521757152091595e-07)*bt_g1_37;
    hv_6 = hv_6 + (0.12205614894628525)*bt_g1_38;
    hv_6 = hv_6 + (-7.5987244940733945e-08)*bt_g1_39;
    hv_6 = hv_6 + (3.4550723171378195e-08)*bt_g1_40;
    hv_6 = hv_6 + (9.0033262267752434e-07)*bt_g1_41;
    hv_6 = hv_6 + (9.4741326392977498e-06)*bt_g1_42;
    hv_6 = hv_6 + (3.8781404754217874e-09)*bt_g1_43;
    hv_6 = hv_6 + (2.882676319870825e-08)*bt_g1_44;
    hv_6 = hv_6 + (-0.027377229183912277)*bt_g1_45;
    hv_6 = hv_6 + (-2.8726174150506267e-07)*bt_g1_46;
    hv_6 = hv_6 + (-6.7062330799672054e-08)*bt_g1_47;
    hv_6 = hv_6 + (-2.0509278719771373e-09)*bt_g1_48;
    hv_6 = hv_6 + (-2.2329418314370741e-08)*bt_g1_49;
    hv_6 = hv_6 + (5.1202590611865162e-07)*bt_g1_50;
    hv_6 = hv_6 + (-8.7526892400546785e-08)*bt_g1_51;
    hv_6 = hv_6 + (7.424951036227867e-07)*bt_g1_52;
    hv_6 = hv_6 + (-3.1493109418079257e-05)*bt_g1_53;
    hv_6 = hv_6 + (-2.0323037460912019e-05)*bt_g1_54;
    hv_6 = hv_6 + (-1.9761237126658671e-06)*bt_g1_55;
    hv_6 = hv_6 + (0.026988334953784943)*bt_g1_56;
    hv_6 = hv_6 + (-6.0180159380252007e-06)*bt_g1_57;
    hv_6 = hv_6 + (2.0235114789102226e-05)*bt_g1_58;
    hv_6 = hv_6 + (-1.0859151444719828e-07)*bt_g1_59;
    hv_6 = hv_6 + (0.075240083038806915)*bt_g1_60;
    hv_6 = hv_6 + (-5.3979323411113e-07)*bt_g1_61;
    hv_6 = hv_6 + (-2.0210651200613938e-05)*bt_g1_62;
    hv_6 = hv_6 + (-3.8922662497498095e-05)*bt_g1_63;
    hv_7 = 5.0634930630621966e-06;
    hv_7 = hv_7 + (-1.2112336662539747e-05)*bt_g1_0;
    hv_7 = hv_7 + (-1.2271542115804834e-10)*bt_g1_1;
    hv_7 = hv_7 + (-3.0437681264317007e-09)*bt_g1_2;
    hv_7 = hv_7 + (5.797139851493327e-11)*bt_g1_3;
    hv_7 = hv_7 + (-1.1642021548186055e-11)*bt_g1_4;
    hv_7 = hv_7 + (2.9529284833323954e-12)*bt_g1_5;
    hv_7 = hv_7 + (-6.0070229836888846e-15)*bt_g1_6;
    hv_7 = hv_7 + (2.6719759738114135e-09)*bt_g1_7;
    hv_7 = hv_7 + (3.4047521746405351e-12)*bt_g1_8;
    hv_7 = hv_7 + (3.4454657876770156e-11)*bt_g1_9;
    hv_7 = hv_7 + (-5.2541076911438722e-06)*bt_g1_10;
    hv_7 = hv_7 + (2.1709836619393519e-12)*bt_g1_11;
    hv_7 = hv_7 + (1.2631763040074628e-12)*bt_g1_12;
    hv_7 = hv_7 + (-3.1962887891978653e-09)*bt_g1_13;
    hv_7 = hv_7 + (-2.3376443003542136e-09)*bt_g1_14;
    hv_7 = hv_7 + (6.0046932703894385e-11)*bt_g1_15;
    hv_7 = hv_7 + (-4.9691622344694153e-11)*bt_g1_16;
    hv_7 = hv_7 + (3.4044184138437572e-10)*bt_g1_17;
    hv_7 = hv_7 + (3.0843757485854439e-06)*bt_g1_18;
    hv_7 = hv_7 + (4.9382092165428659e-11)*bt_g1_19;
    hv_7 = hv_7 + (6.4001005883884687e-11)*bt_g1_20;
    hv_7 = hv_7 + (1.5776271348327819e-12)*bt_g1_21;
    hv_7 = hv_7 + (-4.9785479558361878e-12)*bt_g1_22;
    hv_7 = hv_7 + (-2.4188791703134982e-13)*bt_g1_23;
    hv_7 = hv_7 + (2.2776869172957959e-06)*bt_g1_24;
    hv_7 = hv_7 + (8.1907772231382125e-11)*bt_g1_25;
    hv_7 = hv_7 + (-9.3686181035224081e-10)*bt_g1_26;
    hv_7 = hv_7 + (-1.40806741266708e-11)*bt_g1_27;
    hv_7 = hv_7 + (-2.3586356689975219e-07)*bt_g1_28;
    hv_7 = hv_7 + (-1.1089861667867851e-10)*bt_g1_29;
    hv_7 = hv_7 + (4.7997762014917456e-11)*bt_g1_30;
    hv_7 = hv_7 + (1.6747772873387801e-12)*bt_g1_31;
    hv_7 = hv_7 + (-1.8719290006963263e-11)*bt_g1_32;
    hv_7 = hv_7 + (-3.7812170061712891e-11)*bt_g1_33;
    hv_7 = hv_7 + (7.7535452017163387e-12)*bt_g1_34;
    hv_7 = hv_7 + (6.6279863542018091e-11)*bt_g1_35;
    hv_7 = hv_7 + (-4.278918053213232e-10)*bt_g1_36;
    hv_7 = hv_7 + (-4.7116976986671943e-11)*bt_g1_37;
    hv_7 = hv_7 + (-2.4818066322040977e-06)*bt_g1_38;
    hv_7 = hv_7 + (-3.2344016787783092e-12)*bt_g1_39;
    hv_7 = hv_7 + (4.5218941438496252e-12)*bt_g1_40;
    hv_7 = hv_7 + (5.9105040306484113e-11)*bt_g1_41;
    hv_7 = hv_7 + (4.8050224910056727e-10)*bt_g1_42;
    hv_7 = hv_7 + (-7.370644893034406e-13)*bt_g1_43;
    hv_7 = hv_7 + (1.1561693442907472e-12)*bt_g1_44;
    hv_7 = hv_7 + (1.0626126822899096e-05)*bt_g1_45;
    hv_7 = hv_7 + (-1.9841411499910144e-11)*bt_g1_46;
    hv_7 = hv_7 + (-6.3103959991456238e-13)*bt_g1_47;
    hv_7 = hv_7 + (-1.3622321586720387e-12)*bt_g1_48;
    hv_7 = hv_7 + (-7.7571152626298989e-13)*bt_g1_49;
    hv_7 = hv_7 + (1.845260576283092e-11)*bt_g1_50;
    hv_7 = hv_7 + (-4.171488241638821e-12)*bt_g1_51;
    hv_7 = hv_7 + (2.3083345998542448e-11)*bt_g1_52;
    hv_7 = hv_7 + (-9.1798435519763188e-10)*bt_g1_53;
    hv_7 = hv_7 + (-2.8335378488009155e-10)*bt_g1_54;
    hv_7 = hv_7 + (-2.7487609410847824e-11)*bt_g1_55;
    hv_7 = hv_7 + (9.8407490440877154e-06)*bt_g1_56;
    hv_7 = hv_7 + (-1.5177029077939608e-10)*bt_g1_57;
    hv_7 = hv_7 + (1.106794877969719e-09)*bt_g1_58;
    hv_7 = hv_7 + (-6.6751698569664231e-13)*bt_g1_59;
    hv_7 = hv_7 + (7.8551778415203444e-07)*bt_g1_60;
    hv_7 = hv_7 + (-3.4594334341608857e-11)*bt_g1_61;
    hv_7 = hv_7 + (-1.2260379378403741e-09)*bt_g1_62;
    hv_7 = hv_7 + (-9.2225665992984318e-10)*bt_g1_63;
    hv_8 = 0.0003977885062340647;
    hv_8 = hv_8 + (0.17502301931381226)*bt_g1_0;
    hv_8 = hv_8 + (2.4663864905960509e-07)*bt_g1_1;
    hv_8 = hv_8 + (3.5433266020845622e-05)*bt_g1_2;
    hv_8 = hv_8 + (-1.8377004096237215e-07)*bt_g1_3;
    hv_8 = hv_8 + (5.1083219432257465e-08)*bt_g1_4;
    hv_8 = hv_8 + (-2.0980147397153814e-08)*bt_g1_5;
    hv_8 = hv_8 + (8.080969920998271e-11)*bt_g1_6;
    hv_8 = hv_8 + (-1.9792109014815651e-05)*bt_g1_7;
    hv_8 = hv_8 + (1.8347569152865617e-07)*bt_g1_8;
    hv_8 = hv_8 + (9.9885120619092049e-08)*bt_g1_9;
    hv_8 = hv_8 + (0.020173259079456329)*bt_g1_10;
    hv_8 = hv_8 + (-1.3210860849710571e-08)*bt_g1_11;
    hv_8 = hv_8 + (1.8985905114732304e-07)*bt_g1_12;
    hv_8 = hv_8 + (3.4306649467907846e-05)*bt_g1_13;
    hv_8 = hv_8 + (8.649512892588973e-06)*bt_g1_14;
    hv_8 = hv_8 + (-1.7005658037305693e-06)*bt_g1_15;
    hv_8 = hv_8 + (1.2249782912476803e-06)*bt_g1_16;
    hv_8 = hv_8 + (-4.2658398342609871e-06)*bt_g1_17;
    hv_8 = hv_8 + (-0.15981687605381012)*bt_g1_18;
    hv_8 = hv_8 + (-1.4182004406393389e-06)*bt_g1_19;
    hv_8 = hv_8 + (-1.5367938885901822e-06)*bt_g1_20;
    hv_8 = hv_8 + (2.1623803547754505e-07)*bt_g1_21;
    hv_8 = hv_8 + (4.6040625534260471e-08)*bt_g1_22;
    hv_8 = hv_8 + (-2.9162352532807745e-09)*bt_g1_23;
    hv_8 = hv_8 + (0.096883431077003479)*bt_g1_24;
    hv_8 = hv_8 + (-5.3815512046639924e-07)*bt_g1_25;
    hv_8 = hv_8 + (-4.5172737372922711e-06)*bt_g1_26;
    hv_8 = hv_8 + (-7.332259883696679e-07)*bt_g1_27;
    hv_8 = hv_8 + (-0.021338265389204025)*bt_g1_28;
    hv_8 = hv_8 + (1.9022329524887027e-06)*bt_g1_29;
    hv_8 = hv_8 + (-1.2770588000421412e-06)*bt_g1_30;
    hv_8 = hv_8 + (1.3437595924870038e-08)*bt_g1_31;
    hv_8 = hv_8 + (7.9467623592677228e-09)*bt_g1_32;
    hv_8 = hv_8 + (1.4408415154321119e-06)*bt_g1_33;
    hv_8 = hv_8 + (-1.973858445580845e-07)*bt_g1_34;
    hv_8 = hv_8 + (-9.6109374680963811e-07)*bt_g1_35;
    hv_8 = hv_8 + (2.4047162696660962e-06)*bt_g1_36;
    hv_8 = hv_8 + (9.8990517471975181e-07)*bt_g1_37;
    hv_8 = hv_8 + (0.064618192613124847)*bt_g1_38;
    hv_8 = hv_8 + (-2.2249840014865185e-07)*bt_g1_39;
    hv_8 = hv_8 + (-1.7133396568169701e-07)*bt_g1_40;
    hv_8 = hv_8 + (-8.4545848721973016e-07)*bt_g1_41;
    hv_8 = hv_8 + (-6.0152860896778293e-06)*bt_g1_42;
    hv_8 = hv_8 + (1.2012018046902995e-08)*bt_g1_43;
    hv_8 = hv_8 + (-8.0404847224713194e-09)*bt_g1_44;
    hv_8 = hv_8 + (-0.12311432510614395)*bt_g1_45;
    hv_8 = hv_8 + (4.2725437765511742e-07)*bt_g1_46;
    hv_8 = hv_8 + (-1.911179055014145e-07)*bt_g1_47;
    hv_8 = hv_8 + (1.0605871381130783e-07)*bt_g1_48;
    hv_8 = hv_8 + (-3.8911172062228161e-09)*bt_g1_49;
    hv_8 = hv_8 + (-1.3175566948575579e-07)*bt_g1_50;
    hv_8 = hv_8 + (4.0357072350616363e-08)*bt_g1_51;
    hv_8 = hv_8 + (-1.0371708469847363e-07)*bt_g1_52;
    hv_8 = hv_8 + (2.374316864006687e-06)*bt_g1_53;
    hv_8 = hv_8 + (-8.6363816080847755e-06)*bt_g1_54;
    hv_8 = hv_8 + (1.2807690552563145e-07)*bt_g1_55;
    hv_8 = hv_8 + (-0.10465162247419357)*bt_g1_56;
    hv_8 = hv_8 + (3.1154104362940416e-06)*bt_g1_57;
    hv_8 = hv_8 + (-1.3918714103056118e-05)*bt_g1_58;
    hv_8 = hv_8 + (-1.7939238716735417e-07)*bt_g1_59;
    hv_8 = hv_8 + (0.040015686303377151)*bt_g1_60;
    hv_8 = hv_8 + (7.3785281529126223e-07)*bt_g1_61;
    hv_8 = hv_8 + (1.7502030459581874e-05)*bt_g1_62;
    hv_8 = hv_8 + (-3.4884740216512e-06)*bt_g1_63;
    hv_9 = -0.002079338300973177;
    hv_9 = hv_9 + (0.20796167850494385)*bt_g1_0;
    hv_9 = hv_9 + (-7.0174434085856774e-07)*bt_g1_1;
    hv_9 = hv_9 + (7.4492076237220317e-05)*bt_g1_2;
    hv_9 = hv_9 + (2.8587402312041377e-07)*bt_g1_3;
    hv_9 = hv_9 + (-6.6132088250014931e-08)*bt_g1_4;
    hv_9 = hv_9 + (8.6250127040443658e-09)*bt_g1_5;
    hv_9 = hv_9 + (4.5616073418575098e-11)*bt_g1_6;
    hv_9 = hv_9 + (-2.1329396986402571e-05)*bt_g1_7;
    hv_9 = hv_9 + (2.0625255103823292e-07)*bt_g1_8;
    hv_9 = hv_9 + (2.7223705956203048e-07)*bt_g1_9;
    hv_9 = hv_9 + (-0.28006431460380554)*bt_g1_10;
    hv_9 = hv_9 + (6.591211576534306e-09)*bt_g1_11;
    hv_9 = hv_9 + (2.6863889956985076e-07)*bt_g1_12;
    hv_9 = hv_9 + (6.4995059801731259e-05)*bt_g1_13;
    hv_9 = hv_9 + (5.2501127356663346e-06)*bt_g1_14;
    hv_9 = hv_9 + (-1.7919630863616476e-06)*bt_g1_15;
    hv_9 = hv_9 + (1.0827241112565389e-06)*bt_g1_16;
    hv_9 = hv_9 + (-1.097526251214731e-06)*bt_g1_17;
    hv_9 = hv_9 + (0.053982190787792206)*bt_g1_18;
    hv_9 = hv_9 + (-1.4146645526125212e-06)*bt_g1_19;
    hv_9 = hv_9 + (-1.9887629605364054e-06)*bt_g1_20;
    hv_9 = hv_9 + (2.8462059731282352e-07)*bt_g1_21;
    hv_9 = hv_9 + (-6.6303784684862421e-09)*bt_g1_22;
    hv_9 = hv_9 + (1.0325226229568329e-09)*bt_g1_23;
    hv_9 = hv_9 + (0.030327999964356422)*bt_g1_24;
    hv_9 = hv_9 + (3.3000233656821365e-07)*bt_g1_25;
    hv_9 = hv_9 + (-7.3706746661628131e-06)*bt_g1_26;
    hv_9 = hv_9 + (-1.5070608014866593e-06)*bt_g1_27;
    hv_9 = hv_9 + (0.05004439502954483)*bt_g1_28;
    hv_9 = hv_9 + (1.3388716979534365e-06)*bt_g1_29;
    hv_9 = hv_9 + (-1.1322576938255224e-06)*bt_g1_30;
    hv_9 = hv_9 + (-1.6154777071619719e-08)*bt_g1_31;
    hv_9 = hv_9 + (-1.2279286920602317e-07)*bt_g1_32;
    hv_9 = hv_9 + (1.8736699303190107e-06)*bt_g1_33;
    hv_9 = hv_9 + (-1.3824093514358538e-07)*bt_g1_34;
    hv_9 = hv_9 + (-6.6249293695364031e-07)*bt_g1_35;
    hv_9 = hv_9 + (-1.94699509847851e-06)*bt_g1_36;
    hv_9 = hv_9 + (4.7966301508495235e-07)*bt_g1_37;
    hv_9 = hv_9 + (-0.0011347681283950806)*bt_g1_38;
    hv_9 = hv_9 + (-2.6042567924378091e-07)*bt_g1_39;
    hv_9 = hv_9 + (-1.3922041830483067e-07)*bt_g1_40;
    hv_9 = hv_9 + (2.2386674913832394e-07)*bt_g1_41;
    hv_9 = hv_9 + (-2.3528496058133896e-06)*bt_g1_42;
    hv_9 = hv_9 + (-3.2920316472839772e-10)*bt_g1_43;
    hv_9 = hv_9 + (2.6797366547981483e-09)*bt_g1_44;
    hv_9 = hv_9 + (0.088894486427307129)*bt_g1_45;
    hv_9 = hv_9 + (3.3977880775637459e-07)*bt_g1_46;
    hv_9 = hv_9 + (-2.4749996896389348e-07)*bt_g1_47;
    hv_9 = hv_9 + (9.3183736282753671e-08)*bt_g1_48;
    hv_9 = hv_9 + (1.2686562023134229e-08)*bt_g1_49;
    hv_9 = hv_9 + (6.5259932569006196e-08)*bt_g1_50;
    hv_9 = hv_9 + (-4.4383363650979391e-09)*bt_g1_51;
    hv_9 = hv_9 + (1.1492853957406624e-07)*bt_g1_52;
    hv_9 = hv_9 + (-3.9008455132716335e-06)*bt_g1_53;
    hv_9 = hv_9 + (-3.075798076679348e-06)*bt_g1_54;
    hv_9 = hv_9 + (3.5224482530793466e-07)*bt_g1_55;
    hv_9 = hv_9 + (0.037828370928764343)*bt_g1_56;
    hv_9 = hv_9 + (3.2872842439246597e-06)*bt_g1_57;
    hv_9 = hv_9 + (-9.4733968580840155e-06)*bt_g1_58;
    hv_9 = hv_9 + (-2.3968289042386459e-07)*bt_g1_59;
    hv_9 = hv_9 + (-0.066128633916378021)*bt_g1_60;
    hv_9 = hv_9 + (6.0321872297208756e-07)*bt_g1_61;
    hv_9 = hv_9 + (1.7773414583643898e-05)*bt_g1_62;
    hv_9 = hv_9 + (-5.7097681747109164e-06)*bt_g1_63;
    hv_10 = 0.030098926275968552;
    hv_10 = hv_10 + (-0.033057793974876404)*bt_g1_0;
    hv_10 = hv_10 + (2.3586405859532533e-06)*bt_g1_1;
    hv_10 = hv_10 + (6.2010367400944233e-05)*bt_g1_2;
    hv_10 = hv_10 + (-1.1023997785741813e-06)*bt_g1_3;
    hv_10 = hv_10 + (1.9981597176865762e-07)*bt_g1_4;
    hv_10 = hv_10 + (-4.2518912835021183e-08)*bt_g1_5;
    hv_10 = hv_10 + (7.3070903494620865e-11)*bt_g1_6;
    hv_10 = hv_10 + (-5.5093554692575708e-05)*bt_g1_7;
    hv_10 = hv_10 + (-5.5196288428760454e-08)*bt_g1_8;
    hv_10 = hv_10 + (-8.5188605680741603e-07)*bt_g1_9;
    hv_10 = hv_10 + (0.050534915179014206)*bt_g1_10;
    hv_10 = hv_10 + (-3.363822642654668e-08)*bt_g1_11;
    hv_10 = hv_10 + (-1.5565053956834163e-07)*bt_g1_12;
    hv_10 = hv_10 + (6.4426618337165564e-05)*bt_g1_13;
    hv_10 = hv_10 + (5.6396333093289286e-05)*bt_g1_14;
    hv_10 = hv_10 + (3.5570852219279914e-07)*bt_g1_15;
    hv_10 = hv_10 + (-1.550550479123558e-07)*bt_g1_16;
    hv_10 = hv_10 + (-4.2539841160760261e-06)*bt_g1_17;
    hv_10 = hv_10 + (-0.0046725459396839142)*bt_g1_18;
    hv_10 = hv_10 + (3.8015480186004424e-07)*bt_g1_19;
    hv_10 = hv_10 + (-2.0595555483282624e-08)*bt_g1_20;
    hv_10 = hv_10 + (-1.1184008030795667e-07)*bt_g1_21;
    hv_10 = hv_10 + (6.8052969481868786e-08)*bt_g1_22;
    hv_10 = hv_10 + (1.0835091934779939e-08)*bt_g1_23;
    hv_10 = hv_10 + (0.22997899353504181)*bt_g1_24;
    hv_10 = hv_10 + (-7.4477151201790548e-07)*bt_g1_25;
    hv_10 = hv_10 + (2.6089886887348257e-05)*bt_g1_26;
    hv_10 = hv_10 + (-1.5799409425198974e-07)*bt_g1_27;
    hv_10 = hv_10 + (-0.098492056131362915)*bt_g1_28;
    hv_10 = hv_10 + (1.354017967969412e-06)*bt_g1_29;
    hv_10 = hv_10 + (2.0249449050879775e-07)*bt_g1_30;
    hv_10 = hv_10 + (5.8321489859736175e-09)*bt_g1_31;
    hv_10 = hv_10 + (3.9731455103719782e-07)*bt_g1_32;
    hv_10 = hv_10 + (-9.6142332495219307e-07)*bt_g1_33;
    hv_10 = hv_10 + (-7.9210799697193579e-08)*bt_g1_34;
    hv_10 = hv_10 + (-8.6309273683582433e-07)*bt_g1_35;
    hv_10 = hv_10 + (7.2759680733724963e-06)*bt_g1_36;
    hv_10 = hv_10 + (2.0252780075225019e-07)*bt_g1_37;
    hv_10 = hv_10 + (-0.10385981947183609)*bt_g1_38;
    hv_10 = hv_10 + (7.4837103625213786e-08)*bt_g1_39;
    hv_10 = hv_10 + (-4.2572434466592313e-08)*bt_g1_40;
    hv_10 = hv_10 + (-8.7718535723979585e-07)*bt_g1_41;
    hv_10 = hv_10 + (-5.856055850017583e-06)*bt_g1_42;
    hv_10 = hv_10 + (2.4854005520325018e-09)*bt_g1_43;
    hv_10 = hv_10 + (-1.6244166900492019e-08)*bt_g1_44;
    hv_10 = hv_10 + (-0.12928734719753265)*bt_g1_45;
    hv_10 = hv_10 + (2.2509286168315157e-07)*bt_g1_46;
    hv_10 = hv_10 + (7.1747884078376956e-08)*bt_g1_47;
    hv_10 = hv_10 + (1.3695881762032514e-08)*bt_g1_48;
    hv_10 = hv_10 + (4.8279722442146067e-09)*bt_g1_49;
    hv_10 = hv_10 + (-2.8046926558999985e-07)*bt_g1_50;
    hv_10 = hv_10 + (5.1850683746579307e-08)*bt_g1_51;
    hv_10 = hv_10 + (-3.9568652709931484e-07)*bt_g1_52;
    hv_10 = hv_10 + (1.8389298929832876e-05)*bt_g1_53;
    hv_10 = hv_10 + (1.2610381418198813e-05)*bt_g1_54;
    hv_10 = hv_10 + (5.9575279465207132e-07)*bt_g1_55;
    hv_10 = hv_10 + (-0.1682441383600235)*bt_g1_56;
    hv_10 = hv_10 + (1.7701408978609834e-06)*bt_g1_57;
    hv_10 = hv_10 + (-1.1373774214007426e-05)*bt_g1_58;
    hv_10 = hv_10 + (1.174733199604816e-07)*bt_g1_59;
    hv_10 = hv_10 + (-0.0048411795869469643)*bt_g1_60;
    hv_10 = hv_10 + (3.8220625242502138e-07)*bt_g1_61;
    hv_10 = hv_10 + (1.2289758160477504e-05)*bt_g1_62;
    hv_10 = hv_10 + (2.5098601327044889e-05)*bt_g1_63;
    hv_11 = -0.0044090058654546738;
    hv_11 = hv_11 + (-0.10158608108758926)*bt_g1_0;
    hv_11 = hv_11 + (-1.5671856772314641e-06)*bt_g1_1;
    hv_11 = hv_11 + (-2.0594216039171442e-06)*bt_g1_2;
    hv_11 = hv_11 + (6.7558391947386554e-07)*bt_g1_3;
    hv_11 = hv_11 + (-1.1088875595532954e-07)*bt_g1_4;
    hv_11 = hv_11 + (1.9001435092036445e-08)*bt_g1_5;
    hv_11 = hv_11 + (-9.4437044989570396e-12)*bt_g1_6;
    hv_11 = hv_11 + (7.2344437285210006e-06)*bt_g1_7;
    hv_11 = hv_11 + (-4.8527468266001961e-08)*bt_g1_8;
    hv_11 = hv_11 + (8.0110208955375128e-07)*bt_g1_9;
    hv_11 = hv_11 + (0.31198906898498535)*bt_g1_10;
    hv_11 = hv_11 + (1.5099589134592861e-08)*bt_g1_11;
    hv_11 = hv_11 + (-5.2129212946283587e-08)*bt_g1_12;
    hv_11 = hv_11 + (-8.1605645618765266e-07)*bt_g1_13;
    hv_11 = hv_11 + (-1.8687094780034386e-05)*bt_g1_14;
    hv_11 = hv_11 + (4.0834906940290239e-06)*bt_g1_15;
    hv_11 = hv_11 + (-3.4082047477568267e-06)*bt_g1_16;
    hv_11 = hv_11 + (5.5741952564858366e-06)*bt_g1_17;
    hv_11 = hv_11 + (0.059636615216732025)*bt_g1_18;
    hv_11 = hv_11 + (3.4268368835910223e-06)*bt_g1_19;
    hv_11 = hv_11 + (-1.9778751436660968e-07)*bt_g1_20;
    hv_11 = hv_11 + (-5.6319983343655622e-08)*bt_g1_21;
    hv_11 = hv_11 + (-4.734969749620177e-08)*bt_g1_22;
    hv_11 = hv_11 + (2.0581500947969289e-08)*bt_g1_23;
    hv_11 = hv_11 + (0.046430047601461411)*bt_g1_24;
    hv_11 = hv_11 + (6.9215680014167447e-06)*bt_g1_25;
    hv_11 = hv_11 + (-2.3639586288481951e-05)*bt_g1_26;
    hv_11 = hv_11 + (-3.7433683246490546e-06)*bt_g1_27;
    hv_11 = hv_11 + (-0.20681481063365936)*bt_g1_28;
    hv_11 = hv_11 + (-6.7251198743178975e-06)*bt_g1_29;
    hv_11 = hv_11 + (3.3756123229977675e-06)*bt_g1_30;
    hv_11 = hv_11 + (-7.2271437723259169e-09)*bt_g1_31;
    hv_11 = hv_11 + (-3.0151525720611971e-07)*bt_g1_32;
    hv_11 = hv_11 + (-2.909577460741275e-06)*bt_g1_33;
    hv_11 = hv_11 + (1.211960665159495e-07)*bt_g1_34;
    hv_11 = hv_11 + (-1.2163940255049965e-07)*bt_g1_35;
    hv_11 = hv_11 + (-3.7064928619656712e-06)*bt_g1_36;
    hv_11 = hv_11 + (-3.6425294638320338e-06)*bt_g1_37;
    hv_11 = hv_11 + (-0.059768255800008774)*bt_g1_38;
    hv_11 = hv_11 + (5.2951453000105175e-08)*bt_g1_39;
    hv_11 = hv_11 + (8.4614356410384062e-08)*bt_g1_40;
    hv_11 = hv_11 + (2.7334469905326841e-06)*bt_g1_41;
    hv_11 = hv_11 + (6.1702494349447079e-06)*bt_g1_42;
    hv_11 = hv_11 + (-2.4429889222687962e-08)*bt_g1_43;
    hv_11 = hv_11 + (5.4078501676713131e-09)*bt_g1_44;
    hv_11 = hv_11 + (0.034578487277030945)*bt_g1_45;
    hv_11 = hv_11 + (-3.4160783002334938e-07)*bt_g1_46;
    hv_11 = hv_11 + (5.8304006955722798e-08)*bt_g1_47;
    hv_11 = hv_11 + (-1.9193244327198045e-08)*bt_g1_48;
    hv_11 = hv_11 + (-4.6565052258529249e-08)*bt_g1_49;
    hv_11 = hv_11 + (1.2127929949201643e-07)*bt_g1_50;
    hv_11 = hv_11 + (-4.0033729220567693e-08)*bt_g1_51;
    hv_11 = hv_11 + (2.1840956776486564e-07)*bt_g1_52;
    hv_11 = hv_11 + (-1.0124083928531036e-05)*bt_g1_53;
    hv_11 = hv_11 + (-2.0846900952165015e-05)*bt_g1_54;
    hv_11 = hv_11 + (1.9505985164869344e-06)*bt_g1_55;
    hv_11 = hv_11 + (-0.0054409937001764774)*bt_g1_56;
    hv_11 = hv_11 + (4.7504627218586393e-06)*bt_g1_57;
    hv_11 = hv_11 + (2.5583315164112719e-06)*bt_g1_58;
    hv_11 = hv_11 + (5.6718221230767085e-08)*bt_g1_59;
    hv_11 = hv_11 + (-0.16636861860752106)*bt_g1_60;
    hv_11 = hv_11 + (-5.3336742666942882e-07)*bt_g1_61;
    hv_11 = hv_11 + (-1.6247010137249163e-07)*bt_g1_62;
    hv_11 = hv_11 + (-2.178147406084463e-05)*bt_g1_63;
    hv_12 = 0.030399035662412643;
    hv_12 = hv_12 + (-0.0086281998082995415)*bt_g1_0;
    hv_12 = hv_12 + (4.6737786760786548e-06)*bt_g1_1;
    hv_12 = hv_12 + (9.9777957075275481e-05)*bt_g1_2;
    hv_12 = hv_12 + (-2.2483020529762143e-06)*bt_g1_3;
    hv_12 = hv_12 + (4.6055754410190275e-07)*bt_g1_4;
    hv_12 = hv_12 + (-1.0809934991584669e-07)*bt_g1_5;
    hv_12 = hv_12 + (2.7603827557065586e-10)*bt_g1_6;
    hv_12 = hv_12 + (-9.9736200354527682e-05)*bt_g1_7;
    hv_12 = hv_12 + (6.701545629539396e-08)*bt_g1_8;
    hv_12 = hv_12 + (-1.2540965599328047e-06)*bt_g1_9;
    hv_12 = hv_12 + (-0.18839894235134125)*bt_g1_10;
    hv_12 = hv_12 + (-7.8573712869456358e-08)*bt_g1_11;
    hv_12 = hv_12 + (-2.1019026519297768e-08)*bt_g1_12;
    hv_12 = hv_12 + (0.00010702000872697681)*bt_g1_13;
    hv_12 = hv_12 + (8.5146217315923423e-05)*bt_g1_14;
    hv_12 = hv_12 + (1.6574597339058528e-06)*bt_g1_15;
    hv_12 = hv_12 + (-1.7905219920066884e-06)*bt_g1_16;
    hv_12 = hv_12 + (-8.6395893958979286e-06)*bt_g1_17;
    hv_12 = hv_12 + (0.078805692493915558)*bt_g1_18;
    hv_12 = hv_12 + (1.532127384962223e-06)*bt_g1_19;
    hv_12 = hv_12 + (-6.6493413442003657e-07)*bt_g1_20;
    hv_12 = hv_12 + (3.131366455022544e-08)*bt_g1_21;
    hv_12 = hv_12 + (1.6265990154806786e-07)*bt_g1_22;
    hv_12 = hv_12 + (5.3171991254430395e-08)*bt_g1_23;
    hv_12 = hv_12 + (0.11497817188501358)*bt_g1_24;
    hv_12 = hv_12 + (7.889471817179583e-06)*bt_g1_25;
    hv_12 = hv_12 + (3.4327556932112202e-05)*bt_g1_26;
    hv_12 = hv_12 + (-8.3969143815920688e-06)*bt_g1_27;
    hv_12 = hv_12 + (0.16961517930030823)*bt_g1_28;
    hv_12 = hv_12 + (-2.646465873112902e-06)*bt_g1_29;
    hv_12 = hv_12 + (1.7401840750608244e-06)*bt_g1_30;
    hv_12 = hv_12 + (2.6414447518163797e-08)*bt_g1_31;
    hv_12 = hv_12 + (7.0546832375839585e-07)*bt_g1_32;
    hv_12 = hv_12 + (-7.4203904887326644e-07)*bt_g1_33;
    hv_12 = hv_12 + (-1.2294549378566444e-07)*bt_g1_34;
    hv_12 = hv_12 + (-3.2727725738368463e-06)*bt_g1_35;
    hv_12 = hv_12 + (1.7316697267233394e-05)*bt_g1_36;
    hv_12 = hv_12 + (-2.4975938686111476e-06)*bt_g1_37;
    hv_12 = hv_12 + (-0.037814576178789139)*bt_g1_38;
    hv_12 = hv_12 + (-6.6529707964946283e-08)*bt_g1_39;
    hv_12 = hv_12 + (-9.5388706711219129e-08)*bt_g1_40;
    hv_12 = hv_12 + (3.6058753494216944e-07)*bt_g1_41;
    hv_12 = hv_12 + (-1.4069792996451724e-05)*bt_g1_42;
    hv_12 = hv_12 + (-1.3650878649684728e-08)*bt_g1_43;
    hv_12 = hv_12 + (-4.0511455523528639e-08)*bt_g1_44;
    hv_12 = hv_12 + (-0.18707919120788574)*bt_g1_45;
    hv_12 = hv_12 + (3.7106275385667686e-07)*bt_g1_46;
    hv_12 = hv_12 + (-4.0554205327225645e-08)*bt_g1_47;
    hv_12 = hv_12 + (6.610034120058117e-08)*bt_g1_48;
    hv_12 = hv_12 + (-1.4916953006149924e-08)*bt_g1_49;
    hv_12 = hv_12 + (-6.970940376049839e-07)*bt_g1_50;
    hv_12 = hv_12 + (1.2294944440327527e-07)*bt_g1_51;
    hv_12 = hv_12 + (-9.0206151526217582e-07)*bt_g1_52;
    hv_12 = hv_12 + (3.6086792533751577e-05)*bt_g1_53;
    hv_12 = hv_12 + (7.5369043770479038e-06)*bt_g1_54;
    hv_12 = hv_12 + (4.5497477003664244e-06)*bt_g1_55;
    hv_12 = hv_12 + (-0.087423324584960938)*bt_g1_56;
    hv_12 = hv_12 + (1.7069212844944559e-05)*bt_g1_57;
    hv_12 = hv_12 + (-4.2261843191226944e-05)*bt_g1_58;
    hv_12 = hv_12 + (-1.1465354887718604e-08)*bt_g1_59;
    hv_12 = hv_12 + (-0.0085304006934165955)*bt_g1_60;
    hv_12 = hv_12 + (7.7589879765582737e-07)*bt_g1_61;
    hv_12 = hv_12 + (5.1061972044408321e-05)*bt_g1_62;
    hv_12 = hv_12 + (3.1786483305040747e-05)*bt_g1_63;
    hv_13 = 0.024890989065170288;
    hv_13 = hv_13 + (-0.21003833413124084)*bt_g1_0;
    hv_13 = hv_13 + (3.5961083995061927e-06)*bt_g1_1;
    hv_13 = hv_13 + (5.7806146287475713e-06)*bt_g1_2;
    hv_13 = hv_13 + (-1.5881294075370533e-06)*bt_g1_3;
    hv_13 = hv_13 + (3.1305711445384077e-07)*bt_g1_4;
    hv_13 = hv_13 + (-5.890237986250213e-08)*bt_g1_5;
    hv_13 = hv_13 + (6.4979757685712514e-11)*bt_g1_6;
    hv_13 = hv_13 + (-3.0561579478671774e-05)*bt_g1_7;
    hv_13 = hv_13 + (-2.524619162613817e-07)*bt_g1_8;
    hv_13 = hv_13 + (-1.3134225582689396e-06)*bt_g1_9;
    hv_13 = hv_13 + (-0.058578439056873322)*bt_g1_10;
    hv_13 = hv_13 + (-4.754743088142277e-08)*bt_g1_11;
    hv_13 = hv_13 + (-3.5119731478516769e-07)*bt_g1_12;
    hv_13 = hv_13 + (1.2128500202379655e-05)*bt_g1_13;
    hv_13 = hv_13 + (4.2627420043572783e-05)*bt_g1_14;
    hv_13 = hv_13 + (2.7251858227828052e-06)*bt_g1_15;
    hv_13 = hv_13 + (-2.3971463178895647e-06)*bt_g1_16;
    hv_13 = hv_13 + (-2.8035656214342453e-06)*bt_g1_17;
    hv_13 = hv_13 + (0.014666629955172539)*bt_g1_18;
    hv_13 = hv_13 + (2.6835505195776932e-06)*bt_g1_19;
    hv_13 = hv_13 + (4.362465801932558e-07)*bt_g1_20;
    hv_13 = hv_13 + (-2.8504865667855483e-07)*bt_g1_21;
    hv_13 = hv_13 + (7.9075725523125584e-08)*bt_g1_22;
    hv_13 = hv_13 + (2.099173990188774e-08)*bt_g1_23;
    hv_13 = hv_13 + (0.054129984229803085)*bt_g1_24;
    hv_13 = hv_13 + (1.6548108305869391e-06)*bt_g1_25;
    hv_13 = hv_13 + (3.5806820960715413e-05)*bt_g1_26;
    hv_13 = hv_13 + (-1.9424057882133638e-06)*bt_g1_27;
    hv_13 = hv_13 + (0.054946433752775192)*bt_g1_28;
    hv_13 = hv_13 + (-1.148994556388061e-06)*bt_g1_29;
    hv_13 = hv_13 + (2.418577651042142e-06)*bt_g1_30;
    hv_13 = hv_13 + (-5.2588454479973734e-08)*bt_g1_31;
    hv_13 = hv_13 + (6.0398036794140353e-07)*bt_g1_32;
    hv_13 = hv_13 + (-3.2279715469485382e-06)*bt_g1_33;
    hv_13 = hv_13 + (1.3236265772320621e-07)*bt_g1_34;
    hv_13 = hv_13 + (-7.2604660772412899e-07)*bt_g1_35;
    hv_13 = hv_13 + (1.0194862625212409e-05)*bt_g1_36;
    hv_13 = hv_13 + (-1.7520357005196274e-06)*bt_g1_37;
    hv_13 = hv_13 + (0.10500927269458771)*bt_g1_38;
    hv_13 = hv_13 + (2.8863166789960815e-07)*bt_g1_39;
    hv_13 = hv_13 + (1.6660175106153474e-07)*bt_g1_40;
    hv_13 = hv_13 + (-4.259350703250675e-07)*bt_g1_41;
    hv_13 = hv_13 + (-3.7742827316833427e-06)*bt_g1_42;
    hv_13 = hv_13 + (-5.0782227312140549e-09)*bt_g1_43;
    hv_13 = hv_13 + (-2.2690379353207391e-08)*bt_g1_44;
    hv_13 = hv_13 + (0.097538188099861145)*bt_g1_45;
    hv_13 = hv_13 + (-1.2825046269426821e-07)*bt_g1_46;
    hv_13 = hv_13 + (2.0691973645625694e-07)*bt_g1_47;
    hv_13 = hv_13 + (-1.4016816862749693e-07)*bt_g1_48;
    hv_13 = hv_13 + (7.3723889215671079e-08)*bt_g1_49;
    hv_13 = hv_13 + (-4.0308137272404565e-07)*bt_g1_50;
    hv_13 = hv_13 + (5.9310082178853918e-08)*bt_g1_51;
    hv_13 = hv_13 + (-5.9896058246522443e-07)*bt_g1_52;
    hv_13 = hv_13 + (2.4590874090790749e-05)*bt_g1_53;
    hv_13 = hv_13 + (2.083649997075554e-05)*bt_g1_54;
    hv_13 = hv_13 + (1.2380404541545431e-06)*bt_g1_55;
    hv_13 = hv_13 + (-0.15081547200679779)*bt_g1_56;
    hv_13 = hv_13 + (2.7255784971202957e-06)*bt_g1_57;
    hv_13 = hv_13 + (-6.8837648541375529e-06)*bt_g1_58;
    hv_13 = hv_13 + (2.7092528398497961e-07)*bt_g1_59;
    hv_13 = hv_13 + (0.020999208092689514)*bt_g1_60;
    hv_13 = hv_13 + (-1.0745016965074683e-07)*bt_g1_61;
    hv_13 = hv_13 + (2.7132925879413961e-06)*bt_g1_62;
    hv_13 = hv_13 + (3.3119660656666383e-05)*bt_g1_63;
    hv_14 = -7.5325482384869247e-07;
    hv_14 = hv_14 + (-9.6686617325758561e-06)*bt_g1_0;
    hv_14 = hv_14 + (-1.8424443914977218e-10)*bt_g1_1;
    hv_14 = hv_14 + (-5.8772307021115466e-09)*bt_g1_2;
    hv_14 = hv_14 + (8.9474004594247702e-11)*bt_g1_3;
    hv_14 = hv_14 + (-1.838977407853104e-11)*bt_g1_4;
    hv_14 = hv_14 + (5.2726789948054353e-12)*bt_g1_5;
    hv_14 = hv_14 + (-9.858687623860371e-15)*bt_g1_6;
    hv_14 = hv_14 + (4.5780339519296831e-09)*bt_g1_7;
    hv_14 = hv_14 + (-1.0839142083884923e-11)*bt_g1_8;
    hv_14 = hv_14 + (4.7314919343621753e-11)*bt_g1_9;
    hv_14 = hv_14 + (1.4963674402679317e-05)*bt_g1_10;
    hv_14 = hv_14 + (3.6740849078398252e-12)*bt_g1_11;
    hv_14 = hv_14 + (-1.8831998135383776e-13)*bt_g1_12;
    hv_14 = hv_14 + (-6.0269136348267693e-09)*bt_g1_13;
    hv_14 = hv_14 + (-3.6308682727081987e-09)*bt_g1_14;
    hv_14 = hv_14 + (3.3843139402023326e-10)*bt_g1_15;
    hv_14 = hv_14 + (-3.0313482279886728e-10)*bt_g1_16;
    hv_14 = hv_14 + (8.4012002909972239e-10)*bt_g1_17;
    hv_14 = hv_14 + (3.815149739239132e-06)*bt_g1_18;
    hv_14 = hv_14 + (3.1245189768824844e-10)*bt_g1_19;
    hv_14 = hv_14 + (-3.6701329475530287e-11)*bt_g1_20;
    hv_14 = hv_14 + (-2.6765872504497246e-12)*bt_g1_21;
    hv_14 = hv_14 + (-1.0311719360334148e-11)*bt_g1_22;
    hv_14 = hv_14 + (1.2721297539680654e-12)*bt_g1_23;
    hv_14 = hv_14 + (1.6315226503138547e-06)*bt_g1_24;
    hv_14 = hv_14 + (2.4253327124412749e-10)*bt_g1_25;
    hv_14 = hv_14 + (-1.2467585852604657e-09)*bt_g1_26;
    hv_14 = hv_14 + (-1.0844386369793235e-12)*bt_g1_27;
    hv_14 = hv_14 + (2.1880592612433247e-05)*bt_g1_28;
    hv_14 = hv_14 + (-4.5621398325756957e-10)*bt_g1_29;
    hv_14 = hv_14 + (3.0354951885414039e-10)*bt_g1_30;
    hv_14 = hv_14 + (-4.8748305739310105e-12)*bt_g1_31;
    hv_14 = hv_14 + (-2.7110218583925594e-11)*bt_g1_32;
    hv_14 = hv_14 + (-2.988021774452676e-10)*bt_g1_33;
    hv_14 = hv_14 + (2.6985450332639438e-11)*bt_g1_34;
    hv_14 = hv_14 + (9.1651915223867064e-11)*bt_g1_35;
    hv_14 = hv_14 + (-7.0665862050844908e-10)*bt_g1_36;
    hv_14 = hv_14 + (-2.82539075469046e-10)*bt_g1_37;
    hv_14 = hv_14 + (-8.7743410404073074e-06)*bt_g1_38;
    hv_14 = hv_14 + (9.2499037943061246e-12)*bt_g1_39;
    hv_14 = hv_14 + (2.3642431762338489e-11)*bt_g1_40;
    hv_14 = hv_14 + (2.2933084597998032e-10)*bt_g1_41;
    hv_14 = hv_14 + (1.1290889334603094e-09)*bt_g1_42;
    hv_14 = hv_14 + (-3.0138372266591551e-12)*bt_g1_43;
    hv_14 = hv_14 + (2.0128029017824067e-12)*bt_g1_44;
    hv_14 = hv_14 + (1.1831659321615007e-05)*bt_g1_45;
    hv_14 = hv_14 + (-5.1025805108961819e-11)*bt_g1_46;
    hv_14 = hv_14 + (3.9248352831644517e-12)*bt_g1_47;
    hv_14 = hv_14 + (-1.6520141157827517e-11)*bt_g1_48;
    hv_14 = hv_14 + (7.1459288139563704e-12)*bt_g1_49;
    hv_14 = hv_14 + (3.2253782977775813e-11)*bt_g1_50;
    hv_14 = hv_14 + (-8.9777438955218614e-12)*bt_g1_51;
    hv_14 = hv_14 + (3.6754928961491018e-11)*bt_g1_52;
    hv_14 = hv_14 + (-1.3945300469941913e-09)*bt_g1_53;
    hv_14 = hv_14 + (-2.8977475974301115e-10)*bt_g1_54;
    hv_14 = hv_14 + (5.1065131290162213e-11)*bt_g1_55;
    hv_14 = hv_14 + (-2.5615490812924691e-05)*bt_g1_56;
    hv_14 = hv_14 + (-3.1115482412857887e-10)*bt_g1_57;
    hv_14 = hv_14 + (2.3243140745421442e-09)*bt_g1_58;
    hv_14 = hv_14 + (1.0161446337142443e-12)*bt_g1_59;
    hv_14 = hv_14 + (-1.7084268620237708e-05)*bt_g1_60;
    hv_14 = hv_14 + (-7.5750038186495061e-11)*bt_g1_61;
    hv_14 = hv_14 + (-2.7103319588661634e-09)*bt_g1_62;
    hv_14 = hv_14 + (-1.2535216198372723e-09)*bt_g1_63;
    hv_15 = -5.0814890073525021e-07;
    hv_15 = hv_15 + (-2.5388050062247203e-07)*bt_g1_0;
    hv_15 = hv_15 + (-4.1423656171879486e-11)*bt_g1_1;
    hv_15 = hv_15 + (-8.8275009524352299e-10)*bt_g1_2;
    hv_15 = hv_15 + (1.9348826360565674e-11)*bt_g1_3;
    hv_15 = hv_15 + (-3.839396248844773e-12)*bt_g1_4;
    hv_15 = hv_15 + (9.4597626173337224e-13)*bt_g1_5;
    hv_15 = hv_15 + (-1.5240529353466249e-15)*bt_g1_6;
    hv_15 = hv_15 + (7.7964662503759996e-10)*bt_g1_7;
    hv_15 = hv_15 + (-8.7263621892721965e-13)*bt_g1_8;
    hv_15 = hv_15 + (1.2628897927413618e-11)*bt_g1_9;
    hv_15 = hv_15 + (-1.0708549780247267e-06)*bt_g1_10;
    hv_15 = hv_15 + (6.9573242566373095e-13)*bt_g1_11;
    hv_15 = hv_15 + (8.7952963054999111e-13)*bt_g1_12;
    hv_15 = hv_15 + (-9.1832258464208394e-10)*bt_g1_13;
    hv_15 = hv_15 + (-7.1577171967263098e-10)*bt_g1_14;
    hv_15 = hv_15 + (5.1035398129783971e-11)*bt_g1_15;
    hv_15 = hv_15 + (-4.549371643292055e-11)*bt_g1_16;
    hv_15 = hv_15 + (1.16650064607704e-10)*bt_g1_17;
    hv_15 = hv_15 + (9.5699010671523865e-07)*bt_g1_18;
    hv_15 = hv_15 + (4.8480067182943287e-11)*bt_g1_19;
    hv_15 = hv_15 + (-8.7734463791178108e-12)*bt_g1_20;
    hv_15 = hv_15 + (1.0853923554203504e-13)*bt_g1_21;
    hv_15 = hv_15 + (-1.6503359009240048e-12)*bt_g1_22;
    hv_15 = hv_15 + (2.9738245964057788e-14)*bt_g1_23;
    hv_15 = hv_15 + (1.513398615315964e-07)*bt_g1_24;
    hv_15 = hv_15 + (3.6727135221958918e-11)*bt_g1_25;
    hv_15 = hv_15 + (-3.4292854667050676e-10)*bt_g1_26;
    hv_15 = hv_15 + (-1.2214629481477335e-11)*bt_g1_27;
    hv_15 = hv_15 + (4.4933955223314115e-07)*bt_g1_28;
    hv_15 = hv_15 + (-5.7267503239533113e-11)*bt_g1_29;
    hv_15 = hv_15 + (4.6650783930290984e-11)*bt_g1_30;
    hv_15 = hv_15 + (-4.1281729553852009e-13)*bt_g1_31;
    hv_15 = hv_15 + (-6.5048669575795692e-12)*bt_g1_32;
    hv_15 = hv_15 + (-4.86272237754104e-11)*bt_g1_33;
    hv_15 = hv_15 + (3.2074321497377323e-12)*bt_g1_34;
    hv_15 = hv_15 + (1.2712630427513805e-11)*bt_g1_35;
    hv_15 = hv_15 + (-1.3838259704801459e-10)*bt_g1_36;
    hv_15 = hv_15 + (-4.2736512245733493e-11)*bt_g1_37;
    hv_15 = hv_15 + (-9.8534644621395273e-07)*bt_g1_38;
    hv_15 = hv_15 + (5.9105926533339903e-13)*bt_g1_39;
    hv_15 = hv_15 + (2.7123138804374669e-12)*bt_g1_40;
    hv_15 = hv_15 + (2.8600229823316781e-11)*bt_g1_41;
    hv_15 = hv_15 + (1.5757298243990192e-10)*bt_g1_42;
    hv_15 = hv_15 + (-3.2404162903301725e-13)*bt_g1_43;
    hv_15 = hv_15 + (3.6403226353481921e-13)*bt_g1_44;
    hv_15 = hv_15 + (3.0030655580048915e-06)*bt_g1_45;
    hv_15 = hv_15 + (-5.7281015868049234e-12)*bt_g1_46;
    hv_15 = hv_15 + (2.0518260484755912e-13)*bt_g1_47;
    hv_15 = hv_15 + (-1.9094257425189554e-12)*bt_g1_48;
    hv_15 = hv_15 + (9.0676717436760645e-13)*bt_g1_49;
    hv_15 = hv_15 + (5.9192208426428472e-12)*bt_g1_50;
    hv_15 = hv_15 + (-1.3805174451514413e-12)*bt_g1_51;
    hv_15 = hv_15 + (7.5805490357128136e-12)*bt_g1_52;
    hv_15 = hv_15 + (-3.0134433837147867e-10)*bt_g1_53;
    hv_15 = hv_15 + (-1.4335088671657559e-10)*bt_g1_54;
    hv_15 = hv_15 + (-9.6565030277551145e-13)*bt_g1_55;
    hv_15 = hv_15 + (2.6007949145423481e-06)*bt_g1_56;
    hv_15 = hv_15 + (-3.9294654335941814e-11)*bt_g1_57;
    hv_15 = hv_15 + (3.3027816592756665e-10)*bt_g1_58;
    hv_15 = hv_15 + (-4.8849813083506888e-13)*bt_g1_59;
    hv_15 = hv_15 + (-6.9927506274325424e-07)*bt_g1_60;
    hv_15 = hv_15 + (-8.5375543440457946e-12)*bt_g1_61;
    hv_15 = hv_15 + (-3.6655720125899904e-10)*bt_g1_62;
    hv_15 = hv_15 + (-3.3288477530035721e-10)*bt_g1_63;

    // Device-only head: n, v0, beta
    dh_l0_0 = 0.0025275670923292637;
    dh_l0_0 = dh_l0_0 + (-0.088200613856315613)*hpn_0;
    dh_l0_0 = dh_l0_0 + (0.00035197494435124099)*hpn_1;
    dh_l0_0 = dh_l0_0 + (-0.10556173324584961)*hpn_2;
    dh_l0_0 = dh_l0_0 + (0.18536776304244995)*hpn_3;
    dh_l0_0 = dh_l0_0 + (0.00035198431578464806)*hpn_4;
    dh_l0_0 = dh_l0_0 + (0.008348468691110611)*hpn_5;
    dh_l0_0 = dh_l0_0 + (-0.0072264084592461586)*hpn_6;
    dh_l0_0 = dh_l0_0 + (0.00035198740079067647)*hpn_7;
    dh_l0_0 = dh_l0_0 + (0.037204265594482422)*hpn_8;
    dh_l0_0 = dh_l0_0 + (0.00035198390833102167)*hpn_9;
    dh_l0_0 = dh_l0_0 + (0.00035197229590266943)*hpn_10;
    dh_l0_0 = dh_l0_0 + (0.048859730362892151)*hpn_11;
    dh_l0_0 = dh_l0_0 + (-0.0078083979897201061)*hpn_12;
    dh_l0_0 = dh_l0_0 + (-0.0021238545887172222)*hpn_13;
    dh_l0_0 = dh_l0_0 + (0.0003519805904943496)*hpn_14;
    dh_l0_0 = dh_l0_0 + (0.00035198350087739527)*hpn_15;
    dh_l0_1 = 0.075643740594387054;
    dh_l0_1 = dh_l0_1 + (0.011419855058193207)*hpn_0;
    dh_l0_1 = dh_l0_1 + (-0.0025848879013210535)*hpn_1;
    dh_l0_1 = dh_l0_1 + (-0.0072136269882321358)*hpn_2;
    dh_l0_1 = dh_l0_1 + (-0.019862761721014977)*hpn_3;
    dh_l0_1 = dh_l0_1 + (-0.002584847854450345)*hpn_4;
    dh_l0_1 = dh_l0_1 + (0.036413908004760742)*hpn_5;
    dh_l0_1 = dh_l0_1 + (-0.038248259574174881)*hpn_6;
    dh_l0_1 = dh_l0_1 + (-0.0025848569348454475)*hpn_7;
    dh_l0_1 = dh_l0_1 + (0.13861195743083954)*hpn_8;
    dh_l0_1 = dh_l0_1 + (-0.0025848785880953074)*hpn_9;
    dh_l0_1 = dh_l0_1 + (-0.0025848764926195145)*hpn_10;
    dh_l0_1 = dh_l0_1 + (-0.28123670816421509)*hpn_11;
    dh_l0_1 = dh_l0_1 + (-0.043395139276981354)*hpn_12;
    dh_l0_1 = dh_l0_1 + (0.018459446728229523)*hpn_13;
    dh_l0_1 = dh_l0_1 + (-0.0025848592631518841)*hpn_14;
    dh_l0_1 = dh_l0_1 + (-0.0025848837103694677)*hpn_15;
    dh_l0_2 = -0.029343472793698311;
    dh_l0_2 = dh_l0_2 + (0.015340019017457962)*hpn_0;
    dh_l0_2 = dh_l0_2 + (-0.0025422484613955021)*hpn_1;
    dh_l0_2 = dh_l0_2 + (-0.019117545336484909)*hpn_2;
    dh_l0_2 = dh_l0_2 + (0.022429749369621277)*hpn_3;
    dh_l0_2 = dh_l0_2 + (-0.0025422500912100077)*hpn_4;
    dh_l0_2 = dh_l0_2 + (0.052838966250419617)*hpn_5;
    dh_l0_2 = dh_l0_2 + (-0.024344334378838539)*hpn_6;
    dh_l0_2 = dh_l0_2 + (-0.0025422426406294107)*hpn_7;
    dh_l0_2 = dh_l0_2 + (-0.076504111289978027)*hpn_8;
    dh_l0_2 = dh_l0_2 + (-0.0025422507897019386)*hpn_9;
    dh_l0_2 = dh_l0_2 + (-0.0025422589387744665)*hpn_10;
    dh_l0_2 = dh_l0_2 + (-0.021831391379237175)*hpn_11;
    dh_l0_2 = dh_l0_2 + (0.031146440654993057)*hpn_12;
    dh_l0_2 = dh_l0_2 + (0.047769881784915924)*hpn_13;
    dh_l0_2 = dh_l0_2 + (-0.0025422535836696625)*hpn_14;
    dh_l0_2 = dh_l0_2 + (-0.0025422424077987671)*hpn_15;
    dh_l0_3 = -0.012161234393715858;
    dh_l0_3 = dh_l0_3 + (0.0033007736783474684)*hpn_0;
    dh_l0_3 = dh_l0_3 + (-0.00033737460034899414)*hpn_1;
    dh_l0_3 = dh_l0_3 + (-0.01766253262758255)*hpn_2;
    dh_l0_3 = dh_l0_3 + (0.009683903306722641)*hpn_3;
    dh_l0_3 = dh_l0_3 + (-0.00033737215562723577)*hpn_4;
    dh_l0_3 = dh_l0_3 + (0.0156105887144804)*hpn_5;
    dh_l0_3 = dh_l0_3 + (-0.0015658123884350061)*hpn_6;
    dh_l0_3 = dh_l0_3 + (-0.00033737081685103476)*hpn_7;
    dh_l0_3 = dh_l0_3 + (0.0079233571887016296)*hpn_8;
    dh_l0_3 = dh_l0_3 + (-0.00033737425110302866)*hpn_9;
    dh_l0_3 = dh_l0_3 + (-0.0003373750951141119)*hpn_10;
    dh_l0_3 = dh_l0_3 + (-0.013429396785795689)*hpn_11;
    dh_l0_3 = dh_l0_3 + (-0.0058098896406590939)*hpn_12;
    dh_l0_3 = dh_l0_3 + (0.0039200056344270706)*hpn_13;
    dh_l0_3 = dh_l0_3 + (-0.00033737340709194541)*hpn_14;
    dh_l0_3 = dh_l0_3 + (-0.0003373731451574713)*hpn_15;
    dh_l0_4 = -0.011190340854227543;
    dh_l0_4 = dh_l0_4 + (0.0077446391806006432)*hpn_0;
    dh_l0_4 = dh_l0_4 + (7.822825136827305e-05)*hpn_1;
    dh_l0_4 = dh_l0_4 + (-0.013591629453003407)*hpn_2;
    dh_l0_4 = dh_l0_4 + (-0.00067844917066395283)*hpn_3;
    dh_l0_4 = dh_l0_4 + (7.8229975770227611e-05)*hpn_4;
    dh_l0_4 = dh_l0_4 + (0.0069588967598974705)*hpn_5;
    dh_l0_4 = dh_l0_4 + (0.001381457201205194)*hpn_6;
    dh_l0_4 = dh_l0_4 + (7.8229692007880658e-05)*hpn_7;
    dh_l0_4 = dh_l0_4 + (0.020451519638299942)*hpn_8;
    dh_l0_4 = dh_l0_4 + (7.8228855272755027e-05)*hpn_9;
    dh_l0_4 = dh_l0_4 + (7.8228389611467719e-05)*hpn_10;
    dh_l0_4 = dh_l0_4 + (-0.012737938202917576)*hpn_11;
    dh_l0_4 = dh_l0_4 + (-0.010273967869579792)*hpn_12;
    dh_l0_4 = dh_l0_4 + (-0.0065906736999750137)*hpn_13;
    dh_l0_4 = dh_l0_4 + (7.8229728387668729e-05)*hpn_14;
    dh_l0_4 = dh_l0_4 + (7.822825136827305e-05)*hpn_15;
    dh_l0_5 = -0.040915273129940033;
    dh_l0_5 = dh_l0_5 + (0.053897667676210403)*hpn_0;
    dh_l0_5 = dh_l0_5 + (-0.0029750170651823282)*hpn_1;
    dh_l0_5 = dh_l0_5 + (-0.023241383954882622)*hpn_2;
    dh_l0_5 = dh_l0_5 + (-0.0036714884918183088)*hpn_3;
    dh_l0_5 = dh_l0_5 + (-0.0029750242829322815)*hpn_4;
    dh_l0_5 = dh_l0_5 + (0.017237711697816849)*hpn_5;
    dh_l0_5 = dh_l0_5 + (-0.063980713486671448)*hpn_6;
    dh_l0_5 = dh_l0_5 + (-0.0029750105459243059)*hpn_7;
    dh_l0_5 = dh_l0_5 + (-0.063420549035072327)*hpn_8;
    dh_l0_5 = dh_l0_5 + (-0.0029750240501016378)*hpn_9;
    dh_l0_5 = dh_l0_5 + (-0.0029750256799161434)*hpn_10;
    dh_l0_5 = dh_l0_5 + (-0.0028811842203140259)*hpn_11;
    dh_l0_5 = dh_l0_5 + (0.051484767347574234)*hpn_12;
    dh_l0_5 = dh_l0_5 + (0.015824215486645699)*hpn_13;
    dh_l0_5 = dh_l0_5 + (-0.0029750321991741657)*hpn_14;
    dh_l0_5 = dh_l0_5 + (-0.0029750121757388115)*hpn_15;
    dh_l0_6 = -0.011182731948792934;
    dh_l0_6 = dh_l0_6 + (0.0077831922098994255)*hpn_0;
    dh_l0_6 = dh_l0_6 + (8.174618415068835e-05)*hpn_1;
    dh_l0_6 = dh_l0_6 + (-0.013557008467614651)*hpn_2;
    dh_l0_6 = dh_l0_6 + (-0.000767083081882447)*hpn_3;
    dh_l0_6 = dh_l0_6 + (8.1748774391599e-05)*hpn_4;
    dh_l0_6 = dh_l0_6 + (0.0068851583637297153)*hpn_5;
    dh_l0_6 = dh_l0_6 + (0.0014059657696634531)*hpn_6;
    dh_l0_6 = dh_l0_6 + (8.1747777585405856e-05)*hpn_7;
    dh_l0_6 = dh_l0_6 + (0.020556068047881126)*hpn_8;
    dh_l0_6 = dh_l0_6 + (8.1746125943027437e-05)*hpn_9;
    dh_l0_6 = dh_l0_6 + (8.1746904470492154e-05)*hpn_10;
    dh_l0_6 = dh_l0_6 + (-0.012732122093439102)*hpn_11;
    dh_l0_6 = dh_l0_6 + (-0.010311317630112171)*hpn_12;
    dh_l0_6 = dh_l0_6 + (-0.006680740974843502)*hpn_13;
    dh_l0_6 = dh_l0_6 + (8.1747886724770069e-05)*hpn_14;
    dh_l0_6 = dh_l0_6 + (8.1746562500484288e-05)*hpn_15;
    dh_l0_7 = -0.01129611674696207;
    dh_l0_7 = dh_l0_7 + (0.0072234887629747391)*hpn_0;
    dh_l0_7 = dh_l0_7 + (3.061095776502043e-05)*hpn_1;
    dh_l0_7 = dh_l0_7 + (-0.01406621839851141)*hpn_2;
    dh_l0_7 = dh_l0_7 + (0.00052262574899941683)*hpn_3;
    dh_l0_7 = dh_l0_7 + (3.0612613045377657e-05)*hpn_4;
    dh_l0_7 = dh_l0_7 + (0.0079500749707221985)*hpn_5;
    dh_l0_7 = dh_l0_7 + (0.0010447917738929391)*hpn_6;
    dh_l0_7 = dh_l0_7 + (3.0612573027610779e-05)*hpn_7;
    dh_l0_7 = dh_l0_7 + (0.019038675352931023)*hpn_8;
    dh_l0_7 = dh_l0_7 + (3.0611368856625631e-05)*hpn_9;
    dh_l0_7 = dh_l0_7 + (3.0611165129812434e-05)*hpn_10;
    dh_l0_7 = dh_l0_7 + (-0.012813225388526917)*hpn_11;
    dh_l0_7 = dh_l0_7 + (-0.0097655979916453362)*hpn_12;
    dh_l0_7 = dh_l0_7 + (-0.0053796344436705112)*hpn_13;
    dh_l0_7 = dh_l0_7 + (3.0611772672273219e-05)*hpn_14;
    dh_l0_7 = dh_l0_7 + (3.0611085094278678e-05)*hpn_15;
    dh_l0_8 = -0.011163139715790749;
    dh_l0_8 = dh_l0_8 + (0.0079093342646956444)*hpn_0;
    dh_l0_8 = dh_l0_8 + (9.2269030574243516e-05)*hpn_1;
    dh_l0_8 = dh_l0_8 + (-0.013443352654576302)*hpn_2;
    dh_l0_8 = dh_l0_8 + (-0.0010462309001013637)*hpn_3;
    dh_l0_8 = dh_l0_8 + (9.2271424364298582e-05)*hpn_4;
    dh_l0_8 = dh_l0_8 + (0.0066677127033472061)*hpn_5;
    dh_l0_8 = dh_l0_8 + (0.0014811825240030885)*hpn_6;
    dh_l0_8 = dh_l0_8 + (9.2270194727461785e-05)*hpn_7;
    dh_l0_8 = dh_l0_8 + (0.020859712734818459)*hpn_8;
    dh_l0_8 = dh_l0_8 + (9.2270223831292242e-05)*hpn_9;
    dh_l0_8 = dh_l0_8 + (9.2269889137241989e-05)*hpn_10;
    dh_l0_8 = dh_l0_8 + (-0.012718599289655685)*hpn_11;
    dh_l0_8 = dh_l0_8 + (-0.010420139878988266)*hpn_12;
    dh_l0_8 = dh_l0_8 + (-0.0069479886442422867)*hpn_13;
    dh_l0_8 = dh_l0_8 + (9.2270522145554423e-05)*hpn_14;
    dh_l0_8 = dh_l0_8 + (9.2269692686386406e-05)*hpn_15;
    dh_l0_9 = -0.011181042529642582;
    dh_l0_9 = dh_l0_9 + (0.0077894856221973896)*hpn_0;
    dh_l0_9 = dh_l0_9 + (8.2393860793672502e-05)*hpn_1;
    dh_l0_9 = dh_l0_9 + (-0.013550837524235249)*hpn_2;
    dh_l0_9 = dh_l0_9 + (-0.00078273162944242358)*hpn_3;
    dh_l0_9 = dh_l0_9 + (8.2395934441592544e-05)*hpn_4;
    dh_l0_9 = dh_l0_9 + (0.0068719652481377125)*hpn_5;
    dh_l0_9 = dh_l0_9 + (0.0014107694150879979)*hpn_6;
    dh_l0_9 = dh_l0_9 + (8.2395177742000669e-05)*hpn_7;
    dh_l0_9 = dh_l0_9 + (0.020575501024723053)*hpn_8;
    dh_l0_9 = dh_l0_9 + (8.2394792116247118e-05)*hpn_9;
    dh_l0_9 = dh_l0_9 + (8.2394457422196865e-05)*hpn_10;
    dh_l0_9 = dh_l0_9 + (-0.012731164693832397)*hpn_11;
    dh_l0_9 = dh_l0_9 + (-0.010318676009774208)*hpn_12;
    dh_l0_9 = dh_l0_9 + (-0.0066968156024813652)*hpn_13;
    dh_l0_9 = dh_l0_9 + (8.2395192293915898e-05)*hpn_14;
    dh_l0_9 = dh_l0_9 + (8.2393591583240777e-05)*hpn_15;
    dh_l0_10 = -0.033208902925252914;
    dh_l0_10 = dh_l0_10 + (0.03476753830909729)*hpn_0;
    dh_l0_10 = dh_l0_10 + (-0.0023354932200163603)*hpn_1;
    dh_l0_10 = dh_l0_10 + (-0.0094801681116223335)*hpn_2;
    dh_l0_10 = dh_l0_10 + (-0.0024702057708054781)*hpn_3;
    dh_l0_10 = dh_l0_10 + (-0.0023354948498308659)*hpn_4;
    dh_l0_10 = dh_l0_10 + (0.041169863194227219)*hpn_5;
    dh_l0_10 = dh_l0_10 + (-0.029022244736552238)*hpn_6;
    dh_l0_10 = dh_l0_10 + (-0.0023354862350970507)*hpn_7;
    dh_l0_10 = dh_l0_10 + (-0.071548789739608765)*hpn_8;
    dh_l0_10 = dh_l0_10 + (-0.0023354960139840841)*hpn_9;
    dh_l0_10 = dh_l0_10 + (-0.0023354976437985897)*hpn_10;
    dh_l0_10 = dh_l0_10 + (-0.021767783910036087)*hpn_11;
    dh_l0_10 = dh_l0_10 + (0.035739194601774216)*hpn_12;
    dh_l0_10 = dh_l0_10 + (0.034719586372375488)*hpn_13;
    dh_l0_10 = dh_l0_10 + (-0.0023354946170002222)*hpn_14;
    dh_l0_10 = dh_l0_10 + (-0.0023354853037744761)*hpn_15;
    dh_l0_11 = -0.14591681957244873;
    dh_l0_11 = dh_l0_11 + (0.19676132500171661)*hpn_0;
    dh_l0_11 = dh_l0_11 + (0.012137546204030514)*hpn_1;
    dh_l0_11 = dh_l0_11 + (0.074278630316257477)*hpn_2;
    dh_l0_11 = dh_l0_11 + (-0.17557993531227112)*hpn_3;
    dh_l0_11 = dh_l0_11 + (0.012137500569224358)*hpn_4;
    dh_l0_11 = dh_l0_11 + (-0.052190139889717102)*hpn_5;
    dh_l0_11 = dh_l0_11 + (0.023863097652792931)*hpn_6;
    dh_l0_11 = dh_l0_11 + (0.012137517333030701)*hpn_7;
    dh_l0_11 = dh_l0_11 + (-0.052369244396686554)*hpn_8;
    dh_l0_11 = dh_l0_11 + (0.012137530371546745)*hpn_9;
    dh_l0_11 = dh_l0_11 + (0.012137556448578835)*hpn_10;
    dh_l0_11 = dh_l0_11 + (0.19655086100101471)*hpn_11;
    dh_l0_11 = dh_l0_11 + (-0.094742126762866974)*hpn_12;
    dh_l0_11 = dh_l0_11 + (0.049151238054037094)*hpn_13;
    dh_l0_11 = dh_l0_11 + (0.012137554585933685)*hpn_14;
    dh_l0_11 = dh_l0_11 + (0.012137532234191895)*hpn_15;
    dh_l0_12 = -0.011185944080352783;
    dh_l0_12 = dh_l0_12 + (0.0077625187113881111)*hpn_0;
    dh_l0_12 = dh_l0_12 + (8.0044403148349375e-05)*hpn_1;
    dh_l0_12 = dh_l0_12 + (-0.013575365766882896)*hpn_2;
    dh_l0_12 = dh_l0_12 + (-0.00072175561217591166)*hpn_3;
    dh_l0_12 = dh_l0_12 + (8.0046331277117133e-05)*hpn_4;
    dh_l0_12 = dh_l0_12 + (0.0069206715561449528)*hpn_5;
    dh_l0_12 = dh_l0_12 + (0.0013939971104264259)*hpn_6;
    dh_l0_12 = dh_l0_12 + (8.0045683716889471e-05)*hpn_7;
    dh_l0_12 = dh_l0_12 + (0.020506566390395164)*hpn_8;
    dh_l0_12 = dh_l0_12 + (8.0044992500916123e-05)*hpn_9;
    dh_l0_12 = dh_l0_12 + (8.004502160474658e-05)*hpn_10;
    dh_l0_12 = dh_l0_12 + (-0.012734368443489075)*hpn_11;
    dh_l0_12 = dh_l0_12 + (-0.010293941013514996)*hpn_12;
    dh_l0_12 = dh_l0_12 + (-0.006637202575802803)*hpn_13;
    dh_l0_12 = dh_l0_12 + (8.0045996583066881e-05)*hpn_14;
    dh_l0_12 = dh_l0_12 + (8.0044315836858004e-05)*hpn_15;
    dh_l0_13 = -0.011189494282007217;
    dh_l0_13 = dh_l0_13 + (0.0077482704073190689)*hpn_0;
    dh_l0_13 = dh_l0_13 + (7.8606419265270233e-05)*hpn_1;
    dh_l0_13 = dh_l0_13 + (-0.013588378205895424)*hpn_2;
    dh_l0_13 = dh_l0_13 + (-0.00068751903017982841)*hpn_3;
    dh_l0_13 = dh_l0_13 + (7.8608456533402205e-05)*hpn_4;
    dh_l0_13 = dh_l0_13 + (0.006951039656996727)*hpn_5;
    dh_l0_13 = dh_l0_13 + (0.0013840815518051386)*hpn_6;
    dh_l0_13 = dh_l0_13 + (7.8607954492326826e-05)*hpn_7;
    dh_l0_13 = dh_l0_13 + (0.020462961867451668)*hpn_8;
    dh_l0_13 = dh_l0_13 + (7.8606986789964139e-05)*hpn_9;
    dh_l0_13 = dh_l0_13 + (7.8607721661683172e-05)*hpn_10;
    dh_l0_13 = dh_l0_13 + (-0.012737183831632137)*hpn_11;
    dh_l0_13 = dh_l0_13 + (-0.010278101079165936)*hpn_12;
    dh_l0_13 = dh_l0_13 + (-0.0066002556122839451)*hpn_13;
    dh_l0_13 = dh_l0_13 + (7.8607838077004999e-05)*hpn_14;
    dh_l0_13 = dh_l0_13 + (7.8606455645058304e-05)*hpn_15;
    dh_l0_14 = -0.047444280236959457;
    dh_l0_14 = dh_l0_14 + (0.24709655344486237)*hpn_0;
    dh_l0_14 = dh_l0_14 + (-0.0066804112866520882)*hpn_1;
    dh_l0_14 = dh_l0_14 + (-0.04203445091843605)*hpn_2;
    dh_l0_14 = dh_l0_14 + (-0.083222463726997375)*hpn_3;
    dh_l0_14 = dh_l0_14 + (-0.0066803949885070324)*hpn_4;
    dh_l0_14 = dh_l0_14 + (-0.11865627020597458)*hpn_5;
    dh_l0_14 = dh_l0_14 + (-0.27839109301567078)*hpn_6;
    dh_l0_14 = dh_l0_14 + (-0.0066803949885070324)*hpn_7;
    dh_l0_14 = dh_l0_14 + (-0.015886548906564713)*hpn_8;
    dh_l0_14 = dh_l0_14 + (-0.0066803824156522751)*hpn_9;
    dh_l0_14 = dh_l0_14 + (-0.006680408027023077)*hpn_10;
    dh_l0_14 = dh_l0_14 + (0.11375845968723297)*hpn_11;
    dh_l0_14 = dh_l0_14 + (0.15033100545406342)*hpn_12;
    dh_l0_14 = dh_l0_14 + (-0.1000218465924263)*hpn_13;
    dh_l0_14 = dh_l0_14 + (-0.0066804005764424801)*hpn_14;
    dh_l0_14 = dh_l0_14 + (-0.0066803894005715847)*hpn_15;
    dh_l0_15 = -0.011202595196664333;
    dh_l0_15 = dh_l0_15 + (0.0076892166398465633)*hpn_0;
    dh_l0_15 = dh_l0_15 + (7.3023024015128613e-05)*hpn_1;
    dh_l0_15 = dh_l0_15 + (-0.013642462901771069)*hpn_2;
    dh_l0_15 = dh_l0_15 + (-0.00054895645007491112)*hpn_3;
    dh_l0_15 = dh_l0_15 + (7.3025279561989009e-05)*hpn_4;
    dh_l0_15 = dh_l0_15 + (0.0070673529990017414)*hpn_5;
    dh_l0_15 = dh_l0_15 + (0.0013447096571326256)*hpn_6;
    dh_l0_15 = dh_l0_15 + (7.302442827494815e-05)*hpn_7;
    dh_l0_15 = dh_l0_15 + (0.020296256989240646)*hpn_8;
    dh_l0_15 = dh_l0_15 + (7.3023904405999929e-05)*hpn_9;
    dh_l0_15 = dh_l0_15 + (7.3023940785788e-05)*hpn_10;
    dh_l0_15 = dh_l0_15 + (-0.012746251188218594)*hpn_11;
    dh_l0_15 = dh_l0_15 + (-0.010217691771686077)*hpn_12;
    dh_l0_15 = dh_l0_15 + (-0.0064582531340420246)*hpn_13;
    dh_l0_15 = dh_l0_15 + (7.3025170422624797e-05)*hpn_14;
    dh_l0_15 = dh_l0_15 + (7.3023518780246377e-05)*hpn_15;
    dh_l0_16 = -0.011178339831531048;
    dh_l0_16 = dh_l0_16 + (0.0078014740720391273)*hpn_0;
    dh_l0_16 = dh_l0_16 + (8.3543767686933279e-05)*hpn_1;
    dh_l0_16 = dh_l0_16 + (-0.013539963401854038)*hpn_2;
    dh_l0_16 = dh_l0_16 + (-0.00081077491631731391)*hpn_3;
    dh_l0_16 = dh_l0_16 + (8.3545397501438856e-05)*hpn_4;
    dh_l0_16 = dh_l0_16 + (0.0068479301407933235)*hpn_5;
    dh_l0_16 = dh_l0_16 + (0.0014187749475240707)*hpn_6;
    dh_l0_16 = dh_l0_16 + (8.3544640801846981e-05)*hpn_7;
    dh_l0_16 = dh_l0_16 + (0.020609945058822632)*hpn_8;
    dh_l0_16 = dh_l0_16 + (8.3544196968432516e-05)*hpn_9;
    dh_l0_16 = dh_l0_16 + (8.3543876826297492e-05)*hpn_10;
    dh_l0_16 = dh_l0_16 + (-0.012728902511298656)*hpn_11;
    dh_l0_16 = dh_l0_16 + (-0.010331051424145699)*hpn_12;
    dh_l0_16 = dh_l0_16 + (-0.0067261806689202785)*hpn_13;
    dh_l0_16 = dh_l0_16 + (8.3544538938440382e-05)*hpn_14;
    dh_l0_16 = dh_l0_16 + (8.3543563960120082e-05)*hpn_15;
    dh_l0_17 = -0.011180088855326176;
    dh_l0_17 = dh_l0_17 + (0.007795404177159071)*hpn_0;
    dh_l0_17 = dh_l0_17 + (8.2893231592606753e-05)*hpn_1;
    dh_l0_17 = dh_l0_17 + (-0.013545528054237366)*hpn_2;
    dh_l0_17 = dh_l0_17 + (-0.00079579622251912951)*hpn_3;
    dh_l0_17 = dh_l0_17 + (8.2894890510942787e-05)*hpn_4;
    dh_l0_17 = dh_l0_17 + (0.0068618068471550941)*hpn_5;
    dh_l0_17 = dh_l0_17 + (0.0014143312582746148)*hpn_6;
    dh_l0_17 = dh_l0_17 + (8.2893609942402691e-05)*hpn_7;
    dh_l0_17 = dh_l0_17 + (0.020589748397469521)*hpn_8;
    dh_l0_17 = dh_l0_17 + (8.2893362559843808e-05)*hpn_9;
    dh_l0_17 = dh_l0_17 + (8.2893959188368171e-05)*hpn_10;
    dh_l0_17 = dh_l0_17 + (-0.012730447575449944)*hpn_11;
    dh_l0_17 = dh_l0_17 + (-0.010323892347514629)*hpn_12;
    dh_l0_17 = dh_l0_17 + (-0.0067093838006258011)*hpn_13;
    dh_l0_17 = dh_l0_17 + (8.2893799117300659e-05)*hpn_14;
    dh_l0_17 = dh_l0_17 + (8.2893042417708784e-05)*hpn_15;
    dh_l0_18 = -0.045839015394449234;
    dh_l0_18 = dh_l0_18 + (0.097576767206192017)*hpn_0;
    dh_l0_18 = dh_l0_18 + (-0.0030053507070988417)*hpn_1;
    dh_l0_18 = dh_l0_18 + (-0.006900666281580925)*hpn_2;
    dh_l0_18 = dh_l0_18 + (-0.045892439782619476)*hpn_3;
    dh_l0_18 = dh_l0_18 + (-0.0030053483787924051)*hpn_4;
    dh_l0_18 = dh_l0_18 + (-0.0069707836955785751)*hpn_5;
    dh_l0_18 = dh_l0_18 + (-0.083580493927001953)*hpn_6;
    dh_l0_18 = dh_l0_18 + (-0.0030053409282118082)*hpn_7;
    dh_l0_18 = dh_l0_18 + (-0.059920407831668854)*hpn_8;
    dh_l0_18 = dh_l0_18 + (-0.0030053446535021067)*hpn_9;
    dh_l0_18 = dh_l0_18 + (-0.0030053535010665655)*hpn_10;
    dh_l0_18 = dh_l0_18 + (0.0046111145056784153)*hpn_11;
    dh_l0_18 = dh_l0_18 + (0.068102255463600159)*hpn_12;
    dh_l0_18 = dh_l0_18 + (-0.010883821174502373)*hpn_13;
    dh_l0_18 = dh_l0_18 + (-0.0030053530354052782)*hpn_14;
    dh_l0_18 = dh_l0_18 + (-0.0030053402297198772)*hpn_15;
    dh_l0_19 = 0.019886123016476631;
    dh_l0_19 = dh_l0_19 + (0.1610320508480072)*hpn_0;
    dh_l0_19 = dh_l0_19 + (-0.0015087848296388984)*hpn_1;
    dh_l0_19 = dh_l0_19 + (-0.15912766754627228)*hpn_2;
    dh_l0_19 = dh_l0_19 + (0.2373821884393692)*hpn_3;
    dh_l0_19 = dh_l0_19 + (-0.001508767600171268)*hpn_4;
    dh_l0_19 = dh_l0_19 + (-0.0084185926243662834)*hpn_5;
    dh_l0_19 = dh_l0_19 + (-0.34459519386291504)*hpn_6;
    dh_l0_19 = dh_l0_19 + (-0.0015087781939655542)*hpn_7;
    dh_l0_19 = dh_l0_19 + (0.080659426748752594)*hpn_8;
    dh_l0_19 = dh_l0_19 + (-0.0015087707433849573)*hpn_9;
    dh_l0_19 = dh_l0_19 + (-0.0015087876236066222)*hpn_10;
    dh_l0_19 = dh_l0_19 + (0.077522069215774536)*hpn_11;
    dh_l0_19 = dh_l0_19 + (-0.049147602170705795)*hpn_12;
    dh_l0_19 = dh_l0_19 + (0.037302952259778976)*hpn_13;
    dh_l0_19 = dh_l0_19 + (-0.0015087828505784273)*hpn_14;
    dh_l0_19 = dh_l0_19 + (-0.0015087793581187725)*hpn_15;
    dh_l0_20 = -0.17315676808357239;
    dh_l0_20 = dh_l0_20 + (0.11556895822286606)*hpn_0;
    dh_l0_20 = dh_l0_20 + (0.0097335530444979668)*hpn_1;
    dh_l0_20 = dh_l0_20 + (-0.13638021051883698)*hpn_2;
    dh_l0_20 = dh_l0_20 + (0.026218386366963387)*hpn_3;
    dh_l0_20 = dh_l0_20 + (0.0097335511818528175)*hpn_4;
    dh_l0_20 = dh_l0_20 + (-0.020849041640758514)*hpn_5;
    dh_l0_20 = dh_l0_20 + (0.056861035525798798)*hpn_6;
    dh_l0_20 = dh_l0_20 + (0.0097335455939173698)*hpn_7;
    dh_l0_20 = dh_l0_20 + (0.021385183557868004)*hpn_8;
    dh_l0_20 = dh_l0_20 + (0.009733542799949646)*hpn_9;
    dh_l0_20 = dh_l0_20 + (0.0097335539758205414)*hpn_10;
    dh_l0_20 = dh_l0_20 + (0.021574275568127632)*hpn_11;
    dh_l0_20 = dh_l0_20 + (-0.033041946589946747)*hpn_12;
    dh_l0_20 = dh_l0_20 + (-0.017058702185750008)*hpn_13;
    dh_l0_20 = dh_l0_20 + (0.0097335390746593475)*hpn_14;
    dh_l0_20 = dh_l0_20 + (0.0097335511818528175)*hpn_15;
    dh_l0_21 = -0.011193136684596539;
    dh_l0_21 = dh_l0_21 + (0.0077277040109038353)*hpn_0;
    dh_l0_21 = dh_l0_21 + (7.6804382842965424e-05)*hpn_1;
    dh_l0_21 = dh_l0_21 + (-0.013607022352516651)*hpn_2;
    dh_l0_21 = dh_l0_21 + (-0.00064091826789081097)*hpn_3;
    dh_l0_21 = dh_l0_21 + (7.6806296419817954e-05)*hpn_4;
    dh_l0_21 = dh_l0_21 + (0.0069882692769169807)*hpn_5;
    dh_l0_21 = dh_l0_21 + (0.0013712224317714572)*hpn_6;
    dh_l0_21 = dh_l0_21 + (7.6805969001725316e-05)*hpn_7;
    dh_l0_21 = dh_l0_21 + (0.02041008323431015)*hpn_8;
    dh_l0_21 = dh_l0_21 + (7.6804681157227606e-05)*hpn_9;
    dh_l0_21 = dh_l0_21 + (7.6804557465948164e-05)*hpn_10;
    dh_l0_21 = dh_l0_21 + (-0.012739730067551136)*hpn_11;
    dh_l0_21 = dh_l0_21 + (-0.010259112343192101)*hpn_12;
    dh_l0_21 = dh_l0_21 + (-0.0065545514225959778)*hpn_13;
    dh_l0_21 = dh_l0_21 + (7.6805983553640544e-05)*hpn_14;
    dh_l0_21 = dh_l0_21 + (7.6804491982329637e-05)*hpn_15;
    dh_l0_22 = -0.011185784824192524;
    dh_l0_22 = dh_l0_22 + (0.0077643594704568386)*hpn_0;
    dh_l0_22 = dh_l0_22 + (8.0160614743363112e-05)*hpn_1;
    dh_l0_22 = dh_l0_22 + (-0.013573570176959038)*hpn_2;
    dh_l0_22 = dh_l0_22 + (-0.00072548276511952281)*hpn_3;
    dh_l0_22 = dh_l0_22 + (8.0162797530647367e-05)*hpn_4;
    dh_l0_22 = dh_l0_22 + (0.0069184466265141964)*hpn_5;
    dh_l0_22 = dh_l0_22 + (0.0013949995627626777)*hpn_6;
    dh_l0_22 = dh_l0_22 + (8.0162288213614374e-05)*hpn_7;
    dh_l0_22 = dh_l0_22 + (0.020509582012891769)*hpn_8;
    dh_l0_22 = dh_l0_22 + (8.0161560617852956e-05)*hpn_9;
    dh_l0_22 = dh_l0_22 + (8.0160760262515396e-05)*hpn_10;
    dh_l0_22 = dh_l0_22 + (-0.012734522111713886)*hpn_11;
    dh_l0_22 = dh_l0_22 + (-0.010295122861862183)*hpn_12;
    dh_l0_22 = dh_l0_22 + (-0.0066399537026882172)*hpn_13;
    dh_l0_22 = dh_l0_22 + (8.0161997175309807e-05)*hpn_14;
    dh_l0_22 = dh_l0_22 + (8.0160702054854482e-05)*hpn_15;
    dh_l0_23 = -0.011184018105268478;
    dh_l0_23 = dh_l0_23 + (0.0077715320512652397)*hpn_0;
    dh_l0_23 = dh_l0_23 + (8.0858779256232083e-05)*hpn_1;
    dh_l0_23 = dh_l0_23 + (-0.013567160815000534)*hpn_2;
    dh_l0_23 = dh_l0_23 + (-0.00074239145033061504)*hpn_3;
    dh_l0_23 = dh_l0_23 + (8.0861049355007708e-05)*hpn_4;
    dh_l0_23 = dh_l0_23 + (0.0069038178771734238)*hpn_5;
    dh_l0_23 = dh_l0_23 + (0.0013997859787195921)*hpn_6;
    dh_l0_23 = dh_l0_23 + (8.0860663729254156e-05)*hpn_7;
    dh_l0_23 = dh_l0_23 + (0.020530864596366882)*hpn_8;
    dh_l0_23 = dh_l0_23 + (8.0860030720941722e-05)*hpn_9;
    dh_l0_23 = dh_l0_23 + (8.0859848822001368e-05)*hpn_10;
    dh_l0_23 = dh_l0_23 + (-0.012733075767755508)*hpn_11;
    dh_l0_23 = dh_l0_23 + (-0.010302580893039703)*hpn_12;
    dh_l0_23 = dh_l0_23 + (-0.0066577964462339878)*hpn_13;
    dh_l0_23 = dh_l0_23 + (8.0860416346695274e-05)*hpn_14;
    dh_l0_23 = dh_l0_23 + (8.0859485024120659e-05)*hpn_15;
    dh_l0_24 = 0.34073147177696228;
    dh_l0_24 = dh_l0_24 + (-0.12932087481021881)*hpn_0;
    dh_l0_24 = dh_l0_24 + (-0.0048843333497643471)*hpn_1;
    dh_l0_24 = dh_l0_24 + (0.10522466897964478)*hpn_2;
    dh_l0_24 = dh_l0_24 + (-0.1174202561378479)*hpn_3;
    dh_l0_24 = dh_l0_24 + (-0.0048843170516192913)*hpn_4;
    dh_l0_24 = dh_l0_24 + (0.051338966935873032)*hpn_5;
    dh_l0_24 = dh_l0_24 + (-0.034086965024471283)*hpn_6;
    dh_l0_24 = dh_l0_24 + (-0.004884322639554739)*hpn_7;
    dh_l0_24 = dh_l0_24 + (0.066734865307807922)*hpn_8;
    dh_l0_24 = dh_l0_24 + (-0.004884304478764534)*hpn_9;
    dh_l0_24 = dh_l0_24 + (-0.0048843179829418659)*hpn_10;
    dh_l0_24 = dh_l0_24 + (0.13850842416286469)*hpn_11;
    dh_l0_24 = dh_l0_24 + (-0.087010592222213745)*hpn_12;
    dh_l0_24 = dh_l0_24 + (0.0036346195265650749)*hpn_13;
    dh_l0_24 = dh_l0_24 + (-0.0048843063414096832)*hpn_14;
    dh_l0_24 = dh_l0_24 + (-0.0048843375407159328)*hpn_15;
    dh_l0_25 = -0.011179153807461262;
    dh_l0_25 = dh_l0_25 + (0.0077979424968361855)*hpn_0;
    dh_l0_25 = dh_l0_25 + (8.3181235822848976e-05)*hpn_1;
    dh_l0_25 = dh_l0_25 + (-0.013543191365897655)*hpn_2;
    dh_l0_25 = dh_l0_25 + (-0.0008021777612157166)*hpn_3;
    dh_l0_25 = dh_l0_25 + (8.3183040260337293e-05)*hpn_4;
    dh_l0_25 = dh_l0_25 + (0.0068556061014533043)*hpn_5;
    dh_l0_25 = dh_l0_25 + (0.0014162809820845723)*hpn_6;
    dh_l0_25 = dh_l0_25 + (8.3182821981608868e-05)*hpn_7;
    dh_l0_25 = dh_l0_25 + (0.020598612725734711)*hpn_8;
    dh_l0_25 = dh_l0_25 + (8.3181883383076638e-05)*hpn_9;
    dh_l0_25 = dh_l0_25 + (8.318204345414415e-05)*hpn_10;
    dh_l0_25 = dh_l0_25 + (-0.012729702517390251)*hpn_11;
    dh_l0_25 = dh_l0_25 + (-0.010327072814106941)*hpn_12;
    dh_l0_25 = dh_l0_25 + (-0.0067168679088354111)*hpn_13;
    dh_l0_25 = dh_l0_25 + (8.3183025708422065e-05)*hpn_14;
    dh_l0_25 = dh_l0_25 + (8.3181126683484763e-05)*hpn_15;
    dh_l0_26 = -0.011181953363120556;
    dh_l0_26 = dh_l0_26 + (0.0077824410982429981)*hpn_0;
    dh_l0_26 = dh_l0_26 + (8.1835765740834177e-05)*hpn_1;
    dh_l0_26 = dh_l0_26 + (-0.013557316735386848)*hpn_2;
    dh_l0_26 = dh_l0_26 + (-0.00076741835800930858)*hpn_3;
    dh_l0_26 = dh_l0_26 + (8.1837613834068179e-05)*hpn_4;
    dh_l0_26 = dh_l0_26 + (0.0068835066631436348)*hpn_5;
    dh_l0_26 = dh_l0_26 + (0.0014066834701225162)*hpn_6;
    dh_l0_26 = dh_l0_26 + (8.183693717001006e-05)*hpn_7;
    dh_l0_26 = dh_l0_26 + (0.020559702068567276)*hpn_8;
    dh_l0_26 = dh_l0_26 + (8.1836435128934681e-05)*hpn_9;
    dh_l0_26 = dh_l0_26 + (8.1836617027875036e-05)*hpn_10;
    dh_l0_26 = dh_l0_26 + (-0.012731736525893211)*hpn_11;
    dh_l0_26 = dh_l0_26 + (-0.010312872938811779)*hpn_12;
    dh_l0_26 = dh_l0_26 + (-0.0066826785914599895)*hpn_13;
    dh_l0_26 = dh_l0_26 + (8.1837046309374273e-05)*hpn_14;
    dh_l0_26 = dh_l0_26 + (8.1836151366587728e-05)*hpn_15;
    dh_l0_27 = -0.011192349717020988;
    dh_l0_27 = dh_l0_27 + (0.0077354321256279945)*hpn_0;
    dh_l0_27 = dh_l0_27 + (7.7361859439406544e-05)*hpn_1;
    dh_l0_27 = dh_l0_27 + (-0.013600194826722145)*hpn_2;
    dh_l0_27 = dh_l0_27 + (-0.0006569145480170846)*hpn_3;
    dh_l0_27 = dh_l0_27 + (7.7363474701996893e-05)*hpn_4;
    dh_l0_27 = dh_l0_27 + (0.0069769346155226231)*hpn_5;
    dh_l0_27 = dh_l0_27 + (0.0013753260718658566)*hpn_6;
    dh_l0_27 = dh_l0_27 + (7.736282714176923e-05)*hpn_7;
    dh_l0_27 = dh_l0_27 + (0.020425589755177498)*hpn_8;
    dh_l0_27 = dh_l0_27 + (7.736256520729512e-05)*hpn_9;
    dh_l0_27 = dh_l0_27 + (7.7362230513244867e-05)*hpn_10;
    dh_l0_27 = dh_l0_27 + (-0.012739341706037521)*hpn_11;
    dh_l0_27 = dh_l0_27 + (-0.010264497250318527)*hpn_12;
    dh_l0_27 = dh_l0_27 + (-0.0065686595626175404)*hpn_13;
    dh_l0_27 = dh_l0_27 + (7.7363234595395625e-05)*hpn_14;
    dh_l0_27 = dh_l0_27 + (7.7361808507703245e-05)*hpn_15;
    dh_l0_28 = 0.28903409838676453;
    dh_l0_28 = dh_l0_28 + (0.11413488537073135)*hpn_0;
    dh_l0_28 = dh_l0_28 + (0.0010933316079899669)*hpn_1;
    dh_l0_28 = dh_l0_28 + (0.13699766993522644)*hpn_2;
    dh_l0_28 = dh_l0_28 + (-0.25239554047584534)*hpn_3;
    dh_l0_28 = dh_l0_28 + (0.0010933126322925091)*hpn_4;
    dh_l0_28 = dh_l0_28 + (-0.0055302535183727741)*hpn_5;
    dh_l0_28 = dh_l0_28 + (-0.17733661830425262)*hpn_6;
    dh_l0_28 = dh_l0_28 + (0.0010932889999821782)*hpn_7;
    dh_l0_28 = dh_l0_28 + (-0.041128825396299362)*hpn_8;
    dh_l0_28 = dh_l0_28 + (0.0010933176381513476)*hpn_9;
    dh_l0_28 = dh_l0_28 + (0.0010933437151834369)*hpn_10;
    dh_l0_28 = dh_l0_28 + (0.21533510088920593)*hpn_11;
    dh_l0_28 = dh_l0_28 + (-0.026468098163604736)*hpn_12;
    dh_l0_28 = dh_l0_28 + (-0.024169458076357841)*hpn_13;
    dh_l0_28 = dh_l0_28 + (0.0010933114681392908)*hpn_14;
    dh_l0_28 = dh_l0_28 + (0.0010933068115264177)*hpn_15;
    dh_l0_29 = 0.24082489311695099;
    dh_l0_29 = dh_l0_29 + (-0.18933306634426117)*hpn_0;
    dh_l0_29 = dh_l0_29 + (0.00090059149079024792)*hpn_1;
    dh_l0_29 = dh_l0_29 + (0.03659004345536232)*hpn_2;
    dh_l0_29 = dh_l0_29 + (0.035780351608991623)*hpn_3;
    dh_l0_29 = dh_l0_29 + (0.00090058211935684085)*hpn_4;
    dh_l0_29 = dh_l0_29 + (-0.090628184378147125)*hpn_5;
    dh_l0_29 = dh_l0_29 + (0.23990999162197113)*hpn_6;
    dh_l0_29 = dh_l0_29 + (0.0009005806059576571)*hpn_7;
    dh_l0_29 = dh_l0_29 + (-0.10353097319602966)*hpn_8;
    dh_l0_29 = dh_l0_29 + (0.00090060086222365499)*hpn_9;
    dh_l0_29 = dh_l0_29 + (0.0009006005129776895)*hpn_10;
    dh_l0_29 = dh_l0_29 + (0.1039033904671669)*hpn_11;
    dh_l0_29 = dh_l0_29 + (-0.0064269262365996838)*hpn_12;
    dh_l0_29 = dh_l0_29 + (0.054607350379228592)*hpn_13;
    dh_l0_29 = dh_l0_29 + (0.00090058433124795556)*hpn_14;
    dh_l0_29 = dh_l0_29 + (0.00090058898786082864)*hpn_15;
    dh_l0_30 = -0.011186319403350353;
    dh_l0_30 = dh_l0_30 + (0.0077619906514883041)*hpn_0;
    dh_l0_30 = dh_l0_30 + (7.9938836279325187e-05)*hpn_1;
    dh_l0_30 = dh_l0_30 + (-0.013575905933976173)*hpn_2;
    dh_l0_30 = dh_l0_30 + (-0.00071981677319854498)*hpn_3;
    dh_l0_30 = dh_l0_30 + (7.9940837167669088e-05)*hpn_4;
    dh_l0_30 = dh_l0_30 + (0.0069229793734848499)*hpn_5;
    dh_l0_30 = dh_l0_30 + (0.0013933010632172227)*hpn_6;
    dh_l0_30 = dh_l0_30 + (7.9939913121052086e-05)*hpn_7;
    dh_l0_30 = dh_l0_30 + (0.020503047853708267)*hpn_8;
    dh_l0_30 = dh_l0_30 + (7.9939185525290668e-05)*hpn_9;
    dh_l0_30 = dh_l0_30 + (7.9938829003367573e-05)*hpn_10;
    dh_l0_30 = dh_l0_30 + (-0.012734699063003063)*hpn_11;
    dh_l0_30 = dh_l0_30 + (-0.010292577557265759)*hpn_12;
    dh_l0_30 = dh_l0_30 + (-0.0066345040686428547)*hpn_13;
    dh_l0_30 = dh_l0_30 + (7.9939985880628228e-05)*hpn_14;
    dh_l0_30 = dh_l0_30 + (7.9939083661884069e-05)*hpn_15;
    dh_l0_31 = -0.011203857138752937;
    dh_l0_31 = dh_l0_31 + (0.00767497718334198)*hpn_0;
    dh_l0_31 = dh_l0_31 + (7.1959715569391847e-05)*hpn_1;
    dh_l0_31 = dh_l0_31 + (-0.013655092567205429)*hpn_2;
    dh_l0_31 = dh_l0_31 + (-0.00051902030827477574)*hpn_3;
    dh_l0_31 = dh_l0_31 + (7.196168735390529e-05)*hpn_4;
    dh_l0_31 = dh_l0_31 + (0.0070890369825065136)*hpn_5;
    dh_l0_31 = dh_l0_31 + (0.0013369688531383872)*hpn_6;
    dh_l0_31 = dh_l0_31 + (7.1960836066864431e-05)*hpn_7;
    dh_l0_31 = dh_l0_31 + (0.020266449078917503)*hpn_8;
    dh_l0_31 = dh_l0_31 + (7.1960479544941336e-05)*hpn_9;
    dh_l0_31 = dh_l0_31 + (7.1960297646000981e-05)*hpn_10;
    dh_l0_31 = dh_l0_31 + (-0.012747427448630333)*hpn_11;
    dh_l0_31 = dh_l0_31 + (-0.010207191109657288)*hpn_12;
    dh_l0_31 = dh_l0_31 + (-0.0064314142800867558)*hpn_13;
    dh_l0_31 = dh_l0_31 + (7.1961134381126612e-05)*hpn_14;
    dh_l0_31 = dh_l0_31 + (7.1959795604925603e-05)*hpn_15;
    dh0_mean = (dh_l0_0 + dh_l0_1 + dh_l0_2 + dh_l0_3 + dh_l0_4 + dh_l0_5 + dh_l0_6 + dh_l0_7 + dh_l0_8 + dh_l0_9 + dh_l0_10 + dh_l0_11 + dh_l0_12 + dh_l0_13 + dh_l0_14 + dh_l0_15 + dh_l0_16 + dh_l0_17 + dh_l0_18 + dh_l0_19 + dh_l0_20 + dh_l0_21 + dh_l0_22 + dh_l0_23 + dh_l0_24 + dh_l0_25 + dh_l0_26 + dh_l0_27 + dh_l0_28 + dh_l0_29 + dh_l0_30 + dh_l0_31) / 32;
    dh0_var = (((dh_l0_0) - dh0_mean)*((dh_l0_0) - dh0_mean) + ((dh_l0_1) - dh0_mean)*((dh_l0_1) - dh0_mean) + ((dh_l0_2) - dh0_mean)*((dh_l0_2) - dh0_mean) + ((dh_l0_3) - dh0_mean)*((dh_l0_3) - dh0_mean) + ((dh_l0_4) - dh0_mean)*((dh_l0_4) - dh0_mean) + ((dh_l0_5) - dh0_mean)*((dh_l0_5) - dh0_mean) + ((dh_l0_6) - dh0_mean)*((dh_l0_6) - dh0_mean) + ((dh_l0_7) - dh0_mean)*((dh_l0_7) - dh0_mean) + ((dh_l0_8) - dh0_mean)*((dh_l0_8) - dh0_mean) + ((dh_l0_9) - dh0_mean)*((dh_l0_9) - dh0_mean) + ((dh_l0_10) - dh0_mean)*((dh_l0_10) - dh0_mean) + ((dh_l0_11) - dh0_mean)*((dh_l0_11) - dh0_mean) + ((dh_l0_12) - dh0_mean)*((dh_l0_12) - dh0_mean) + ((dh_l0_13) - dh0_mean)*((dh_l0_13) - dh0_mean) + ((dh_l0_14) - dh0_mean)*((dh_l0_14) - dh0_mean) + ((dh_l0_15) - dh0_mean)*((dh_l0_15) - dh0_mean) + ((dh_l0_16) - dh0_mean)*((dh_l0_16) - dh0_mean) + ((dh_l0_17) - dh0_mean)*((dh_l0_17) - dh0_mean) + ((dh_l0_18) - dh0_mean)*((dh_l0_18) - dh0_mean) + ((dh_l0_19) - dh0_mean)*((dh_l0_19) - dh0_mean) + ((dh_l0_20) - dh0_mean)*((dh_l0_20) - dh0_mean) + ((dh_l0_21) - dh0_mean)*((dh_l0_21) - dh0_mean) + ((dh_l0_22) - dh0_mean)*((dh_l0_22) - dh0_mean) + ((dh_l0_23) - dh0_mean)*((dh_l0_23) - dh0_mean) + ((dh_l0_24) - dh0_mean)*((dh_l0_24) - dh0_mean) + ((dh_l0_25) - dh0_mean)*((dh_l0_25) - dh0_mean) + ((dh_l0_26) - dh0_mean)*((dh_l0_26) - dh0_mean) + ((dh_l0_27) - dh0_mean)*((dh_l0_27) - dh0_mean) + ((dh_l0_28) - dh0_mean)*((dh_l0_28) - dh0_mean) + ((dh_l0_29) - dh0_mean)*((dh_l0_29) - dh0_mean) + ((dh_l0_30) - dh0_mean)*((dh_l0_30) - dh0_mean) + ((dh_l0_31) - dh0_mean)*((dh_l0_31) - dh0_mean)) / 32;
    dh_n0_0 = (((dh_l0_0) - dh0_mean) / sqrt(dh0_var + ln_eps)) * (0.13773836195468903) + (-0.010358409024775028);
    dh_n0_1 = (((dh_l0_1) - dh0_mean) / sqrt(dh0_var + ln_eps)) * (0.35256516933441162) + (-0.00094133050879463553);
    dh_n0_2 = (((dh_l0_2) - dh0_mean) / sqrt(dh0_var + ln_eps)) * (5.2222362683096435e-06) + (1.6000691402950906e-06);
    dh_n0_3 = (((dh_l0_3) - dh0_mean) / sqrt(dh0_var + ln_eps)) * (-1.4287088561104611e-05) + (-4.8742972467152867e-06);
    dh_n0_4 = (((dh_l0_4) - dh0_mean) / sqrt(dh0_var + ln_eps)) * (-3.3096264360210625e-06) + (-1.0629536291162367e-06);
    dh_n0_5 = (((dh_l0_5) - dh0_mean) / sqrt(dh0_var + ln_eps)) * (-5.1237364351308656e-10) + (1.9892032465662624e-10);
    dh_n0_6 = (((dh_l0_6) - dh0_mean) / sqrt(dh0_var + ln_eps)) * (-4.8559854803897906e-06) + (-1.5202555232463055e-06);
    dh_n0_7 = (((dh_l0_7) - dh0_mean) / sqrt(dh0_var + ln_eps)) * (-5.4358238230634015e-06) + (2.6198933937848778e-06);
    dh_n0_8 = (((dh_l0_8) - dh0_mean) / sqrt(dh0_var + ln_eps)) * (-2.5819792881520698e-06) + (-8.4509196085491567e-07);
    dh_n0_9 = (((dh_l0_9) - dh0_mean) / sqrt(dh0_var + ln_eps)) * (-3.8681773730786517e-06) + (-1.2518486300905352e-06);
    dh_n0_10 = (((dh_l0_10) - dh0_mean) / sqrt(dh0_var + ln_eps)) * (2.3221802119297117e-15) + (1.8682952778028899e-15);
    dh_n0_11 = (((dh_l0_11) - dh0_mean) / sqrt(dh0_var + ln_eps)) * (0.39306092262268066) + (-0.013449146412312984);
    dh_n0_12 = (((dh_l0_12) - dh0_mean) / sqrt(dh0_var + ln_eps)) * (3.9184542401926592e-06) + (1.1629634855125914e-06);
    dh_n0_13 = (((dh_l0_13) - dh0_mean) / sqrt(dh0_var + ln_eps)) * (-3.6928190638718661e-07) + (-1.4155874339394359e-07);
    dh_n0_14 = (((dh_l0_14) - dh0_mean) / sqrt(dh0_var + ln_eps)) * (-9.4588500587633462e-07) + (3.4399888590996852e-06);
    dh_n0_15 = (((dh_l0_15) - dh0_mean) / sqrt(dh0_var + ln_eps)) * (-6.0201887208677363e-07) + (3.7094292792971828e-07);
    dh_n0_16 = (((dh_l0_16) - dh0_mean) / sqrt(dh0_var + ln_eps)) * (6.2938812561696977e-07) + (-1.0733121769135323e-07);
    dh_n0_17 = (((dh_l0_17) - dh0_mean) / sqrt(dh0_var + ln_eps)) * (-3.9836754694988485e-06) + (-1.2007974419248058e-06);
    dh_n0_18 = (((dh_l0_18) - dh0_mean) / sqrt(dh0_var + ln_eps)) * (5.5015271982483682e-07) + (-2.9952823865642131e-07);
    dh_n0_19 = (((dh_l0_19) - dh0_mean) / sqrt(dh0_var + ln_eps)) * (0.47023075819015503) + (0.073191873729228973);
    dh_n0_20 = (((dh_l0_20) - dh0_mean) / sqrt(dh0_var + ln_eps)) * (0.55332088470458984) + (-0.0062841395847499371);
    dh_n0_21 = (((dh_l0_21) - dh0_mean) / sqrt(dh0_var + ln_eps)) * (-3.4467250316083664e-06) + (-1.0115229542861925e-06);
    dh_n0_22 = (((dh_l0_22) - dh0_mean) / sqrt(dh0_var + ln_eps)) * (9.56080498326628e-07) + (3.1451182280761714e-07);
    dh_n0_23 = (((dh_l0_23) - dh0_mean) / sqrt(dh0_var + ln_eps)) * (-4.6531608859368134e-06) + (-1.3871363080397714e-06);
    dh_n0_24 = (((dh_l0_24) - dh0_mean) / sqrt(dh0_var + ln_eps)) * (0.63163661956787109) + (0.058736164122819901);
    dh_n0_25 = (((dh_l0_25) - dh0_mean) / sqrt(dh0_var + ln_eps)) * (2.6475283902982483e-06) + (8.1266233564747381e-07);
    dh_n0_26 = (((dh_l0_26) - dh0_mean) / sqrt(dh0_var + ln_eps)) * (2.3229822545545176e-06) + (7.5928926435153699e-07);
    dh_n0_27 = (((dh_l0_27) - dh0_mean) / sqrt(dh0_var + ln_eps)) * (-4.7299984373694315e-08) + (4.6475065573758911e-08);
    dh_n0_28 = (((dh_l0_28) - dh0_mean) / sqrt(dh0_var + ln_eps)) * (0.66711604595184326) + (-0.01887829415500164);
    dh_n0_29 = (((dh_l0_29) - dh0_mean) / sqrt(dh0_var + ln_eps)) * (0.56979465484619141) + (0.11410274356603622);
    dh_n0_30 = (((dh_l0_30) - dh0_mean) / sqrt(dh0_var + ln_eps)) * (-5.6888943618105259e-06) + (-1.9092999536951538e-06);
    dh_n0_31 = (((dh_l0_31) - dh0_mean) / sqrt(dh0_var + ln_eps)) * (-2.953139073724742e-06) + (-9.5988298198790289e-07);
    dh_g0_0 = gelu_approx(dh_n0_0);
    dh_g0_1 = gelu_approx(dh_n0_1);
    dh_g0_2 = gelu_approx(dh_n0_2);
    dh_g0_3 = gelu_approx(dh_n0_3);
    dh_g0_4 = gelu_approx(dh_n0_4);
    dh_g0_5 = gelu_approx(dh_n0_5);
    dh_g0_6 = gelu_approx(dh_n0_6);
    dh_g0_7 = gelu_approx(dh_n0_7);
    dh_g0_8 = gelu_approx(dh_n0_8);
    dh_g0_9 = gelu_approx(dh_n0_9);
    dh_g0_10 = gelu_approx(dh_n0_10);
    dh_g0_11 = gelu_approx(dh_n0_11);
    dh_g0_12 = gelu_approx(dh_n0_12);
    dh_g0_13 = gelu_approx(dh_n0_13);
    dh_g0_14 = gelu_approx(dh_n0_14);
    dh_g0_15 = gelu_approx(dh_n0_15);
    dh_g0_16 = gelu_approx(dh_n0_16);
    dh_g0_17 = gelu_approx(dh_n0_17);
    dh_g0_18 = gelu_approx(dh_n0_18);
    dh_g0_19 = gelu_approx(dh_n0_19);
    dh_g0_20 = gelu_approx(dh_n0_20);
    dh_g0_21 = gelu_approx(dh_n0_21);
    dh_g0_22 = gelu_approx(dh_n0_22);
    dh_g0_23 = gelu_approx(dh_n0_23);
    dh_g0_24 = gelu_approx(dh_n0_24);
    dh_g0_25 = gelu_approx(dh_n0_25);
    dh_g0_26 = gelu_approx(dh_n0_26);
    dh_g0_27 = gelu_approx(dh_n0_27);
    dh_g0_28 = gelu_approx(dh_n0_28);
    dh_g0_29 = gelu_approx(dh_n0_29);
    dh_g0_30 = gelu_approx(dh_n0_30);
    dh_g0_31 = gelu_approx(dh_n0_31);
    dh_l1_0 = 0.10470280051231384;
    dh_l1_0 = dh_l1_0 + (0.10323970019817352)*dh_g0_0;
    dh_l1_0 = dh_l1_0 + (-0.10839593410491943)*dh_g0_1;
    dh_l1_0 = dh_l1_0 + (3.4338802379352273e-07)*dh_g0_2;
    dh_l1_0 = dh_l1_0 + (-1.0023229606304085e-06)*dh_g0_3;
    dh_l1_0 = dh_l1_0 + (-2.1404228789378976e-07)*dh_g0_4;
    dh_l1_0 = dh_l1_0 + (-2.5752268373313569e-11)*dh_g0_5;
    dh_l1_0 = dh_l1_0 + (-2.485978143340617e-07)*dh_g0_6;
    dh_l1_0 = dh_l1_0 + (3.5322111671121093e-06)*dh_g0_7;
    dh_l1_0 = dh_l1_0 + (-2.0764109365245531e-07)*dh_g0_8;
    dh_l1_0 = dh_l1_0 + (-3.2471592703586794e-07)*dh_g0_9;
    dh_l1_0 = dh_l1_0 + (3.9929874287396565e-15)*dh_g0_10;
    dh_l1_0 = dh_l1_0 + (0.19229316711425781)*dh_g0_11;
    dh_l1_0 = dh_l1_0 + (9.7054018155517952e-09)*dh_g0_12;
    dh_l1_0 = dh_l1_0 + (-7.8260598002088955e-08)*dh_g0_13;
    dh_l1_0 = dh_l1_0 + (3.2455423593091837e-07)*dh_g0_14;
    dh_l1_0 = dh_l1_0 + (5.6831754591257777e-07)*dh_g0_15;
    dh_l1_0 = dh_l1_0 + (-3.1411670420311566e-07)*dh_g0_16;
    dh_l1_0 = dh_l1_0 + (-9.701000891482181e-08)*dh_g0_17;
    dh_l1_0 = dh_l1_0 + (1.9257564431995888e-08)*dh_g0_18;
    dh_l1_0 = dh_l1_0 + (0.042993593961000443)*dh_g0_19;
    dh_l1_0 = dh_l1_0 + (0.47677132487297058)*dh_g0_20;
    dh_l1_0 = dh_l1_0 + (1.5066756731130226e-08)*dh_g0_21;
    dh_l1_0 = dh_l1_0 + (7.7714972235298774e-08)*dh_g0_22;
    dh_l1_0 = dh_l1_0 + (-5.4904476520789558e-09)*dh_g0_23;
    dh_l1_0 = dh_l1_0 + (0.0068771080113947392)*dh_g0_24;
    dh_l1_0 = dh_l1_0 + (1.2116515790694393e-07)*dh_g0_25;
    dh_l1_0 = dh_l1_0 + (1.7374092919908435e-07)*dh_g0_26;
    dh_l1_0 = dh_l1_0 + (8.5169801877782447e-08)*dh_g0_27;
    dh_l1_0 = dh_l1_0 + (0.0024110917001962662)*dh_g0_28;
    dh_l1_0 = dh_l1_0 + (0.48340675234794617)*dh_g0_29;
    dh_l1_0 = dh_l1_0 + (-5.6417650284856791e-07)*dh_g0_30;
    dh_l1_0 = dh_l1_0 + (-2.1599171873276646e-07)*dh_g0_31;
    dh_l1_1 = -0.51819789409637451;
    dh_l1_1 = dh_l1_1 + (0.022348916158080101)*dh_g0_0;
    dh_l1_1 = dh_l1_1 + (-0.22782774269580841)*dh_g0_1;
    dh_l1_1 = dh_l1_1 + (2.2277311018115142e-06)*dh_g0_2;
    dh_l1_1 = dh_l1_1 + (-4.4145085098534764e-07)*dh_g0_3;
    dh_l1_1 = dh_l1_1 + (7.1596630846215703e-08)*dh_g0_4;
    dh_l1_1 = dh_l1_1 + (-9.5940733135790879e-10)*dh_g0_5;
    dh_l1_1 = dh_l1_1 + (-5.5838466295199396e-08)*dh_g0_6;
    dh_l1_1 = dh_l1_1 + (-3.3271976462856401e-06)*dh_g0_7;
    dh_l1_1 = dh_l1_1 + (-8.3942373052536823e-09)*dh_g0_8;
    dh_l1_1 = dh_l1_1 + (-9.1597840423673915e-09)*dh_g0_9;
    dh_l1_1 = dh_l1_1 + (1.813314919768029e-14)*dh_g0_10;
    dh_l1_1 = dh_l1_1 + (0.05397704616189003)*dh_g0_11;
    dh_l1_1 = dh_l1_1 + (5.2663136784758535e-07)*dh_g0_12;
    dh_l1_1 = dh_l1_1 + (-1.6004725011953269e-07)*dh_g0_13;
    dh_l1_1 = dh_l1_1 + (5.661390218847373e-07)*dh_g0_14;
    dh_l1_1 = dh_l1_1 + (-2.0747399958054302e-06)*dh_g0_15;
    dh_l1_1 = dh_l1_1 + (4.6114055862744863e-07)*dh_g0_16;
    dh_l1_1 = dh_l1_1 + (-2.8726549317070749e-07)*dh_g0_17;
    dh_l1_1 = dh_l1_1 + (2.6532416086411104e-07)*dh_g0_18;
    dh_l1_1 = dh_l1_1 + (-0.30414897203445435)*dh_g0_19;
    dh_l1_1 = dh_l1_1 + (0.0086009204387664795)*dh_g0_20;
    dh_l1_1 = dh_l1_1 + (-5.6050237162708072e-07)*dh_g0_21;
    dh_l1_1 = dh_l1_1 + (1.4669492287566754e-08)*dh_g0_22;
    dh_l1_1 = dh_l1_1 + (-6.3312990050690132e-07)*dh_g0_23;
    dh_l1_1 = dh_l1_1 + (-0.58770203590393066)*dh_g0_24;
    dh_l1_1 = dh_l1_1 + (7.1618671881878981e-08)*dh_g0_25;
    dh_l1_1 = dh_l1_1 + (1.2648746938737077e-08)*dh_g0_26;
    dh_l1_1 = dh_l1_1 + (1.8290825209987815e-07)*dh_g0_27;
    dh_l1_1 = dh_l1_1 + (-0.3736339807510376)*dh_g0_28;
    dh_l1_1 = dh_l1_1 + (-0.13506725430488586)*dh_g0_29;
    dh_l1_1 = dh_l1_1 + (-2.7784079748016666e-07)*dh_g0_30;
    dh_l1_1 = dh_l1_1 + (-8.5569809016305953e-09)*dh_g0_31;
    dh_l1_2 = -4.9059038846472548e-40;
    dh_l1_2 = dh_l1_2 + (-4.9209398171694601e-40)*dh_g0_0;
    dh_l1_2 = dh_l1_2 + (-4.9150543636192959e-40)*dh_g0_1;
    dh_l1_2 = dh_l1_2 + (4.9834237156937037e-40)*dh_g0_2;
    dh_l1_2 = dh_l1_2 + (-4.910317974809878e-40)*dh_g0_3;
    dh_l1_2 = dh_l1_2 + (4.9857778971137694e-40)*dh_g0_4;
    dh_l1_2 = dh_l1_2 + (-4.9331451267937293e-40)*dh_g0_5;
    dh_l1_2 = dh_l1_2 + (-4.9844887025265906e-40)*dh_g0_6;
    dh_l1_2 = dh_l1_2 + (-5.0223097480787174e-40)*dh_g0_7;
    dh_l1_2 = dh_l1_2 + (5.0143503728013524e-40)*dh_g0_8;
    dh_l1_2 = dh_l1_2 + (-4.9383299311117311e-40)*dh_g0_9;
    dh_l1_2 = dh_l1_2 + (-5.0670251820753223e-40)*dh_g0_10;
    dh_l1_2 = dh_l1_2 + (-4.9735725874895002e-40)*dh_g0_11;
    dh_l1_2 = dh_l1_2 + (4.9954748824868971e-40)*dh_g0_12;
    dh_l1_2 = dh_l1_2 + (4.95605635668544e-40)*dh_g0_13;
    dh_l1_2 = dh_l1_2 + (-4.9442714366004683e-40)*dh_g0_14;
    dh_l1_2 = dh_l1_2 + (6.0416983289364488e-40)*dh_g0_15;
    dh_l1_2 = dh_l1_2 + (-5.5216904818101524e-40)*dh_g0_16;
    dh_l1_2 = dh_l1_2 + (4.9756044702627712e-40)*dh_g0_17;
    dh_l1_2 = dh_l1_2 + (5.0434133029514491e-40)*dh_g0_18;
    dh_l1_2 = dh_l1_2 + (-4.9478167217152101e-40)*dh_g0_19;
    dh_l1_2 = dh_l1_2 + (-4.9511798380295897e-40)*dh_g0_20;
    dh_l1_2 = dh_l1_2 + (-4.9122517666906462e-40)*dh_g0_21;
    dh_l1_2 = dh_l1_2 + (-4.9068707805876389e-40)*dh_g0_22;
    dh_l1_2 = dh_l1_2 + (5.0217912676469172e-40)*dh_g0_23;
    dh_l1_2 = dh_l1_2 + (-5.772088504400354e-40)*dh_g0_24;
    dh_l1_2 = dh_l1_2 + (4.9453083974640687e-40)*dh_g0_25;
    dh_l1_2 = dh_l1_2 + (5.3693272997841151e-40)*dh_g0_26;
    dh_l1_2 = dh_l1_2 + (-4.9167078958071992e-40)*dh_g0_27;
    dh_l1_2 = dh_l1_2 + (-4.9494142019645404e-40)*dh_g0_28;
    dh_l1_2 = dh_l1_2 + (4.9563646423475915e-40)*dh_g0_29;
    dh_l1_2 = dh_l1_2 + (-4.9474383711298424e-40)*dh_g0_30;
    dh_l1_2 = dh_l1_2 + (4.9592092782301709e-40)*dh_g0_31;
    dh_l1_3 = 0.0025941918138414621;
    dh_l1_3 = dh_l1_3 + (-3.8550577301066369e-05)*dh_g0_0;
    dh_l1_3 = dh_l1_3 + (-0.028550839051604271)*dh_g0_1;
    dh_l1_3 = dh_l1_3 + (5.1758559038717067e-07)*dh_g0_2;
    dh_l1_3 = dh_l1_3 + (-5.098271458336967e-07)*dh_g0_3;
    dh_l1_3 = dh_l1_3 + (-8.6272575572365895e-07)*dh_g0_4;
    dh_l1_3 = dh_l1_3 + (-3.445411456137748e-10)*dh_g0_5;
    dh_l1_3 = dh_l1_3 + (3.4622054556621151e-08)*dh_g0_6;
    dh_l1_3 = dh_l1_3 + (-1.5252699370194023e-07)*dh_g0_7;
    dh_l1_3 = dh_l1_3 + (3.7556620924306117e-08)*dh_g0_8;
    dh_l1_3 = dh_l1_3 + (5.7666106556553132e-08)*dh_g0_9;
    dh_l1_3 = dh_l1_3 + (6.1478409406204911e-15)*dh_g0_10;
    dh_l1_3 = dh_l1_3 + (0.03427085280418396)*dh_g0_11;
    dh_l1_3 = dh_l1_3 + (-4.7618311782571254e-07)*dh_g0_12;
    dh_l1_3 = dh_l1_3 + (-1.9094803960229001e-08)*dh_g0_13;
    dh_l1_3 = dh_l1_3 + (4.8997879531498256e-08)*dh_g0_14;
    dh_l1_3 = dh_l1_3 + (-7.2559309671760275e-08)*dh_g0_15;
    dh_l1_3 = dh_l1_3 + (6.2058029826062011e-09)*dh_g0_16;
    dh_l1_3 = dh_l1_3 + (3.9912146121423575e-07)*dh_g0_17;
    dh_l1_3 = dh_l1_3 + (4.9920124922664399e-08)*dh_g0_18;
    dh_l1_3 = dh_l1_3 + (-0.076000377535820007)*dh_g0_19;
    dh_l1_3 = dh_l1_3 + (0.014983659610152245)*dh_g0_20;
    dh_l1_3 = dh_l1_3 + (4.7258146196327289e-07)*dh_g0_21;
    dh_l1_3 = dh_l1_3 + (-5.8399738378511756e-08)*dh_g0_22;
    dh_l1_3 = dh_l1_3 + (5.1457283234412898e-07)*dh_g0_23;
    dh_l1_3 = dh_l1_3 + (-0.011027410626411438)*dh_g0_24;
    dh_l1_3 = dh_l1_3 + (-1.9588142663451436e-07)*dh_g0_25;
    dh_l1_3 = dh_l1_3 + (-9.0011127440448035e-08)*dh_g0_26;
    dh_l1_3 = dh_l1_3 + (3.5019503741295921e-08)*dh_g0_27;
    dh_l1_3 = dh_l1_3 + (0.042065288871526718)*dh_g0_28;
    dh_l1_3 = dh_l1_3 + (0.031600844115018845)*dh_g0_29;
    dh_l1_3 = dh_l1_3 + (-1.6501903132848383e-07)*dh_g0_30;
    dh_l1_3 = dh_l1_3 + (4.2867451810479906e-08)*dh_g0_31;
    n_raw = dh_l1_0;
    v0_raw = dh_l1_1;
    beta_raw = dh_l1_3;
    n_par = limexp(smooth_clip(n_raw, exp_arg_limit));
    v0_par = limexp(smooth_clip(v0_raw, exp_arg_limit));
    b_par = 1.4 + 1.1*sigmoid_lim(beta_raw);

    // FiLM fusion + full head
    film_0 = -0.067109480500221252;
    film_0 = film_0 + (-0.024917837232351303)*hpn_0;
    film_0 = film_0 + (0.0002886171278078109)*hpn_1;
    film_0 = film_0 + (0.023660805076360703)*hpn_2;
    film_0 = film_0 + (-0.014731337316334248)*hpn_3;
    film_0 = film_0 + (0.00028858435689471662)*hpn_4;
    film_0 = film_0 + (-0.059145942330360413)*hpn_5;
    film_0 = film_0 + (-0.055705323815345764)*hpn_6;
    film_0 = film_0 + (0.00028857449069619179)*hpn_7;
    film_0 = film_0 + (-0.095835573971271515)*hpn_8;
    film_0 = film_0 + (0.0002886104048229754)*hpn_9;
    film_0 = film_0 + (0.00028861392638646066)*hpn_10;
    film_0 = film_0 + (0.1579870730638504)*hpn_11;
    film_0 = film_0 + (0.0021101757884025574)*hpn_12;
    film_0 = film_0 + (0.075321532785892487)*hpn_13;
    film_0 = film_0 + (0.00028858857695013285)*hpn_14;
    film_0 = film_0 + (0.0002886050206143409)*hpn_15;
    film_1 = 0.052701320499181747;
    film_1 = film_1 + (-0.1825692355632782)*hpn_0;
    film_1 = film_1 + (0.0027071342337876558)*hpn_1;
    film_1 = film_1 + (0.21807488799095154)*hpn_2;
    film_1 = film_1 + (0.0073722158558666706)*hpn_3;
    film_1 = film_1 + (0.0027071181684732437)*hpn_4;
    film_1 = film_1 + (-0.084825091063976288)*hpn_5;
    film_1 = film_1 + (-0.031532112509012222)*hpn_6;
    film_1 = film_1 + (0.0027070920914411545)*hpn_7;
    film_1 = film_1 + (-0.030874572694301605)*hpn_8;
    film_1 = film_1 + (0.0027071346994489431)*hpn_9;
    film_1 = film_1 + (0.0027071386575698853)*hpn_10;
    film_1 = film_1 + (-0.027771191671490669)*hpn_11;
    film_1 = film_1 + (0.069081731140613556)*hpn_12;
    film_1 = film_1 + (0.050747916102409363)*hpn_13;
    film_1 = film_1 + (0.0027071244549006224)*hpn_14;
    film_1 = film_1 + (0.0027071177028119564)*hpn_15;
    film_2 = -2.8898643904540222e-06;
    film_2 = film_2 + (-2.2349449864123017e-06)*hpn_0;
    film_2 = film_2 + (3.474052050478349e-07)*hpn_1;
    film_2 = film_2 + (-1.1254396667936817e-05)*hpn_2;
    film_2 = film_2 + (2.1189265680732206e-05)*hpn_3;
    film_2 = film_2 + (3.4740398291432939e-07)*hpn_4;
    film_2 = film_2 + (1.9562197849154472e-05)*hpn_5;
    film_2 = film_2 + (-8.1060187540060724e-07)*hpn_6;
    film_2 = film_2 + (3.4740415344458597e-07)*hpn_7;
    film_2 = film_2 + (-5.1713133871089667e-05)*hpn_8;
    film_2 = film_2 + (3.4740611454253667e-07)*hpn_9;
    film_2 = film_2 + (3.4740045862236002e-07)*hpn_10;
    film_2 = film_2 + (9.4736906248726882e-06)*hpn_11;
    film_2 = film_2 + (-2.0374018276925199e-05)*hpn_12;
    film_2 = film_2 + (3.7737136153737083e-05)*hpn_13;
    film_2 = film_2 + (3.4740412502287654e-07)*hpn_14;
    film_2 = film_2 + (3.4740162391244667e-07)*hpn_15;
    film_3 = 0.014123027212917805;
    film_3 = film_3 + (-0.19644534587860107)*hpn_0;
    film_3 = film_3 + (-0.0012741804821416736)*hpn_1;
    film_3 = film_3 + (0.047002002596855164)*hpn_2;
    film_3 = film_3 + (0.024992316961288452)*hpn_3;
    film_3 = film_3 + (-0.0012741811806336045)*hpn_4;
    film_3 = film_3 + (-0.018038991838693619)*hpn_5;
    film_3 = film_3 + (0.23422092199325562)*hpn_6;
    film_3 = film_3 + (-0.0012741885147988796)*hpn_7;
    film_3 = film_3 + (-0.084775254130363464)*hpn_8;
    film_3 = film_3 + (-0.0012741695391014218)*hpn_9;
    film_3 = film_3 + (-0.0012741759419441223)*hpn_10;
    film_3 = film_3 + (-0.028774812817573547)*hpn_11;
    film_3 = film_3 + (0.059020049870014191)*hpn_12;
    film_3 = film_3 + (-0.020960021764039993)*hpn_13;
    film_3 = film_3 + (-0.0012741812970489264)*hpn_14;
    film_3 = film_3 + (-0.001274184207431972)*hpn_15;
    film_4 = -0.10185816884040833;
    film_4 = film_4 + (-0.042214218527078629)*hpn_0;
    film_4 = film_4 + (0.00070384220452979207)*hpn_1;
    film_4 = film_4 + (-0.054920338094234467)*hpn_2;
    film_4 = film_4 + (0.0088998526334762573)*hpn_3;
    film_4 = film_4 + (0.00070384482387453318)*hpn_4;
    film_4 = film_4 + (0.039766471832990646)*hpn_5;
    film_4 = film_4 + (0.19987200200557709)*hpn_6;
    film_4 = film_4 + (0.00070383911952376366)*hpn_7;
    film_4 = film_4 + (-0.091192618012428284)*hpn_8;
    film_4 = film_4 + (0.00070383941056206822)*hpn_9;
    film_4 = film_4 + (0.0007038440671749413)*hpn_10;
    film_4 = film_4 + (-0.17260080575942993)*hpn_11;
    film_4 = film_4 + (0.071954011917114258)*hpn_12;
    film_4 = film_4 + (0.03014509379863739)*hpn_13;
    film_4 = film_4 + (0.00070384424179792404)*hpn_14;
    film_4 = film_4 + (0.00070384069113060832)*hpn_15;
    film_5 = -0.0073172068223357201;
    film_5 = film_5 + (0.19631807506084442)*hpn_0;
    film_5 = film_5 + (-0.0014620886649936438)*hpn_1;
    film_5 = film_5 + (-0.18764385581016541)*hpn_2;
    film_5 = film_5 + (0.027999049052596092)*hpn_3;
    film_5 = film_5 + (-0.0014620770234614611)*hpn_4;
    film_5 = film_5 + (0.057335130870342255)*hpn_5;
    film_5 = film_5 + (-0.078395448625087738)*hpn_6;
    film_5 = film_5 + (-0.0014620628207921982)*hpn_7;
    film_5 = film_5 + (-0.026953687891364098)*hpn_8;
    film_5 = film_5 + (-0.0014620941365137696)*hpn_9;
    film_5 = film_5 + (-0.0014620947185903788)*hpn_10;
    film_5 = film_5 + (-0.03271237388253212)*hpn_11;
    film_5 = film_5 + (0.008335920050740242)*hpn_12;
    film_5 = film_5 + (0.0038708948995918036)*hpn_13;
    film_5 = film_5 + (-0.0014620779547840357)*hpn_14;
    film_5 = film_5 + (-0.0014620712026953697)*hpn_15;
    film_6 = -0.089371606707572937;
    film_6 = film_6 + (-0.084403686225414276)*hpn_0;
    film_6 = film_6 + (0.0011703756172209978)*hpn_1;
    film_6 = film_6 + (-0.092448219656944275)*hpn_2;
    film_6 = film_6 + (0.11274491250514984)*hpn_3;
    film_6 = film_6 + (0.0011703775962814689)*hpn_4;
    film_6 = film_6 + (-0.096878238022327423)*hpn_5;
    film_6 = film_6 + (0.17531129717826843)*hpn_6;
    film_6 = film_6 + (0.0011703773634508252)*hpn_7;
    film_6 = film_6 + (0.067103788256645203)*hpn_8;
    film_6 = film_6 + (0.0011703852796927094)*hpn_9;
    film_6 = film_6 + (0.0011703724740073085)*hpn_10;
    film_6 = film_6 + (-0.008935258723795414)*hpn_11;
    film_6 = film_6 + (0.055093105882406235)*hpn_12;
    film_6 = film_6 + (-0.079880364239215851)*hpn_13;
    film_6 = film_6 + (0.0011703793425112963)*hpn_14;
    film_6 = film_6 + (0.0011703735217452049)*hpn_15;
    film_7 = -6.0944744291191455e-06;
    film_7 = film_7 + (1.523378614365356e-05)*hpn_0;
    film_7 = film_7 + (-2.9993708494657767e-07)*hpn_1;
    film_7 = film_7 + (1.3160300795789226e-06)*hpn_2;
    film_7 = film_7 + (-1.925370997923892e-05)*hpn_3;
    film_7 = film_7 + (-2.9993734074196254e-07)*hpn_4;
    film_7 = film_7 + (-5.9652666095644236e-06)*hpn_5;
    film_7 = film_7 + (4.7514918151136953e-06)*hpn_6;
    film_7 = film_7 + (-2.9993563543939672e-07)*hpn_7;
    film_7 = film_7 + (6.3704273998155259e-06)*hpn_8;
    film_7 = film_7 + (-2.999390744662378e-07)*hpn_9;
    film_7 = film_7 + (-2.9993523753546469e-07)*hpn_10;
    film_7 = film_7 + (-1.2120986866648309e-05)*hpn_11;
    film_7 = film_7 + (6.9016982706671115e-06)*hpn_12;
    film_7 = film_7 + (-1.3464830772136338e-05)*hpn_13;
    film_7 = film_7 + (-2.9993697125973995e-07)*hpn_14;
    film_7 = film_7 + (-2.999351522703364e-07)*hpn_15;
    film_8 = 0.10052952915430069;
    film_8 = film_8 + (0.038589946925640106)*hpn_0;
    film_8 = film_8 + (-0.0011073520872741938)*hpn_1;
    film_8 = film_8 + (-0.20091506838798523)*hpn_2;
    film_8 = film_8 + (0.081365041434764862)*hpn_3;
    film_8 = film_8 + (-0.0011073553469032049)*hpn_4;
    film_8 = film_8 + (-0.0076112058013677597)*hpn_5;
    film_8 = film_8 + (0.11742939054965973)*hpn_6;
    film_8 = film_8 + (-0.0011073523201048374)*hpn_7;
    film_8 = film_8 + (-0.03620399534702301)*hpn_8;
    film_8 = film_8 + (-0.0011073498753830791)*hpn_9;
    film_8 = film_8 + (-0.0011073554633185267)*hpn_10;
    film_8 = film_8 + (0.06250704824924469)*hpn_11;
    film_8 = film_8 + (-0.024147000163793564)*hpn_12;
    film_8 = film_8 + (-0.0052345334552228451)*hpn_13;
    film_8 = film_8 + (-0.0011073527857661247)*hpn_14;
    film_8 = film_8 + (-0.00110735057387501)*hpn_15;
    film_9 = -0.22837196290493011;
    film_9 = film_9 + (0.10659153759479523)*hpn_0;
    film_9 = film_9 + (0.0048961150459945202)*hpn_1;
    film_9 = film_9 + (-0.023112144321203232)*hpn_2;
    film_9 = film_9 + (-0.010389580391347408)*hpn_3;
    film_9 = film_9 + (0.0048961048014461994)*hpn_4;
    film_9 = film_9 + (0.098106779158115387)*hpn_5;
    film_9 = film_9 + (-0.13534717261791229)*hpn_6;
    film_9 = film_9 + (0.0048960819840431213)*hpn_7;
    film_9 = film_9 + (0.0014188182540237904)*hpn_8;
    film_9 = film_9 + (0.0048961015418171883)*hpn_9;
    film_9 = film_9 + (0.0048961271531879902)*hpn_10;
    film_9 = film_9 + (-0.2273934930562973)*hpn_11;
    film_9 = film_9 + (0.080694608390331268)*hpn_12;
    film_9 = film_9 + (0.01576712541282177)*hpn_13;
    film_9 = film_9 + (0.0048960917629301548)*hpn_14;
    film_9 = film_9 + (0.0048960978165268898)*hpn_15;
    film_10 = 0.089528545737266541;
    film_10 = film_10 + (0.12735603749752045)*hpn_0;
    film_10 = film_10 + (0.0018499195575714111)*hpn_1;
    film_10 = film_10 + (0.042184099555015564)*hpn_2;
    film_10 = film_10 + (-0.18460454046726227)*hpn_3;
    film_10 = film_10 + (0.0018498842837288976)*hpn_4;
    film_10 = film_10 + (0.076078690588474274)*hpn_5;
    film_10 = film_10 + (-0.042377620935440063)*hpn_6;
    film_10 = film_10 + (0.0018498761346563697)*hpn_7;
    film_10 = film_10 + (-0.044241182506084442)*hpn_8;
    film_10 = film_10 + (0.001849891385063529)*hpn_9;
    film_10 = film_10 + (0.0018499240977689624)*hpn_10;
    film_10 = film_10 + (0.18778252601623535)*hpn_11;
    film_10 = film_10 + (-0.12139973044395447)*hpn_12;
    film_10 = film_10 + (-0.018509771674871445)*hpn_13;
    film_10 = film_10 + (0.001849889406003058)*hpn_14;
    film_10 = film_10 + (0.0018498949939385056)*hpn_15;
    film_11 = 0.2216343879699707;
    film_11 = film_11 + (-0.19751757383346558)*hpn_0;
    film_11 = film_11 + (0.0010508955456316471)*hpn_1;
    film_11 = film_11 + (0.10408522188663483)*hpn_2;
    film_11 = film_11 + (0.0064967167563736439)*hpn_3;
    film_11 = film_11 + (0.0010508771520107985)*hpn_4;
    film_11 = film_11 + (0.025113362818956375)*hpn_5;
    film_11 = film_11 + (0.1547672301530838)*hpn_6;
    film_11 = film_11 + (0.0010508558480069041)*hpn_7;
    film_11 = film_11 + (-0.024718888103961945)*hpn_8;
    film_11 = film_11 + (0.0010508868144825101)*hpn_9;
    film_11 = film_11 + (0.0010509055573493242)*hpn_10;
    film_11 = film_11 + (-0.26469725370407104)*hpn_11;
    film_11 = film_11 + (0.13494360446929932)*hpn_12;
    film_11 = film_11 + (0.004674089141190052)*hpn_13;
    film_11 = film_11 + (0.0010508812265470624)*hpn_14;
    film_11 = film_11 + (0.0010508717969059944)*hpn_15;
    film_12 = -0.040106594562530518;
    film_12 = film_12 + (-0.12012296169996262)*hpn_0;
    film_12 = film_12 + (5.2794384828303009e-05)*hpn_1;
    film_12 = film_12 + (0.091970384120941162)*hpn_2;
    film_12 = film_12 + (-0.088499613106250763)*hpn_3;
    film_12 = film_12 + (5.2807667088927701e-05)*hpn_4;
    film_12 = film_12 + (-0.0055207801051437855)*hpn_5;
    film_12 = film_12 + (0.28119835257530212)*hpn_6;
    film_12 = film_12 + (5.2809689805144444e-05)*hpn_7;
    film_12 = film_12 + (0.011332900263369083)*hpn_8;
    film_12 = film_12 + (5.2796214731642976e-05)*hpn_9;
    film_12 = film_12 + (5.2797080570599064e-05)*hpn_10;
    film_12 = film_12 + (-0.06966555118560791)*hpn_11;
    film_12 = film_12 + (-0.048135150223970413)*hpn_12;
    film_12 = film_12 + (-0.052163023501634598)*hpn_13;
    film_12 = film_12 + (5.2805986342718825e-05)*hpn_14;
    film_12 = film_12 + (5.2797335229115561e-05)*hpn_15;
    film_13 = -0.040650412440299988;
    film_13 = film_13 + (-0.14668957889080048)*hpn_0;
    film_13 = film_13 + (-0.0022382379975169897)*hpn_1;
    film_13 = film_13 + (0.19366253912448883)*hpn_2;
    film_13 = film_13 + (-0.0033081176225095987)*hpn_3;
    film_13 = film_13 + (-0.002238226355984807)*hpn_4;
    film_13 = film_13 + (-0.006654614582657814)*hpn_5;
    film_13 = film_13 + (-0.12940704822540283)*hpn_6;
    film_13 = film_13 + (-0.0022382165770977736)*hpn_7;
    film_13 = film_13 + (-0.043718427419662476)*hpn_8;
    film_13 = film_13 + (-0.0022382307797670364)*hpn_9;
    film_13 = film_13 + (-0.0022382470779120922)*hpn_10;
    film_13 = film_13 + (0.061111114919185638)*hpn_11;
    film_13 = film_13 + (0.033226970583200455)*hpn_12;
    film_13 = film_13 + (0.01778164878487587)*hpn_13;
    film_13 = film_13 + (-0.0022382298484444618)*hpn_14;
    film_13 = film_13 + (-0.0022382221650332212)*hpn_15;
    film_14 = -7.9089122664299794e-06;
    film_14 = film_14 + (2.2308780899038538e-05)*hpn_0;
    film_14 = film_14 + (-3.6984252460570133e-07)*hpn_1;
    film_14 = film_14 + (1.3176735592423938e-05)*hpn_2;
    film_14 = film_14 + (-3.8631762436125427e-05)*hpn_3;
    film_14 = film_14 + (-3.6984144458074297e-07)*hpn_4;
    film_14 = film_14 + (-9.4729512056801468e-06)*hpn_5;
    film_14 = film_14 + (9.5553687060601078e-06)*hpn_6;
    film_14 = film_14 + (-3.69841842484675e-07)*hpn_7;
    film_14 = film_14 + (5.3814219427295029e-05)*hpn_8;
    film_14 = film_14 + (-3.6984522466809722e-07)*hpn_9;
    film_14 = film_14 + (-3.6983504969612113e-07)*hpn_10;
    film_14 = film_14 + (-2.4217026293626986e-05)*hpn_11;
    film_14 = film_14 + (1.3786943782179151e-05)*hpn_12;
    film_14 = film_14 + (-4.3189640564378351e-05)*hpn_13;
    film_14 = film_14 + (-3.6984138773732411e-07)*hpn_14;
    film_14 = film_14 + (-3.6983780660193588e-07)*hpn_15;
    film_15 = -7.1023265491021448e-07;
    film_15 = film_15 + (3.4765791951940628e-06)*hpn_0;
    film_15 = film_15 + (-1.6873851649279459e-08)*hpn_1;
    film_15 = film_15 + (3.289327651145868e-06)*hpn_2;
    film_15 = film_15 + (-1.211477751894563e-06)*hpn_3;
    film_15 = film_15 + (-1.687361184110614e-08)*hpn_4;
    film_15 = film_15 + (-3.2138082133315038e-06)*hpn_5;
    film_15 = film_15 + (2.2040519525035052e-06)*hpn_6;
    film_15 = film_15 + (-1.6873652697313446e-08)*hpn_7;
    film_15 = film_15 + (3.703527681864216e-06)*hpn_8;
    film_15 = film_15 + (-1.6873762831437489e-08)*hpn_9;
    film_15 = film_15 + (-1.6873743291512255e-08)*hpn_10;
    film_15 = film_15 + (-2.3721825073153013e-06)*hpn_11;
    film_15 = film_15 + (3.2834964258654509e-07)*hpn_12;
    film_15 = film_15 + (4.6614277948719973e-07)*hpn_13;
    film_15 = film_15 + (-1.6873594077537746e-08)*hpn_14;
    film_15 = film_15 + (-1.6873491048841061e-08)*hpn_15;
    film_16 = -0.1246059387922287;
    film_16 = film_16 + (0.21626664698123932)*hpn_0;
    film_16 = film_16 + (0.006028173491358757)*hpn_1;
    film_16 = film_16 + (-0.033161874860525131)*hpn_2;
    film_16 = film_16 + (0.0016533734742552042)*hpn_3;
    film_16 = film_16 + (0.0060281800106167793)*hpn_4;
    film_16 = film_16 + (0.014723831787705421)*hpn_5;
    film_16 = film_16 + (-0.024688525125384331)*hpn_6;
    film_16 = film_16 + (0.0060281911864876747)*hpn_7;
    film_16 = film_16 + (-0.031784985214471817)*hpn_8;
    film_16 = film_16 + (0.0060281627811491489)*hpn_9;
    film_16 = film_16 + (0.0060281539335846901)*hpn_10;
    film_16 = film_16 + (0.045228388160467148)*hpn_11;
    film_16 = film_16 + (-0.025929436087608337)*hpn_12;
    film_16 = film_16 + (-0.033220130950212479)*hpn_13;
    film_16 = film_16 + (0.0060281702317297459)*hpn_14;
    film_16 = film_16 + (0.0060281669721007347)*hpn_15;
    film_17 = 0.11045331507921219;
    film_17 = film_17 + (-0.096698470413684845)*hpn_0;
    film_17 = film_17 + (-0.0006000160938128829)*hpn_1;
    film_17 = film_17 + (-0.03206176683306694)*hpn_2;
    film_17 = film_17 + (-0.0086668375879526138)*hpn_3;
    film_17 = film_17 + (-0.0006000238936394453)*hpn_4;
    film_17 = film_17 + (0.012571674771606922)*hpn_5;
    film_17 = film_17 + (-0.00084205687744542956)*hpn_6;
    film_17 = film_17 + (-0.0006000204011797905)*hpn_7;
    film_17 = film_17 + (0.036622863262891769)*hpn_8;
    film_17 = film_17 + (-0.00060002761892974377)*hpn_9;
    film_17 = film_17 + (-0.00060002587269991636)*hpn_10;
    film_17 = film_17 + (0.019085809588432312)*hpn_11;
    film_17 = film_17 + (-0.051965486258268356)*hpn_12;
    film_17 = film_17 + (0.039735238999128342)*hpn_13;
    film_17 = film_17 + (-0.00060002104146406054)*hpn_14;
    film_17 = film_17 + (-0.00060001475503668189)*hpn_15;
    film_18 = 0.047135666012763977;
    film_18 = film_18 + (-0.01937815360724926)*hpn_0;
    film_18 = film_18 + (0.00010331265366403386)*hpn_1;
    film_18 = film_18 + (0.032593715935945511)*hpn_2;
    film_18 = film_18 + (0.0079954667016863823)*hpn_3;
    film_18 = film_18 + (0.00010333068348700181)*hpn_4;
    film_18 = film_18 + (-0.024072423577308655)*hpn_5;
    film_18 = film_18 + (-0.021727534011006355)*hpn_6;
    film_18 = film_18 + (0.00010333977843401954)*hpn_7;
    film_18 = film_18 + (0.020785653963685036)*hpn_8;
    film_18 = film_18 + (0.00010332372039556503)*hpn_9;
    film_18 = film_18 + (0.00010331056546419859)*hpn_10;
    film_18 = film_18 + (-0.0068212952464818954)*hpn_11;
    film_18 = film_18 + (0.036088913679122925)*hpn_12;
    film_18 = film_18 + (-0.0095407357439398766)*hpn_13;
    film_18 = film_18 + (0.00010332591773476452)*hpn_14;
    film_18 = film_18 + (0.00010332715464755893)*hpn_15;
    film_19 = 0.049725323915481567;
    film_19 = film_19 + (-0.16992372274398804)*hpn_0;
    film_19 = film_19 + (-0.029120258986949921)*hpn_1;
    film_19 = film_19 + (0.1021987721323967)*hpn_2;
    film_19 = film_19 + (0.037080250680446625)*hpn_3;
    film_19 = film_19 + (-0.029120299965143204)*hpn_4;
    film_19 = film_19 + (-0.074328824877738953)*hpn_5;
    film_19 = film_19 + (-0.10353365540504456)*hpn_6;
    film_19 = film_19 + (-0.029120286926627159)*hpn_7;
    film_19 = film_19 + (-0.045842971652746201)*hpn_8;
    film_19 = film_19 + (-0.029120292514562607)*hpn_9;
    film_19 = film_19 + (-0.029120290651917458)*hpn_10;
    film_19 = film_19 + (0.010391486808657646)*hpn_11;
    film_19 = film_19 + (-0.052926875650882721)*hpn_12;
    film_19 = film_19 + (-0.042276240885257721)*hpn_13;
    film_19 = film_19 + (-0.029120290651917458)*hpn_14;
    film_19 = film_19 + (-0.029120251536369324)*hpn_15;
    film_20 = -0.025622237473726273;
    film_20 = film_20 + (-0.18169857561588287)*hpn_0;
    film_20 = film_20 + (0.024621983990073204)*hpn_1;
    film_20 = film_20 + (0.034705888479948044)*hpn_2;
    film_20 = film_20 + (-0.0022778122220188379)*hpn_3;
    film_20 = film_20 + (0.024621941149234772)*hpn_4;
    film_20 = film_20 + (0.056721772998571396)*hpn_5;
    film_20 = film_20 + (0.15893171727657318)*hpn_6;
    film_20 = film_20 + (0.024621911346912384)*hpn_7;
    film_20 = film_20 + (0.0001954478066181764)*hpn_8;
    film_20 = film_20 + (0.024621976539492607)*hpn_9;
    film_20 = film_20 + (0.024621956050395966)*hpn_10;
    film_20 = film_20 + (-0.028966207057237625)*hpn_11;
    film_20 = film_20 + (0.052070043981075287)*hpn_12;
    film_20 = film_20 + (0.017801018431782722)*hpn_13;
    film_20 = film_20 + (0.024621928110718727)*hpn_14;
    film_20 = film_20 + (0.024621961638331413)*hpn_15;
    film_21 = -0.24100296199321747;
    film_21 = film_21 + (0.17094236612319946)*hpn_0;
    film_21 = film_21 + (-0.003583588870242238)*hpn_1;
    film_21 = film_21 + (-0.14871139824390411)*hpn_2;
    film_21 = film_21 + (0.046967711299657822)*hpn_3;
    film_21 = film_21 + (-0.0035836105234920979)*hpn_4;
    film_21 = film_21 + (0.077663399279117584)*hpn_5;
    film_21 = film_21 + (-0.22263309359550476)*hpn_6;
    film_21 = film_21 + (-0.0035836163442581892)*hpn_7;
    film_21 = film_21 + (-0.0097211077809333801)*hpn_8;
    film_21 = film_21 + (-0.003583601675927639)*hpn_9;
    film_21 = film_21 + (-0.0035835986491292715)*hpn_10;
    film_21 = film_21 + (0.034180425107479095)*hpn_11;
    film_21 = film_21 + (-0.039651881903409958)*hpn_12;
    film_21 = film_21 + (-0.048684950917959213)*hpn_13;
    film_21 = film_21 + (-0.003583613084629178)*hpn_14;
    film_21 = film_21 + (-0.0035836037714034319)*hpn_15;
    film_22 = 0.0059144995175302029;
    film_22 = film_22 + (0.02753976546227932)*hpn_0;
    film_22 = film_22 + (0.00027293214225210249)*hpn_1;
    film_22 = film_22 + (0.094491750001907349)*hpn_2;
    film_22 = film_22 + (-0.080510050058364868)*hpn_3;
    film_22 = film_22 + (0.00027291412698104978)*hpn_4;
    film_22 = film_22 + (0.041540663689374924)*hpn_5;
    film_22 = film_22 + (-0.035510595887899399)*hpn_6;
    film_22 = film_22 + (0.000272900186246261)*hpn_7;
    film_22 = film_22 + (-0.024842157959938049)*hpn_8;
    film_22 = film_22 + (0.00027292370214127004)*hpn_9;
    film_22 = film_22 + (0.00027293249149806798)*hpn_10;
    film_22 = film_22 + (0.0627855584025383)*hpn_11;
    film_22 = film_22 + (-0.074774689972400665)*hpn_12;
    film_22 = film_22 + (0.018380913883447647)*hpn_13;
    film_22 = film_22 + (0.00027291342848911881)*hpn_14;
    film_22 = film_22 + (0.00027291956939734519)*hpn_15;
    film_23 = 0.047098804265260696;
    film_23 = film_23 + (-0.019366579130291939)*hpn_0;
    film_23 = film_23 + (0.00011648562212940305)*hpn_1;
    film_23 = film_23 + (0.032590113580226898)*hpn_2;
    film_23 = film_23 + (0.007950187660753727)*hpn_3;
    film_23 = film_23 + (0.00011650398664642125)*hpn_4;
    film_23 = film_23 + (-0.024004904553294182)*hpn_5;
    film_23 = film_23 + (-0.021719550713896751)*hpn_6;
    film_23 = film_23 + (0.00011651295062620193)*hpn_7;
    film_23 = film_23 + (0.020842991769313812)*hpn_8;
    film_23 = film_23 + (0.00011649818770820275)*hpn_9;
    film_23 = film_23 + (0.00011648474901448935)*hpn_10;
    film_23 = film_23 + (-0.0068974755704402924)*hpn_11;
    film_23 = film_23 + (0.035999227315187454)*hpn_12;
    film_23 = film_23 + (-0.0095229446887969971)*hpn_13;
    film_23 = film_23 + (0.00011650023225229234)*hpn_14;
    film_23 = film_23 + (0.00011650085798464715)*hpn_15;
    film_24 = -0.27099263668060303;
    film_24 = film_24 + (0.083641000092029572)*hpn_0;
    film_24 = film_24 + (0.0046311523765325546)*hpn_1;
    film_24 = film_24 + (-0.022041561082005501)*hpn_2;
    film_24 = film_24 + (-0.038276586681604385)*hpn_3;
    film_24 = film_24 + (0.0046311407350003719)*hpn_4;
    film_24 = film_24 + (-0.020408429205417633)*hpn_5;
    film_24 = film_24 + (-0.039872206747531891)*hpn_6;
    film_24 = film_24 + (0.0046311509795486927)*hpn_7;
    film_24 = film_24 + (0.073496803641319275)*hpn_8;
    film_24 = film_24 + (0.0046311486512422562)*hpn_9;
    film_24 = film_24 + (0.0046311481855809689)*hpn_10;
    film_24 = film_24 + (0.0060758008621633053)*hpn_11;
    film_24 = film_24 + (-0.041555460542440414)*hpn_12;
    film_24 = film_24 + (0.085298255085945129)*hpn_13;
    film_24 = film_24 + (0.0046311579644680023)*hpn_14;
    film_24 = film_24 + (0.0046311570331454277)*hpn_15;
    film_25 = -0.020814009010791779;
    film_25 = film_25 + (-0.054867979139089584)*hpn_0;
    film_25 = film_25 + (4.3055100832134485e-05)*hpn_1;
    film_25 = film_25 + (-0.00058656034525483847)*hpn_2;
    film_25 = film_25 + (0.10146111249923706)*hpn_3;
    film_25 = film_25 + (4.3042495235567912e-05)*hpn_4;
    film_25 = film_25 + (-0.0052641611546278)*hpn_5;
    film_25 = film_25 + (-0.066136114299297333)*hpn_6;
    film_25 = film_25 + (4.3027914216509089e-05)*hpn_7;
    film_25 = film_25 + (-0.0068815532140433788)*hpn_8;
    film_25 = film_25 + (4.3043830373790115e-05)*hpn_9;
    film_25 = film_25 + (4.3063082557637244e-05)*hpn_10;
    film_25 = film_25 + (0.037973750382661819)*hpn_11;
    film_25 = film_25 + (-0.024576736614108086)*hpn_12;
    film_25 = film_25 + (0.012193489819765091)*hpn_13;
    film_25 = film_25 + (4.3042593460995704e-05)*hpn_14;
    film_25 = film_25 + (4.3039290176238865e-05)*hpn_15;
    film_26 = -0.0097020445391535759;
    film_26 = film_26 + (0.044775836169719696)*hpn_0;
    film_26 = film_26 + (-0.0038804945070296526)*hpn_1;
    film_26 = film_26 + (0.037533041089773178)*hpn_2;
    film_26 = film_26 + (-0.074147701263427734)*hpn_3;
    film_26 = film_26 + (-0.0038804670330137014)*hpn_4;
    film_26 = film_26 + (0.12118743360042572)*hpn_5;
    film_26 = film_26 + (-0.070372000336647034)*hpn_6;
    film_26 = film_26 + (-0.0038804600480943918)*hpn_7;
    film_26 = film_26 + (-0.052189864218235016)*hpn_8;
    film_26 = film_26 + (-0.0038804796058684587)*hpn_9;
    film_26 = film_26 + (-0.0038804886862635612)*hpn_10;
    film_26 = film_26 + (-0.054633647203445435)*hpn_11;
    film_26 = film_26 + (0.071301087737083435)*hpn_12;
    film_26 = film_26 + (-0.015652349218726158)*hpn_13;
    film_26 = film_26 + (-0.0038804782088845968)*hpn_14;
    film_26 = film_26 + (-0.0038804782088845968)*hpn_15;
    film_27 = 0.12419590353965759;
    film_27 = film_27 + (0.10263989865779877)*hpn_0;
    film_27 = film_27 + (-0.0039806696586310863)*hpn_1;
    film_27 = film_27 + (-0.0017728990642353892)*hpn_2;
    film_27 = film_27 + (-0.01687297597527504)*hpn_3;
    film_27 = film_27 + (-0.0039807013235986233)*hpn_4;
    film_27 = film_27 + (-0.007501102052628994)*hpn_5;
    film_27 = film_27 + (0.0017884942935779691)*hpn_6;
    film_27 = film_27 + (-0.0039807152934372425)*hpn_7;
    film_27 = film_27 + (-0.0082704890519380569)*hpn_8;
    film_27 = film_27 + (-0.0039806729182600975)*hpn_9;
    film_27 = film_27 + (-0.0039806906133890152)*hpn_10;
    film_27 = film_27 + (-0.097293950617313385)*hpn_11;
    film_27 = film_27 + (0.0046000550501048565)*hpn_12;
    film_27 = film_27 + (-0.039052575826644897)*hpn_13;
    film_27 = film_27 + (-0.003980711568146944)*hpn_14;
    film_27 = film_27 + (-0.0039806943386793137)*hpn_15;
    film_28 = -0.051725491881370544;
    film_28 = film_28 + (-0.067585989832878113)*hpn_0;
    film_28 = film_28 + (0.0038728113286197186)*hpn_1;
    film_28 = film_28 + (0.039870578795671463)*hpn_2;
    film_28 = film_28 + (0.022544365376234055)*hpn_3;
    film_28 = film_28 + (0.0038728085346519947)*hpn_4;
    film_28 = film_28 + (-0.018568113446235657)*hpn_5;
    film_28 = film_28 + (0.021260833367705345)*hpn_6;
    film_28 = film_28 + (0.0038728008512407541)*hpn_7;
    film_28 = film_28 + (0.041660863906145096)*hpn_8;
    film_28 = film_28 + (0.0038728006184101105)*hpn_9;
    film_28 = film_28 + (0.0038728131912648678)*hpn_10;
    film_28 = film_28 + (-0.069618284702301025)*hpn_11;
    film_28 = film_28 + (0.034815382212400436)*hpn_12;
    film_28 = film_28 + (0.018609534949064255)*hpn_13;
    film_28 = film_28 + (0.0038728057406842709)*hpn_14;
    film_28 = film_28 + (0.0038728236686438322)*hpn_15;
    film_29 = 0.11068915575742722;
    film_29 = film_29 + (-0.0069998828694224358)*hpn_0;
    film_29 = film_29 + (0.00082647765520960093)*hpn_1;
    film_29 = film_29 + (0.052312325686216354)*hpn_2;
    film_29 = film_29 + (0.013608849607408047)*hpn_3;
    film_29 = film_29 + (0.00082645908696576953)*hpn_4;
    film_29 = film_29 + (-0.053658276796340942)*hpn_5;
    film_29 = film_29 + (-0.011363728903234005)*hpn_6;
    film_29 = film_29 + (0.00082642963388934731)*hpn_7;
    film_29 = film_29 + (-0.019238537177443504)*hpn_8;
    film_29 = film_29 + (0.00082647113595157862)*hpn_9;
    film_29 = film_29 + (0.00082648714305832982)*hpn_10;
    film_29 = film_29 + (-0.024129616096615791)*hpn_11;
    film_29 = film_29 + (0.003213242394849658)*hpn_12;
    film_29 = film_29 + (0.044703833758831024)*hpn_13;
    film_29 = film_29 + (0.0008264628704637289)*hpn_14;
    film_29 = film_29 + (0.00082645262591540813)*hpn_15;
    film_30 = 0.047096051275730133;
    film_30 = film_30 + (-0.019376350566744804)*hpn_0;
    film_30 = film_30 + (8.9267326984554529e-05)*hpn_1;
    film_30 = film_30 + (0.032566409558057785)*hpn_2;
    film_30 = film_30 + (0.0080085331574082375)*hpn_3;
    film_30 = film_30 + (8.9284782006870955e-05)*hpn_4;
    film_30 = film_30 + (-0.024001596495509148)*hpn_5;
    film_30 = film_30 + (-0.021731734275817871)*hpn_6;
    film_30 = film_30 + (8.9294204371981323e-05)*hpn_7;
    film_30 = film_30 + (0.020716443657875061)*hpn_8;
    film_30 = film_30 + (8.9278299128636718e-05)*hpn_9;
    film_30 = film_30 + (8.9265922724734992e-05)*hpn_10;
    film_30 = film_30 + (-0.0067796986550092697)*hpn_11;
    film_30 = film_30 + (0.036071505397558212)*hpn_12;
    film_30 = film_30 + (-0.0094932280480861664)*hpn_13;
    film_30 = film_30 + (8.9281449618283659e-05)*hpn_14;
    film_30 = film_30 + (8.9281835244037211e-05)*hpn_15;
    film_31 = 0.047111276537179947;
    film_31 = film_31 + (-0.019391622394323349)*hpn_0;
    film_31 = film_31 + (5.2968916861573234e-05)*hpn_1;
    film_31 = film_31 + (0.032543949782848358)*hpn_2;
    film_31 = film_31 + (0.0080960923805832863)*hpn_3;
    film_31 = film_31 + (5.2987143135396764e-05)*hpn_4;
    film_31 = film_31 + (-0.02404353953897953)*hpn_5;
    film_31 = film_31 + (-0.021750427782535553)*hpn_6;
    film_31 = film_31 + (5.2996423619333655e-05)*hpn_7;
    film_31 = film_31 + (0.020550509914755821)*hpn_8;
    film_31 = film_31 + (5.298091855365783e-05)*hpn_9;
    film_31 = film_31 + (5.2968032832723111e-05)*hpn_10;
    film_31 = film_31 + (-0.0066085755825042725)*hpn_11;
    film_31 = film_31 + (0.036199923604726791)*hpn_12;
    film_31 = film_31 + (-0.0094715803861618042)*hpn_13;
    film_31 = film_31 + (5.2982988563599065e-05)*hpn_14;
    film_31 = film_31 + (5.2984152716817334e-05)*hpn_15;
    hfp_0 = hv_0 * film_0 + film_16;
    hfp_1 = hv_1 * film_1 + film_17;
    hfp_2 = hv_2 * film_2 + film_18;
    hfp_3 = hv_3 * film_3 + film_19;
    hfp_4 = hv_4 * film_4 + film_20;
    hfp_5 = hv_5 * film_5 + film_21;
    hfp_6 = hv_6 * film_6 + film_22;
    hfp_7 = hv_7 * film_7 + film_23;
    hfp_8 = hv_8 * film_8 + film_24;
    hfp_9 = hv_9 * film_9 + film_25;
    hfp_10 = hv_10 * film_10 + film_26;
    hfp_11 = hv_11 * film_11 + film_27;
    hfp_12 = hv_12 * film_12 + film_28;
    hfp_13 = hv_13 * film_13 + film_29;
    hfp_14 = hv_14 * film_14 + film_30;
    hfp_15 = hv_15 * film_15 + film_31;
    hf_mean = (hfp_0 + hfp_1 + hfp_2 + hfp_3 + hfp_4 + hfp_5 + hfp_6 + hfp_7 + hfp_8 + hfp_9 + hfp_10 + hfp_11 + hfp_12 + hfp_13 + hfp_14 + hfp_15) / 16;
    hf_var = (((hfp_0) - hf_mean)*((hfp_0) - hf_mean) + ((hfp_1) - hf_mean)*((hfp_1) - hf_mean) + ((hfp_2) - hf_mean)*((hfp_2) - hf_mean) + ((hfp_3) - hf_mean)*((hfp_3) - hf_mean) + ((hfp_4) - hf_mean)*((hfp_4) - hf_mean) + ((hfp_5) - hf_mean)*((hfp_5) - hf_mean) + ((hfp_6) - hf_mean)*((hfp_6) - hf_mean) + ((hfp_7) - hf_mean)*((hfp_7) - hf_mean) + ((hfp_8) - hf_mean)*((hfp_8) - hf_mean) + ((hfp_9) - hf_mean)*((hfp_9) - hf_mean) + ((hfp_10) - hf_mean)*((hfp_10) - hf_mean) + ((hfp_11) - hf_mean)*((hfp_11) - hf_mean) + ((hfp_12) - hf_mean)*((hfp_12) - hf_mean) + ((hfp_13) - hf_mean)*((hfp_13) - hf_mean) + ((hfp_14) - hf_mean)*((hfp_14) - hf_mean) + ((hfp_15) - hf_mean)*((hfp_15) - hf_mean)) / 16;
    hfn_0 = ((hfp_0) - hf_mean) / sqrt(hf_var + ln_eps);
    hfn_1 = ((hfp_1) - hf_mean) / sqrt(hf_var + ln_eps);
    hfn_2 = ((hfp_2) - hf_mean) / sqrt(hf_var + ln_eps);
    hfn_3 = ((hfp_3) - hf_mean) / sqrt(hf_var + ln_eps);
    hfn_4 = ((hfp_4) - hf_mean) / sqrt(hf_var + ln_eps);
    hfn_5 = ((hfp_5) - hf_mean) / sqrt(hf_var + ln_eps);
    hfn_6 = ((hfp_6) - hf_mean) / sqrt(hf_var + ln_eps);
    hfn_7 = ((hfp_7) - hf_mean) / sqrt(hf_var + ln_eps);
    hfn_8 = ((hfp_8) - hf_mean) / sqrt(hf_var + ln_eps);
    hfn_9 = ((hfp_9) - hf_mean) / sqrt(hf_var + ln_eps);
    hfn_10 = ((hfp_10) - hf_mean) / sqrt(hf_var + ln_eps);
    hfn_11 = ((hfp_11) - hf_mean) / sqrt(hf_var + ln_eps);
    hfn_12 = ((hfp_12) - hf_mean) / sqrt(hf_var + ln_eps);
    hfn_13 = ((hfp_13) - hf_mean) / sqrt(hf_var + ln_eps);
    hfn_14 = ((hfp_14) - hf_mean) / sqrt(hf_var + ln_eps);
    hfn_15 = ((hfp_15) - hf_mean) / sqrt(hf_var + ln_eps);
    fh_l0_0 = -0.01865769550204277;
    fh_l0_0 = fh_l0_0 + (-0.0039122025482356548)*hfn_0;
    fh_l0_0 = fh_l0_0 + (-0.0068450453691184521)*hfn_1;
    fh_l0_0 = fh_l0_0 + (0.00027214878355152905)*hfn_2;
    fh_l0_0 = fh_l0_0 + (-0.00147337990347296)*hfn_3;
    fh_l0_0 = fh_l0_0 + (-0.025224078446626663)*hfn_4;
    fh_l0_0 = fh_l0_0 + (0.014823908917605877)*hfn_5;
    fh_l0_0 = fh_l0_0 + (-0.0066616903059184551)*hfn_6;
    fh_l0_0 = fh_l0_0 + (0.00026613913360051811)*hfn_7;
    fh_l0_0 = fh_l0_0 + (-0.0066850869916379452)*hfn_8;
    fh_l0_0 = fh_l0_0 + (0.0081059997901320457)*hfn_9;
    fh_l0_0 = fh_l0_0 + (-0.024626461789011955)*hfn_10;
    fh_l0_0 = fh_l0_0 + (0.0066337715834379196)*hfn_11;
    fh_l0_0 = fh_l0_0 + (0.018556565046310425)*hfn_12;
    fh_l0_0 = fh_l0_0 + (0.0072305123321712017)*hfn_13;
    fh_l0_0 = fh_l0_0 + (0.00027881539426743984)*hfn_14;
    fh_l0_0 = fh_l0_0 + (0.00029528597951866686)*hfn_15;
    fh_l0_1 = 0.18352413177490234;
    fh_l0_1 = fh_l0_1 + (-0.070436112582683563)*hfn_0;
    fh_l0_1 = fh_l0_1 + (0.017585569992661476)*hfn_1;
    fh_l0_1 = fh_l0_1 + (0.018742626532912254)*hfn_2;
    fh_l0_1 = fh_l0_1 + (-0.10357168316841125)*hfn_3;
    fh_l0_1 = fh_l0_1 + (0.19946983456611633)*hfn_4;
    fh_l0_1 = fh_l0_1 + (-0.074174955487251282)*hfn_5;
    fh_l0_1 = fh_l0_1 + (-0.048011992126703262)*hfn_6;
    fh_l0_1 = fh_l0_1 + (0.018808769062161446)*hfn_7;
    fh_l0_1 = fh_l0_1 + (0.14770433306694031)*hfn_8;
    fh_l0_1 = fh_l0_1 + (-0.072549603879451752)*hfn_9;
    fh_l0_1 = fh_l0_1 + (0.044549252837896347)*hfn_10;
    fh_l0_1 = fh_l0_1 + (-0.078341521322727203)*hfn_11;
    fh_l0_1 = fh_l0_1 + (0.14410915970802307)*hfn_12;
    fh_l0_1 = fh_l0_1 + (-0.18690250813961029)*hfn_13;
    fh_l0_1 = fh_l0_1 + (0.018772853538393974)*hfn_14;
    fh_l0_1 = fh_l0_1 + (0.018694691359996796)*hfn_15;
    fh_l0_2 = 0.067199140787124634;
    fh_l0_2 = fh_l0_2 + (-0.032842513173818588)*hfn_0;
    fh_l0_2 = fh_l0_2 + (-0.24194963276386261)*hfn_1;
    fh_l0_2 = fh_l0_2 + (-0.065846674144268036)*hfn_2;
    fh_l0_2 = fh_l0_2 + (-0.001134718069806695)*hfn_3;
    fh_l0_2 = fh_l0_2 + (0.32983046770095825)*hfn_4;
    fh_l0_2 = fh_l0_2 + (-0.23397713899612427)*hfn_5;
    fh_l0_2 = fh_l0_2 + (-0.024385023862123489)*hfn_6;
    fh_l0_2 = fh_l0_2 + (-0.065890491008758545)*hfn_7;
    fh_l0_2 = fh_l0_2 + (-0.092367462813854218)*hfn_8;
    fh_l0_2 = fh_l0_2 + (0.052804980427026749)*hfn_9;
    fh_l0_2 = fh_l0_2 + (0.17247770726680756)*hfn_10;
    fh_l0_2 = fh_l0_2 + (0.023391455411911011)*hfn_11;
    fh_l0_2 = fh_l0_2 + (0.067352637648582458)*hfn_12;
    fh_l0_2 = fh_l0_2 + (0.10513059049844742)*hfn_13;
    fh_l0_2 = fh_l0_2 + (-0.065802060067653656)*hfn_14;
    fh_l0_2 = fh_l0_2 + (-0.065681852400302887)*hfn_15;
    fh_l0_3 = -0.018462717533111572;
    fh_l0_3 = fh_l0_3 + (-0.0051579829305410385)*hfn_0;
    fh_l0_3 = fh_l0_3 + (-0.0025549980346113443)*hfn_1;
    fh_l0_3 = fh_l0_3 + (0.0011730121914297342)*hfn_2;
    fh_l0_3 = fh_l0_3 + (-0.0025321180000901222)*hfn_3;
    fh_l0_3 = fh_l0_3 + (-0.027956483885645866)*hfn_4;
    fh_l0_3 = fh_l0_3 + (0.01447104848921299)*hfn_5;
    fh_l0_3 = fh_l0_3 + (-0.0035962872207164764)*hfn_6;
    fh_l0_3 = fh_l0_3 + (0.0011656096903607249)*hfn_7;
    fh_l0_3 = fh_l0_3 + (-0.0048493081703782082)*hfn_8;
    fh_l0_3 = fh_l0_3 + (0.0099142380058765411)*hfn_9;
    fh_l0_3 = fh_l0_3 + (-0.028932303190231323)*hfn_10;
    fh_l0_3 = fh_l0_3 + (0.00478355772793293)*hfn_11;
    fh_l0_3 = fh_l0_3 + (0.01633262075483799)*hfn_12;
    fh_l0_3 = fh_l0_3 + (0.0050046141259372234)*hfn_13;
    fh_l0_3 = fh_l0_3 + (0.0011800203938037157)*hfn_14;
    fh_l0_3 = fh_l0_3 + (0.0011991470819339156)*hfn_15;
    fh_l0_4 = -0.026299087330698967;
    fh_l0_4 = fh_l0_4 + (0.025873716920614243)*hfn_0;
    fh_l0_4 = fh_l0_4 + (0.013378911651670933)*hfn_1;
    fh_l0_4 = fh_l0_4 + (-0.0025714107323437929)*hfn_2;
    fh_l0_4 = fh_l0_4 + (0.012549795210361481)*hfn_3;
    fh_l0_4 = fh_l0_4 + (0.0040959934704005718)*hfn_4;
    fh_l0_4 = fh_l0_4 + (0.04401523619890213)*hfn_5;
    fh_l0_4 = fh_l0_4 + (-0.02552475780248642)*hfn_6;
    fh_l0_4 = fh_l0_4 + (-0.0025672719348222017)*hfn_7;
    fh_l0_4 = fh_l0_4 + (-0.020924188196659088)*hfn_8;
    fh_l0_4 = fh_l0_4 + (-0.035325679928064346)*hfn_9;
    fh_l0_4 = fh_l0_4 + (-0.019581718370318413)*hfn_10;
    fh_l0_4 = fh_l0_4 + (0.0096370689570903778)*hfn_11;
    fh_l0_4 = fh_l0_4 + (0.024892009794712067)*hfn_12;
    fh_l0_4 = fh_l0_4 + (-0.0018811476184055209)*hfn_13;
    fh_l0_4 = fh_l0_4 + (-0.0025723965372890234)*hfn_14;
    fh_l0_4 = fh_l0_4 + (-0.0025806420017033815)*hfn_15;
    fh_l0_5 = -0.019718829542398453;
    fh_l0_5 = fh_l0_5 + (-0.0023502679541707039)*hfn_0;
    fh_l0_5 = fh_l0_5 + (0.0027713063172996044)*hfn_1;
    fh_l0_5 = fh_l0_5 + (0.0014211186207830906)*hfn_2;
    fh_l0_5 = fh_l0_5 + (-0.0014952821657061577)*hfn_3;
    fh_l0_5 = fh_l0_5 + (-0.026387307792901993)*hfn_4;
    fh_l0_5 = fh_l0_5 + (0.017946192994713783)*hfn_5;
    fh_l0_5 = fh_l0_5 + (-0.0038809729740023613)*hfn_6;
    fh_l0_5 = fh_l0_5 + (0.0014140836428850889)*hfn_7;
    fh_l0_5 = fh_l0_5 + (-0.0054466314613819122)*hfn_8;
    fh_l0_5 = fh_l0_5 + (0.0059151239693164825)*hfn_9;
    fh_l0_5 = fh_l0_5 + (-0.031149094924330711)*hfn_10;
    fh_l0_5 = fh_l0_5 + (0.0040209037251770496)*hfn_11;
    fh_l0_5 = fh_l0_5 + (0.015574985183775425)*hfn_12;
    fh_l0_5 = fh_l0_5 + (0.0024849851615726948)*hfn_13;
    fh_l0_5 = fh_l0_5 + (0.0014274172717705369)*hfn_14;
    fh_l0_5 = fh_l0_5 + (0.0014452470932155848)*hfn_15;
    fh_l0_6 = 0.10569808632135391;
    fh_l0_6 = fh_l0_6 + (-0.052780147641897202)*hfn_0;
    fh_l0_6 = fh_l0_6 + (-0.087769657373428345)*hfn_1;
    fh_l0_6 = fh_l0_6 + (-0.015567692928016186)*hfn_2;
    fh_l0_6 = fh_l0_6 + (0.0069413995370268822)*hfn_3;
    fh_l0_6 = fh_l0_6 + (0.074248045682907104)*hfn_4;
    fh_l0_6 = fh_l0_6 + (-0.08692517876625061)*hfn_5;
    fh_l0_6 = fh_l0_6 + (0.019562380388379097)*hfn_6;
    fh_l0_6 = fh_l0_6 + (-0.015551943331956863)*hfn_7;
    fh_l0_6 = fh_l0_6 + (0.043685346841812134)*hfn_8;
    fh_l0_6 = fh_l0_6 + (0.018856361508369446)*hfn_9;
    fh_l0_6 = fh_l0_6 + (-0.0096754115074872971)*hfn_10;
    fh_l0_6 = fh_l0_6 + (0.096375219523906708)*hfn_11;
    fh_l0_6 = fh_l0_6 + (0.00052938313456252217)*hfn_12;
    fh_l0_6 = fh_l0_6 + (0.06977061927318573)*hfn_13;
    fh_l0_6 = fh_l0_6 + (-0.015567976981401443)*hfn_14;
    fh_l0_6 = fh_l0_6 + (-0.015594791620969772)*hfn_15;
    fh_l0_7 = -0.046571269631385803;
    fh_l0_7 = fh_l0_7 + (0.25528326630592346)*hfn_0;
    fh_l0_7 = fh_l0_7 + (0.061961211264133453)*hfn_1;
    fh_l0_7 = fh_l0_7 + (0.015498677268624306)*hfn_2;
    fh_l0_7 = fh_l0_7 + (-0.11282546818256378)*hfn_3;
    fh_l0_7 = fh_l0_7 + (0.1920839250087738)*hfn_4;
    fh_l0_7 = fh_l0_7 + (-0.011688821017742157)*hfn_5;
    fh_l0_7 = fh_l0_7 + (-0.011038416065275669)*hfn_6;
    fh_l0_7 = fh_l0_7 + (0.015469524078071117)*hfn_7;
    fh_l0_7 = fh_l0_7 + (0.031231427565217018)*hfn_8;
    fh_l0_7 = fh_l0_7 + (-0.045630652457475662)*hfn_9;
    fh_l0_7 = fh_l0_7 + (-0.048326794058084488)*hfn_10;
    fh_l0_7 = fh_l0_7 + (-0.17519870400428772)*hfn_11;
    fh_l0_7 = fh_l0_7 + (-0.027890805155038834)*hfn_12;
    fh_l0_7 = fh_l0_7 + (0.031837519258260727)*hfn_13;
    fh_l0_7 = fh_l0_7 + (0.015475566498935223)*hfn_14;
    fh_l0_7 = fh_l0_7 + (0.015498412773013115)*hfn_15;
    fh_l0_8 = -0.0061761457473039627;
    fh_l0_8 = fh_l0_8 + (-0.046221159398555756)*hfn_0;
    fh_l0_8 = fh_l0_8 + (-0.048207633197307587)*hfn_1;
    fh_l0_8 = fh_l0_8 + (0.051277145743370056)*hfn_2;
    fh_l0_8 = fh_l0_8 + (-0.051549945026636124)*hfn_3;
    fh_l0_8 = fh_l0_8 + (0.088957242667675018)*hfn_4;
    fh_l0_8 = fh_l0_8 + (-0.15137740969657898)*hfn_5;
    fh_l0_8 = fh_l0_8 + (0.033691231161355972)*hfn_6;
    fh_l0_8 = fh_l0_8 + (0.051311559975147247)*hfn_7;
    fh_l0_8 = fh_l0_8 + (0.010257779620587826)*hfn_8;
    fh_l0_8 = fh_l0_8 + (0.029547102749347687)*hfn_9;
    fh_l0_8 = fh_l0_8 + (0.055367060005664825)*hfn_10;
    fh_l0_8 = fh_l0_8 + (0.037358943372964859)*hfn_11;
    fh_l0_8 = fh_l0_8 + (-0.025057019665837288)*hfn_12;
    fh_l0_8 = fh_l0_8 + (0.013628926128149033)*hfn_13;
    fh_l0_8 = fh_l0_8 + (0.051163822412490845)*hfn_14;
    fh_l0_8 = fh_l0_8 + (0.050993070006370544)*hfn_15;
    fh_l0_9 = -0.022883167490363121;
    fh_l0_9 = fh_l0_9 + (0.0060546435415744781)*hfn_0;
    fh_l0_9 = fh_l0_9 + (-0.035592135041952133)*hfn_1;
    fh_l0_9 = fh_l0_9 + (-0.0061678020283579826)*hfn_2;
    fh_l0_9 = fh_l0_9 + (0.006562430877238512)*hfn_3;
    fh_l0_9 = fh_l0_9 + (-0.0057066376321017742)*hfn_4;
    fh_l0_9 = fh_l0_9 + (0.02007063664495945)*hfn_5;
    fh_l0_9 = fh_l0_9 + (-0.028861779719591141)*hfn_6;
    fh_l0_9 = fh_l0_9 + (-0.0061633842997252941)*hfn_7;
    fh_l0_9 = fh_l0_9 + (-0.020579038187861443)*hfn_8;
    fh_l0_9 = fh_l0_9 + (-0.0061388132162392139)*hfn_9;
    fh_l0_9 = fh_l0_9 + (0.0055534825660288334)*hfn_10;
    fh_l0_9 = fh_l0_9 + (0.020071966573596001)*hfn_11;
    fh_l0_9 = fh_l0_9 + (0.034225694835186005)*hfn_12;
    fh_l0_9 = fh_l0_9 + (0.022696509957313538)*hfn_13;
    fh_l0_9 = fh_l0_9 + (-0.0061640446074306965)*hfn_14;
    fh_l0_9 = fh_l0_9 + (-0.0061678322963416576)*hfn_15;
    fh_l0_10 = 0.019220845773816109;
    fh_l0_10 = fh_l0_10 + (0.11250916123390198)*hfn_0;
    fh_l0_10 = fh_l0_10 + (-0.030856335535645485)*hfn_1;
    fh_l0_10 = fh_l0_10 + (-0.032348901033401489)*hfn_2;
    fh_l0_10 = fh_l0_10 + (0.028434315696358681)*hfn_3;
    fh_l0_10 = fh_l0_10 + (0.092976659536361694)*hfn_4;
    fh_l0_10 = fh_l0_10 + (-0.233603835105896)*hfn_5;
    fh_l0_10 = fh_l0_10 + (-0.13102571666240692)*hfn_6;
    fh_l0_10 = fh_l0_10 + (-0.032334137707948685)*hfn_7;
    fh_l0_10 = fh_l0_10 + (0.015631070360541344)*hfn_8;
    fh_l0_10 = fh_l0_10 + (0.10827352106571198)*hfn_9;
    fh_l0_10 = fh_l0_10 + (0.086024142801761627)*hfn_10;
    fh_l0_10 = fh_l0_10 + (-0.029409216716885567)*hfn_11;
    fh_l0_10 = fh_l0_10 + (-0.048305463045835495)*hfn_12;
    fh_l0_10 = fh_l0_10 + (-0.044385563582181931)*hfn_13;
    fh_l0_10 = fh_l0_10 + (-0.032322902232408524)*hfn_14;
    fh_l0_10 = fh_l0_10 + (-0.032324139028787613)*hfn_15;
    fh_l0_11 = -0.033320892602205276;
    fh_l0_11 = fh_l0_11 + (0.044290963560342789)*hfn_0;
    fh_l0_11 = fh_l0_11 + (0.013227252289652824)*hfn_1;
    fh_l0_11 = fh_l0_11 + (-0.0064451354555785656)*hfn_2;
    fh_l0_11 = fh_l0_11 + (0.022490009665489197)*hfn_3;
    fh_l0_11 = fh_l0_11 + (0.025832172483205795)*hfn_4;
    fh_l0_11 = fh_l0_11 + (0.062304738909006119)*hfn_5;
    fh_l0_11 = fh_l0_11 + (-0.04286087304353714)*hfn_6;
    fh_l0_11 = fh_l0_11 + (-0.0064317770302295685)*hfn_7;
    fh_l0_11 = fh_l0_11 + (-0.033461049199104309)*hfn_8;
    fh_l0_11 = fh_l0_11 + (-0.062325716018676758)*hfn_9;
    fh_l0_11 = fh_l0_11 + (-0.006186729297041893)*hfn_10;
    fh_l0_11 = fh_l0_11 + (0.016390180215239525)*hfn_11;
    fh_l0_11 = fh_l0_11 + (0.033792603760957718)*hfn_12;
    fh_l0_11 = fh_l0_11 + (-0.00043634491157718003)*hfn_13;
    fh_l0_11 = fh_l0_11 + (-0.0064510488882660866)*hfn_14;
    fh_l0_11 = fh_l0_11 + (-0.0064797205850481987)*hfn_15;
    fh_l0_12 = -0.019970810040831566;
    fh_l0_12 = fh_l0_12 + (0.0005698633030988276)*hfn_0;
    fh_l0_12 = fh_l0_12 + (-0.0080735646188259125)*hfn_1;
    fh_l0_12 = fh_l0_12 + (-0.00082562956959009171)*hfn_2;
    fh_l0_12 = fh_l0_12 + (0.0010080980136990547)*hfn_3;
    fh_l0_12 = fh_l0_12 + (-0.019557353109121323)*hfn_4;
    fh_l0_12 = fh_l0_12 + (0.018732083961367607)*hfn_5;
    fh_l0_12 = fh_l0_12 + (-0.011418593116104603)*hfn_6;
    fh_l0_12 = fh_l0_12 + (-0.00082925974857062101)*hfn_7;
    fh_l0_12 = fh_l0_12 + (-0.0099391471594572067)*hfn_8;
    fh_l0_12 = fh_l0_12 + (0.001520071760751307)*hfn_9;
    fh_l0_12 = fh_l0_12 + (-0.020450351759791374)*hfn_10;
    fh_l0_12 = fh_l0_12 + (0.0085648596286773682)*hfn_11;
    fh_l0_12 = fh_l0_12 + (0.021157901734113693)*hfn_12;
    fh_l0_12 = fh_l0_12 + (0.0080473171547055244)*hfn_13;
    fh_l0_12 = fh_l0_12 + (-0.0008201620657928288)*hfn_14;
    fh_l0_12 = fh_l0_12 + (-0.00080889504170045257)*hfn_15;
    fh_l0_13 = -0.045462664216756821;
    fh_l0_13 = fh_l0_13 + (0.076864160597324371)*hfn_0;
    fh_l0_13 = fh_l0_13 + (0.06605423241853714)*hfn_1;
    fh_l0_13 = fh_l0_13 + (-0.0058213267475366592)*hfn_2;
    fh_l0_13 = fh_l0_13 + (0.034437794238328934)*hfn_3;
    fh_l0_13 = fh_l0_13 + (0.052493371069431305)*hfn_4;
    fh_l0_13 = fh_l0_13 + (0.10795275121927261)*hfn_5;
    fh_l0_13 = fh_l0_13 + (-0.051023438572883606)*hfn_6;
    fh_l0_13 = fh_l0_13 + (-0.0058009540662169456)*hfn_7;
    fh_l0_13 = fh_l0_13 + (-0.043411213904619217)*hfn_8;
    fh_l0_13 = fh_l0_13 + (-0.11446361988782883)*hfn_9;
    fh_l0_13 = fh_l0_13 + (-0.025284638628363609)*hfn_10;
    fh_l0_13 = fh_l0_13 + (0.0099530033767223358)*hfn_11;
    fh_l0_13 = fh_l0_13 + (0.031144911423325539)*hfn_12;
    fh_l0_13 = fh_l0_13 + (-0.025570888072252274)*hfn_13;
    fh_l0_13 = fh_l0_13 + (-0.0058356397785246372)*hfn_14;
    fh_l0_13 = fh_l0_13 + (-0.0058845179155468941)*hfn_15;
    fh_l0_14 = -0.019936157390475273;
    fh_l0_14 = fh_l0_14 + (0.0002787166740745306)*hfn_0;
    fh_l0_14 = fh_l0_14 + (-0.010366560891270638)*hfn_1;
    fh_l0_14 = fh_l0_14 + (-0.0011060328688472509)*hfn_2;
    fh_l0_14 = fh_l0_14 + (0.0010980074293911457)*hfn_3;
    fh_l0_14 = fh_l0_14 + (-0.019346680492162704)*hfn_4;
    fh_l0_14 = fh_l0_14 + (0.018022198230028152)*hfn_5;
    fh_l0_14 = fh_l0_14 + (-0.012155951932072639)*hfn_6;
    fh_l0_14 = fh_l0_14 + (-0.0011093668872490525)*hfn_7;
    fh_l0_14 = fh_l0_14 + (-0.010299448855221272)*hfn_8;
    fh_l0_14 = fh_l0_14 + (0.0020527623128145933)*hfn_9;
    fh_l0_14 = fh_l0_14 + (-0.018813887611031532)*hfn_10;
    fh_l0_14 = fh_l0_14 + (0.0092725921422243118)*hfn_11;
    fh_l0_14 = fh_l0_14 + (0.021855438128113747)*hfn_12;
    fh_l0_14 = fh_l0_14 + (0.0092380261048674583)*hfn_13;
    fh_l0_14 = fh_l0_14 + (-0.0011004849802702665)*hfn_14;
    fh_l0_14 = fh_l0_14 + (-0.0010895992163568735)*hfn_15;
    fh_l0_15 = -0.023401295766234398;
    fh_l0_15 = fh_l0_15 + (0.0097821801900863647)*hfn_0;
    fh_l0_15 = fh_l0_15 + (-0.0054766670800745487)*hfn_1;
    fh_l0_15 = fh_l0_15 + (-0.0023030699230730534)*hfn_2;
    fh_l0_15 = fh_l0_15 + (0.0057365358807146549)*hfn_3;
    fh_l0_15 = fh_l0_15 + (-0.0096956947818398476)*hfn_4;
    fh_l0_15 = fh_l0_15 + (0.027806157246232033)*hfn_5;
    fh_l0_15 = fh_l0_15 + (-0.018903056159615517)*hfn_6;
    fh_l0_15 = fh_l0_15 + (-0.0023026899434626102)*hfn_7;
    fh_l0_15 = fh_l0_15 + (-0.015473466366529465)*hfn_8;
    fh_l0_15 = fh_l0_15 + (-0.011787514202296734)*hfn_9;
    fh_l0_15 = fh_l0_15 + (-0.015886953100562096)*hfn_10;
    fh_l0_15 = fh_l0_15 + (0.010990334674715996)*hfn_11;
    fh_l0_15 = fh_l0_15 + (0.024461114779114723)*hfn_12;
    fh_l0_15 = fh_l0_15 + (0.0073076887056231499)*hfn_13;
    fh_l0_15 = fh_l0_15 + (-0.0023000251967459917)*hfn_14;
    fh_l0_15 = fh_l0_15 + (-0.0022979136556386948)*hfn_15;
    fh_l0_16 = -0.0082008671015501022;
    fh_l0_16 = fh_l0_16 + (-0.034338891506195068)*hfn_0;
    fh_l0_16 = fh_l0_16 + (0.030734237283468246)*hfn_1;
    fh_l0_16 = fh_l0_16 + (0.012082284316420555)*hfn_2;
    fh_l0_16 = fh_l0_16 + (-0.021636286750435829)*hfn_3;
    fh_l0_16 = fh_l0_16 + (-0.070501334965229034)*hfn_4;
    fh_l0_16 = fh_l0_16 + (-0.0060410392470657825)*hfn_5;
    fh_l0_16 = fh_l0_16 + (0.038425412029027939)*hfn_6;
    fh_l0_16 = fh_l0_16 + (0.012055018916726112)*hfn_7;
    fh_l0_16 = fh_l0_16 + (0.022603807970881462)*hfn_8;
    fh_l0_16 = fh_l0_16 + (0.05121234804391861)*hfn_9;
    fh_l0_16 = fh_l0_16 + (-0.07657989114522934)*hfn_10;
    fh_l0_16 = fh_l0_16 + (-0.017154291272163391)*hfn_11;
    fh_l0_16 = fh_l0_16 + (-0.0093428120017051697)*hfn_12;
    fh_l0_16 = fh_l0_16 + (-0.013818351551890373)*hfn_13;
    fh_l0_16 = fh_l0_16 + (0.012096990831196308)*hfn_14;
    fh_l0_16 = fh_l0_16 + (0.012157134711742401)*hfn_15;
    fh_l0_17 = -0.019826879724860191;
    fh_l0_17 = fh_l0_17 + (-0.0015455370303243399)*hfn_0;
    fh_l0_17 = fh_l0_17 + (0.0076597817242145538)*hfn_1;
    fh_l0_17 = fh_l0_17 + (0.0020131056662648916)*hfn_2;
    fh_l0_17 = fh_l0_17 + (-0.0015522886533290148)*hfn_3;
    fh_l0_17 = fh_l0_17 + (-0.026826128363609314)*hfn_4;
    fh_l0_17 = fh_l0_17 + (0.019349073991179466)*hfn_5;
    fh_l0_17 = fh_l0_17 + (-0.0024850184563547373)*hfn_6;
    fh_l0_17 = fh_l0_17 + (0.002005482092499733)*hfn_7;
    fh_l0_17 = fh_l0_17 + (-0.004748927429318428)*hfn_8;
    fh_l0_17 = fh_l0_17 + (0.0046801408752799034)*hfn_9;
    fh_l0_17 = fh_l0_17 + (-0.034498464316129684)*hfn_10;
    fh_l0_17 = fh_l0_17 + (0.0025742347352206707)*hfn_11;
    fh_l0_17 = fh_l0_17 + (0.014111275784671307)*hfn_12;
    fh_l0_17 = fh_l0_17 + (-3.4675489587243646e-05)*hfn_13;
    fh_l0_17 = fh_l0_17 + (0.0020192007068544626)*hfn_14;
    fh_l0_17 = fh_l0_17 + (0.0020378069020807743)*hfn_15;
    fh_l0_18 = 0.0016833910485729575;
    fh_l0_18 = fh_l0_18 + (0.10000798106193542)*hfn_0;
    fh_l0_18 = fh_l0_18 + (-0.065790832042694092)*hfn_1;
    fh_l0_18 = fh_l0_18 + (0.032714836299419403)*hfn_2;
    fh_l0_18 = fh_l0_18 + (0.25902855396270752)*hfn_3;
    fh_l0_18 = fh_l0_18 + (-0.027120482176542282)*hfn_4;
    fh_l0_18 = fh_l0_18 + (0.0076446961611509323)*hfn_5;
    fh_l0_18 = fh_l0_18 + (-0.058517564088106155)*hfn_6;
    fh_l0_18 = fh_l0_18 + (0.032732933759689331)*hfn_7;
    fh_l0_18 = fh_l0_18 + (0.055967859923839569)*hfn_8;
    fh_l0_18 = fh_l0_18 + (0.062378175556659698)*hfn_9;
    fh_l0_18 = fh_l0_18 + (0.0094519257545471191)*hfn_10;
    fh_l0_18 = fh_l0_18 + (-0.013805167749524117)*hfn_11;
    fh_l0_18 = fh_l0_18 + (-0.14788825809955597)*hfn_12;
    fh_l0_18 = fh_l0_18 + (-0.011959638446569443)*hfn_13;
    fh_l0_18 = fh_l0_18 + (0.032697036862373352)*hfn_14;
    fh_l0_18 = fh_l0_18 + (0.032646417617797852)*hfn_15;
    fh_l0_19 = -0.018758960068225861;
    fh_l0_19 = fh_l0_19 + (-0.003752206452190876)*hfn_0;
    fh_l0_19 = fh_l0_19 + (-0.0062653892673552036)*hfn_1;
    fh_l0_19 = fh_l0_19 + (0.00032794714206829667)*hfn_2;
    fh_l0_19 = fh_l0_19 + (-0.0014380279462784529)*hfn_3;
    fh_l0_19 = fh_l0_19 + (-0.025224223732948303)*hfn_4;
    fh_l0_19 = fh_l0_19 + (0.015075554139912128)*hfn_5;
    fh_l0_19 = fh_l0_19 + (-0.0065560312941670418)*hfn_6;
    fh_l0_19 = fh_l0_19 + (0.00032190754427574575)*hfn_7;
    fh_l0_19 = fh_l0_19 + (-0.0066568548791110516)*hfn_8;
    fh_l0_19 = fh_l0_19 + (0.0078823035582900047)*hfn_9;
    fh_l0_19 = fh_l0_19 + (-0.024971006438136101)*hfn_10;
    fh_l0_19 = fh_l0_19 + (0.0065035521984100342)*hfn_11;
    fh_l0_19 = fh_l0_19 + (0.018404636532068253)*hfn_12;
    fh_l0_19 = fh_l0_19 + (0.0069506857544183731)*hfn_13;
    fh_l0_19 = fh_l0_19 + (0.00033457326935604215)*hfn_14;
    fh_l0_19 = fh_l0_19 + (0.00035105453571304679)*hfn_15;
    fh_l0_20 = 0.069769762456417084;
    fh_l0_20 = fh_l0_20 + (0.031253289431333542)*hfn_0;
    fh_l0_20 = fh_l0_20 + (0.063032001256942749)*hfn_1;
    fh_l0_20 = fh_l0_20 + (0.004836502019315958)*hfn_2;
    fh_l0_20 = fh_l0_20 + (-0.021882157772779465)*hfn_3;
    fh_l0_20 = fh_l0_20 + (-0.084402672946453094)*hfn_4;
    fh_l0_20 = fh_l0_20 + (0.0011697233421728015)*hfn_5;
    fh_l0_20 = fh_l0_20 + (0.26040682196617126)*hfn_6;
    fh_l0_20 = fh_l0_20 + (0.0048599052242934704)*hfn_7;
    fh_l0_20 = fh_l0_20 + (-0.055833414196968079)*hfn_8;
    fh_l0_20 = fh_l0_20 + (-0.058671765029430389)*hfn_9;
    fh_l0_20 = fh_l0_20 + (0.15363775193691254)*hfn_10;
    fh_l0_20 = fh_l0_20 + (-0.10333500057458878)*hfn_11;
    fh_l0_20 = fh_l0_20 + (-0.16079740226268768)*hfn_12;
    fh_l0_20 = fh_l0_20 + (-0.017441298812627792)*hfn_13;
    fh_l0_20 = fh_l0_20 + (0.0048498869873583317)*hfn_14;
    fh_l0_20 = fh_l0_20 + (0.0048241703771054745)*hfn_15;
    fh_l0_21 = -0.027632826939225197;
    fh_l0_21 = fh_l0_21 + (0.021005053073167801)*hfn_0;
    fh_l0_21 = fh_l0_21 + (0.021093647927045822)*hfn_1;
    fh_l0_21 = fh_l0_21 + (-0.00062112469458952546)*hfn_2;
    fh_l0_21 = fh_l0_21 + (0.009142708033323288)*hfn_3;
    fh_l0_21 = fh_l0_21 + (-0.0038019877392798662)*hfn_4;
    fh_l0_21 = fh_l0_21 + (0.043433856219053268)*hfn_5;
    fh_l0_21 = fh_l0_21 + (-0.017750555649399757)*hfn_6;
    fh_l0_21 = fh_l0_21 + (-0.00062019628239795566)*hfn_7;
    fh_l0_21 = fh_l0_21 + (-0.01662871427834034)*hfn_8;
    fh_l0_21 = fh_l0_21 + (-0.028768813237547874)*hfn_9;
    fh_l0_21 = fh_l0_21 + (-0.029098751023411751)*hfn_10;
    fh_l0_21 = fh_l0_21 + (0.005855068564414978)*hfn_11;
    fh_l0_21 = fh_l0_21 + (0.019880263134837151)*hfn_12;
    fh_l0_21 = fh_l0_21 + (-0.0056913010776042938)*hfn_13;
    fh_l0_21 = fh_l0_21 + (-0.00062096200417727232)*hfn_14;
    fh_l0_21 = fh_l0_21 + (-0.00062269391492009163)*hfn_15;
    fh_l0_22 = -0.033754553645849228;
    fh_l0_22 = fh_l0_22 + (0.042031519114971161)*hfn_0;
    fh_l0_22 = fh_l0_22 + (0.0013494292506948113)*hfn_1;
    fh_l0_22 = fh_l0_22 + (-0.0078782904893159866)*hfn_2;
    fh_l0_22 = fh_l0_22 + (0.022397447377443314)*hfn_3;
    fh_l0_22 = fh_l0_22 + (0.026554252952337265)*hfn_4;
    fh_l0_22 = fh_l0_22 + (0.059357102960348129)*hfn_5;
    fh_l0_22 = fh_l0_22 + (-0.046029187738895416)*hfn_6;
    fh_l0_22 = fh_l0_22 + (-0.007863413542509079)*hfn_7;
    fh_l0_22 = fh_l0_22 + (-0.035194870084524155)*hfn_8;
    fh_l0_22 = fh_l0_22 + (-0.05904826894402504)*hfn_9;
    fh_l0_22 = fh_l0_22 + (0.0017657718854025006)*hfn_10;
    fh_l0_22 = fh_l0_22 + (0.019924070686101913)*hfn_11;
    fh_l0_22 = fh_l0_22 + (0.03728128969669342)*hfn_12;
    fh_l0_22 = fh_l0_22 + (0.0057643945328891277)*hfn_13;
    fh_l0_22 = fh_l0_22 + (-0.0078836996108293533)*hfn_14;
    fh_l0_22 = fh_l0_22 + (-0.0079144639894366264)*hfn_15;
    fh_l0_23 = -0.10792243480682373;
    fh_l0_23 = fh_l0_23 + (-0.098358340561389923)*hfn_0;
    fh_l0_23 = fh_l0_23 + (-0.081624723970890045)*hfn_1;
    fh_l0_23 = fh_l0_23 + (-0.041681177914142609)*hfn_2;
    fh_l0_23 = fh_l0_23 + (-0.027162898331880569)*hfn_3;
    fh_l0_23 = fh_l0_23 + (0.060177277773618698)*hfn_4;
    fh_l0_23 = fh_l0_23 + (0.041598185896873474)*hfn_5;
    fh_l0_23 = fh_l0_23 + (-0.065902940928936005)*hfn_6;
    fh_l0_23 = fh_l0_23 + (-0.041648741811513901)*hfn_7;
    fh_l0_23 = fh_l0_23 + (-0.0076000066474080086)*hfn_8;
    fh_l0_23 = fh_l0_23 + (0.13788294792175293)*hfn_9;
    fh_l0_23 = fh_l0_23 + (0.03099580854177475)*hfn_10;
    fh_l0_23 = fh_l0_23 + (0.11422424763441086)*hfn_11;
    fh_l0_23 = fh_l0_23 + (-0.069447502493858337)*hfn_12;
    fh_l0_23 = fh_l0_23 + (-0.0099230529740452766)*hfn_13;
    fh_l0_23 = fh_l0_23 + (-0.041668470948934555)*hfn_14;
    fh_l0_23 = fh_l0_23 + (-0.041709821671247482)*hfn_15;
    fh_l0_24 = -0.068923510611057281;
    fh_l0_24 = fh_l0_24 + (-0.077241703867912292)*hfn_0;
    fh_l0_24 = fh_l0_24 + (0.060506667941808701)*hfn_1;
    fh_l0_24 = fh_l0_24 + (0.0056844558566808701)*hfn_2;
    fh_l0_24 = fh_l0_24 + (-0.0066170846112072468)*hfn_3;
    fh_l0_24 = fh_l0_24 + (0.096620917320251465)*hfn_4;
    fh_l0_24 = fh_l0_24 + (-0.030884604901075363)*hfn_5;
    fh_l0_24 = fh_l0_24 + (-0.053323689848184586)*hfn_6;
    fh_l0_24 = fh_l0_24 + (0.00565761374309659)*hfn_7;
    fh_l0_24 = fh_l0_24 + (0.20131130516529083)*hfn_8;
    fh_l0_24 = fh_l0_24 + (-0.06394679844379425)*hfn_9;
    fh_l0_24 = fh_l0_24 + (0.056088414043188095)*hfn_10;
    fh_l0_24 = fh_l0_24 + (-0.00058649276616051793)*hfn_11;
    fh_l0_24 = fh_l0_24 + (-0.094146057963371277)*hfn_12;
    fh_l0_24 = fh_l0_24 + (-0.031935892999172211)*hfn_13;
    fh_l0_24 = fh_l0_24 + (0.0057318410836160183)*hfn_14;
    fh_l0_24 = fh_l0_24 + (0.0058298148214817047)*hfn_15;
    fh_l0_25 = -0.019585020840167999;
    fh_l0_25 = fh_l0_25 + (-0.0012076350394636393)*hfn_0;
    fh_l0_25 = fh_l0_25 + (-0.0067799403332173824)*hfn_1;
    fh_l0_25 = fh_l0_25 + (-0.00026298905140720308)*hfn_2;
    fh_l0_25 = fh_l0_25 + (-2.874175515898969e-05)*hfn_3;
    fh_l0_25 = fh_l0_25 + (-0.022127455100417137)*hfn_4;
    fh_l0_25 = fh_l0_25 + (0.017304837703704834)*hfn_5;
    fh_l0_25 = fh_l0_25 + (-0.0091733820736408234)*hfn_6;
    fh_l0_25 = fh_l0_25 + (-0.00026771036209538579)*hfn_7;
    fh_l0_25 = fh_l0_25 + (-0.0084636770188808441)*hfn_8;
    fh_l0_25 = fh_l0_25 + (0.0041978280059993267)*hfn_9;
    fh_l0_25 = fh_l0_25 + (-0.022736620157957077)*hfn_10;
    fh_l0_25 = fh_l0_25 + (0.0075616701506078243)*hfn_11;
    fh_l0_25 = fh_l0_25 + (0.019789092242717743)*hfn_12;
    fh_l0_25 = fh_l0_25 + (0.0073438948020339012)*hfn_13;
    fh_l0_25 = fh_l0_25 + (-0.00025703481514938176)*hfn_14;
    fh_l0_25 = fh_l0_25 + (-0.00024343903351109475)*hfn_15;
    fh_l0_26 = -0.017423395067453384;
    fh_l0_26 = fh_l0_26 + (-0.0074945292435586452)*hfn_0;
    fh_l0_26 = fh_l0_26 + (-0.0071568987332284451)*hfn_1;
    fh_l0_26 = fh_l0_26 + (0.00094814522890374064)*hfn_2;
    fh_l0_26 = fh_l0_26 + (-0.0033655993174761534)*hfn_3;
    fh_l0_26 = fh_l0_26 + (-0.029268974438309669)*hfn_4;
    fh_l0_26 = fh_l0_26 + (0.011491752229630947)*hfn_5;
    fh_l0_26 = fh_l0_26 + (-0.0034331080969423056)*hfn_6;
    fh_l0_26 = fh_l0_26 + (0.00094046263257041574)*hfn_7;
    fh_l0_26 = fh_l0_26 + (-0.0043823067098855972)*hfn_8;
    fh_l0_26 = fh_l0_26 + (0.013291476294398308)*hfn_9;
    fh_l0_26 = fh_l0_26 + (-0.026948980987071991)*hfn_10;
    fh_l0_26 = fh_l0_26 + (0.0054791527800261974)*hfn_11;
    fh_l0_26 = fh_l0_26 + (0.017009707167744637)*hfn_12;
    fh_l0_26 = fh_l0_26 + (0.0071974396705627441)*hfn_13;
    fh_l0_26 = fh_l0_26 + (0.00095574790611863136)*hfn_14;
    fh_l0_26 = fh_l0_26 + (0.00097595684928819537)*hfn_15;
    fh_l0_27 = -0.019279072061181068;
    fh_l0_27 = fh_l0_27 + (-0.0019737950060516596)*hfn_0;
    fh_l0_27 = fh_l0_27 + (-0.0074456534348428249)*hfn_1;
    fh_l0_27 = fh_l0_27 + (-0.0002091861970257014)*hfn_2;
    fh_l0_27 = fh_l0_27 + (-0.00037843864993192255)*hfn_3;
    fh_l0_27 = fh_l0_27 + (-0.022806430235505104)*hfn_4;
    fh_l0_27 = fh_l0_27 + (0.016477979719638824)*hfn_5;
    fh_l0_27 = fh_l0_27 + (-0.0087472386658191681)*hfn_6;
    fh_l0_27 = fh_l0_27 + (-0.00021415577793959528)*hfn_7;
    fh_l0_27 = fh_l0_27 + (-0.0081097390502691269)*hfn_8;
    fh_l0_27 = fh_l0_27 + (0.0053035053424537182)*hfn_9;
    fh_l0_27 = fh_l0_27 + (-0.02275751531124115)*hfn_10;
    fh_l0_27 = fh_l0_27 + (0.0075108930468559265)*hfn_11;
    fh_l0_27 = fh_l0_27 + (0.019687538966536522)*hfn_12;
    fh_l0_27 = fh_l0_27 + (0.0076363924890756607)*hfn_13;
    fh_l0_27 = fh_l0_27 + (-0.00020303518977016211)*hfn_14;
    fh_l0_27 = fh_l0_27 + (-0.00018882389122154564)*hfn_15;
    fh_l0_28 = -0.02109183743596077;
    fh_l0_28 = fh_l0_28 + (0.0010482693323865533)*hfn_0;
    fh_l0_28 = fh_l0_28 + (-0.00036373239709064364)*hfn_1;
    fh_l0_28 = fh_l0_28 + (0.00024335512716788799)*hfn_2;
    fh_l0_28 = fh_l0_28 + (0.00063539925031363964)*hfn_3;
    fh_l0_28 = fh_l0_28 + (-0.021584700793027878)*hfn_4;
    fh_l0_28 = fh_l0_28 + (0.020735995844006538)*hfn_5;
    fh_l0_28 = fh_l0_28 + (-0.0084602478891611099)*hfn_6;
    fh_l0_28 = fh_l0_28 + (0.0002385802217759192)*hfn_7;
    fh_l0_28 = fh_l0_28 + (-0.0085237212479114532)*hfn_8;
    fh_l0_28 = fh_l0_28 + (0.0010241287527605891)*hfn_9;
    fh_l0_28 = fh_l0_28 + (-0.026186926290392876)*hfn_10;
    fh_l0_28 = fh_l0_28 + (0.0063398252241313457)*hfn_11;
    fh_l0_28 = fh_l0_28 + (0.018347788602113724)*hfn_12;
    fh_l0_28 = fh_l0_28 + (0.0043280208483338356)*hfn_13;
    fh_l0_28 = fh_l0_28 + (0.0002487294259481132)*hfn_14;
    fh_l0_28 = fh_l0_28 + (0.00026181992143392563)*hfn_15;
    fh_l0_29 = 0.19078603386878967;
    fh_l0_29 = fh_l0_29 + (-0.058214388787746429)*hfn_0;
    fh_l0_29 = fh_l0_29 + (0.04466576874256134)*hfn_1;
    fh_l0_29 = fh_l0_29 + (0.040656100958585739)*hfn_2;
    fh_l0_29 = fh_l0_29 + (0.023482447490096092)*hfn_3;
    fh_l0_29 = fh_l0_29 + (0.095989100635051727)*hfn_4;
    fh_l0_29 = fh_l0_29 + (-0.090047389268875122)*hfn_5;
    fh_l0_29 = fh_l0_29 + (-0.15907660126686096)*hfn_6;
    fh_l0_29 = fh_l0_29 + (0.040522277355194092)*hfn_7;
    fh_l0_29 = fh_l0_29 + (-0.10871926695108414)*hfn_8;
    fh_l0_29 = fh_l0_29 + (-0.043710250407457352)*hfn_9;
    fh_l0_29 = fh_l0_29 + (0.064231917262077332)*hfn_10;
    fh_l0_29 = fh_l0_29 + (0.1189258024096489)*hfn_11;
    fh_l0_29 = fh_l0_29 + (-0.0028893048875033855)*hfn_12;
    fh_l0_29 = fh_l0_29 + (-0.041357915848493576)*hfn_13;
    fh_l0_29 = fh_l0_29 + (0.040657598525285721)*hfn_14;
    fh_l0_29 = fh_l0_29 + (0.040881186723709106)*hfn_15;
    fh_l0_30 = 0.0093088280409574509;
    fh_l0_30 = fh_l0_30 + (-0.087757416069507599)*hfn_0;
    fh_l0_30 = fh_l0_30 + (0.04396483302116394)*hfn_1;
    fh_l0_30 = fh_l0_30 + (0.024878038093447685)*hfn_2;
    fh_l0_30 = fh_l0_30 + (-0.051236271858215332)*hfn_3;
    fh_l0_30 = fh_l0_30 + (-0.13483907282352448)*hfn_4;
    fh_l0_30 = fh_l0_30 + (-0.049485828727483749)*hfn_5;
    fh_l0_30 = fh_l0_30 + (0.095629371702671051)*hfn_6;
    fh_l0_30 = fh_l0_30 + (0.024824082851409912)*hfn_7;
    fh_l0_30 = fh_l0_30 + (0.061499185860157013)*hfn_8;
    fh_l0_30 = fh_l0_30 + (0.12948374450206757)*hfn_9;
    fh_l0_30 = fh_l0_30 + (-0.12519362568855286)*hfn_10;
    fh_l0_30 = fh_l0_30 + (-0.040507018566131592)*hfn_11;
    fh_l0_30 = fh_l0_30 + (-0.038361791521310806)*hfn_12;
    fh_l0_30 = fh_l0_30 + (-0.022434476763010025)*hfn_13;
    fh_l0_30 = fh_l0_30 + (0.024905886501073837)*hfn_14;
    fh_l0_30 = fh_l0_30 + (0.025024047121405602)*hfn_15;
    fh_l0_31 = 0.072470426559448242;
    fh_l0_31 = fh_l0_31 + (-0.063599847257137299)*hfn_0;
    fh_l0_31 = fh_l0_31 + (0.15785549581050873)*hfn_1;
    fh_l0_31 = fh_l0_31 + (-0.020148923620581627)*hfn_2;
    fh_l0_31 = fh_l0_31 + (0.0079532358795404434)*hfn_3;
    fh_l0_31 = fh_l0_31 + (0.060807626694440842)*hfn_4;
    fh_l0_31 = fh_l0_31 + (-0.22963573038578033)*hfn_5;
    fh_l0_31 = fh_l0_31 + (0.016222178936004639)*hfn_6;
    fh_l0_31 = fh_l0_31 + (-0.020106907933950424)*hfn_7;
    fh_l0_31 = fh_l0_31 + (-0.091891437768936157)*hfn_8;
    fh_l0_31 = fh_l0_31 + (0.0093039954081177711)*hfn_9;
    fh_l0_31 = fh_l0_31 + (-0.07821209728717804)*hfn_10;
    fh_l0_31 = fh_l0_31 + (0.05249452218413353)*hfn_11;
    fh_l0_31 = fh_l0_31 + (-0.0006337333470582962)*hfn_12;
    fh_l0_31 = fh_l0_31 + (0.060565553605556488)*hfn_13;
    fh_l0_31 = fh_l0_31 + (-0.020137058570981026)*hfn_14;
    fh_l0_31 = fh_l0_31 + (-0.020192166790366173)*hfn_15;
    fh0_mean = (fh_l0_0 + fh_l0_1 + fh_l0_2 + fh_l0_3 + fh_l0_4 + fh_l0_5 + fh_l0_6 + fh_l0_7 + fh_l0_8 + fh_l0_9 + fh_l0_10 + fh_l0_11 + fh_l0_12 + fh_l0_13 + fh_l0_14 + fh_l0_15 + fh_l0_16 + fh_l0_17 + fh_l0_18 + fh_l0_19 + fh_l0_20 + fh_l0_21 + fh_l0_22 + fh_l0_23 + fh_l0_24 + fh_l0_25 + fh_l0_26 + fh_l0_27 + fh_l0_28 + fh_l0_29 + fh_l0_30 + fh_l0_31) / 32;
    fh0_var = (((fh_l0_0) - fh0_mean)*((fh_l0_0) - fh0_mean) + ((fh_l0_1) - fh0_mean)*((fh_l0_1) - fh0_mean) + ((fh_l0_2) - fh0_mean)*((fh_l0_2) - fh0_mean) + ((fh_l0_3) - fh0_mean)*((fh_l0_3) - fh0_mean) + ((fh_l0_4) - fh0_mean)*((fh_l0_4) - fh0_mean) + ((fh_l0_5) - fh0_mean)*((fh_l0_5) - fh0_mean) + ((fh_l0_6) - fh0_mean)*((fh_l0_6) - fh0_mean) + ((fh_l0_7) - fh0_mean)*((fh_l0_7) - fh0_mean) + ((fh_l0_8) - fh0_mean)*((fh_l0_8) - fh0_mean) + ((fh_l0_9) - fh0_mean)*((fh_l0_9) - fh0_mean) + ((fh_l0_10) - fh0_mean)*((fh_l0_10) - fh0_mean) + ((fh_l0_11) - fh0_mean)*((fh_l0_11) - fh0_mean) + ((fh_l0_12) - fh0_mean)*((fh_l0_12) - fh0_mean) + ((fh_l0_13) - fh0_mean)*((fh_l0_13) - fh0_mean) + ((fh_l0_14) - fh0_mean)*((fh_l0_14) - fh0_mean) + ((fh_l0_15) - fh0_mean)*((fh_l0_15) - fh0_mean) + ((fh_l0_16) - fh0_mean)*((fh_l0_16) - fh0_mean) + ((fh_l0_17) - fh0_mean)*((fh_l0_17) - fh0_mean) + ((fh_l0_18) - fh0_mean)*((fh_l0_18) - fh0_mean) + ((fh_l0_19) - fh0_mean)*((fh_l0_19) - fh0_mean) + ((fh_l0_20) - fh0_mean)*((fh_l0_20) - fh0_mean) + ((fh_l0_21) - fh0_mean)*((fh_l0_21) - fh0_mean) + ((fh_l0_22) - fh0_mean)*((fh_l0_22) - fh0_mean) + ((fh_l0_23) - fh0_mean)*((fh_l0_23) - fh0_mean) + ((fh_l0_24) - fh0_mean)*((fh_l0_24) - fh0_mean) + ((fh_l0_25) - fh0_mean)*((fh_l0_25) - fh0_mean) + ((fh_l0_26) - fh0_mean)*((fh_l0_26) - fh0_mean) + ((fh_l0_27) - fh0_mean)*((fh_l0_27) - fh0_mean) + ((fh_l0_28) - fh0_mean)*((fh_l0_28) - fh0_mean) + ((fh_l0_29) - fh0_mean)*((fh_l0_29) - fh0_mean) + ((fh_l0_30) - fh0_mean)*((fh_l0_30) - fh0_mean) + ((fh_l0_31) - fh0_mean)*((fh_l0_31) - fh0_mean)) / 32;
    fh_n0_0 = (((fh_l0_0) - fh0_mean) / sqrt(fh0_var + ln_eps)) * (-1.2488063475757372e-05) + (5.9027261158917099e-06);
    fh_n0_1 = (((fh_l0_1) - fh0_mean) / sqrt(fh0_var + ln_eps)) * (0.50783222913742065) + (-0.17592434585094452);
    fh_n0_2 = (((fh_l0_2) - fh0_mean) / sqrt(fh0_var + ln_eps)) * (0.61142396926879883) + (-0.20453217625617981);
    fh_n0_3 = (((fh_l0_3) - fh0_mean) / sqrt(fh0_var + ln_eps)) * (7.2026805355562828e-06) + (5.9063136177428532e-06);
    fh_n0_4 = (((fh_l0_4) - fh0_mean) / sqrt(fh0_var + ln_eps)) * (-1.0832228269919142e-07) + (6.7393322922271182e-08);
    fh_n0_5 = (((fh_l0_5) - fh0_mean) / sqrt(fh0_var + ln_eps)) * (4.5433880586642772e-05) + (-2.2843511032988317e-05);
    fh_n0_6 = (((fh_l0_6) - fh0_mean) / sqrt(fh0_var + ln_eps)) * (0.26035621762275696) + (-0.027971990406513214);
    fh_n0_7 = (((fh_l0_7) - fh0_mean) / sqrt(fh0_var + ln_eps)) * (0.29020589590072632) + (-0.06552472710609436);
    fh_n0_8 = (((fh_l0_8) - fh0_mean) / sqrt(fh0_var + ln_eps)) * (0.32445219159126282) + (-0.2918931245803833);
    fh_n0_9 = (((fh_l0_9) - fh0_mean) / sqrt(fh0_var + ln_eps)) * (4.1926199628505856e-05) + (-2.0426326955202967e-05);
    fh_n0_10 = (((fh_l0_10) - fh0_mean) / sqrt(fh0_var + ln_eps)) * (0.38720405101776123) + (-0.1416301429271698);
    fh_n0_11 = (((fh_l0_11) - fh0_mean) / sqrt(fh0_var + ln_eps)) * (-8.8182870727759877e-11) + (1.1055597409770357e-10);
    fh_n0_12 = (((fh_l0_12) - fh0_mean) / sqrt(fh0_var + ln_eps)) * (6.132374892331427e-06) + (-9.6048233899637125e-06);
    fh_n0_13 = (((fh_l0_13) - fh0_mean) / sqrt(fh0_var + ln_eps)) * (-6.3659195102816479e-12) + (8.8670416495406634e-12);
    fh_n0_14 = (((fh_l0_14) - fh0_mean) / sqrt(fh0_var + ln_eps)) * (3.7809124478371814e-05) + (-1.7506881704321131e-05);
    fh_n0_15 = (((fh_l0_15) - fh0_mean) / sqrt(fh0_var + ln_eps)) * (-9.9784570920746773e-05) + (4.721921868622303e-05);
    fh_n0_16 = (((fh_l0_16) - fh0_mean) / sqrt(fh0_var + ln_eps)) * (1.6806005078251474e-05) + (-3.5638021245176787e-07);
    fh_n0_17 = (((fh_l0_17) - fh0_mean) / sqrt(fh0_var + ln_eps)) * (2.0976622181478888e-06) + (-1.1327413176331902e-06);
    fh_n0_18 = (((fh_l0_18) - fh0_mean) / sqrt(fh0_var + ln_eps)) * (0.27046763896942139) + (-0.086009524762630463);
    fh_n0_19 = (((fh_l0_19) - fh0_mean) / sqrt(fh0_var + ln_eps)) * (-1.2504318647188484e-06) + (-1.212426809615863e-06);
    fh_n0_20 = (((fh_l0_20) - fh0_mean) / sqrt(fh0_var + ln_eps)) * (0.82246118783950806) + (0.10688301175832748);
    fh_n0_21 = (((fh_l0_21) - fh0_mean) / sqrt(fh0_var + ln_eps)) * (-5.9366152527218219e-07) + (-6.5612260868874728e-07);
    fh_n0_22 = (((fh_l0_22) - fh0_mean) / sqrt(fh0_var + ln_eps)) * (-1.9315726603963412e-05) + (1.7350810594507493e-05);
    fh_n0_23 = (((fh_l0_23) - fh0_mean) / sqrt(fh0_var + ln_eps)) * (0.39495119452476501) + (-0.067111313343048096);
    fh_n0_24 = (((fh_l0_24) - fh0_mean) / sqrt(fh0_var + ln_eps)) * (0.45055189728736877) + (-0.19447968900203705);
    fh_n0_25 = (((fh_l0_25) - fh0_mean) / sqrt(fh0_var + ln_eps)) * (1.0876184205699246e-05) + (1.0306375770596787e-05);
    fh_n0_26 = (((fh_l0_26) - fh0_mean) / sqrt(fh0_var + ln_eps)) * (2.5140434445347637e-05) + (-1.2910237273899838e-05);
    fh_n0_27 = (((fh_l0_27) - fh0_mean) / sqrt(fh0_var + ln_eps)) * (-1.4681984794151504e-05) + (1.0116403245774563e-05);
    fh_n0_28 = (((fh_l0_28) - fh0_mean) / sqrt(fh0_var + ln_eps)) * (3.1521557275482337e-07) + (-4.4488700723377406e-07);
    fh_n0_29 = (((fh_l0_29) - fh0_mean) / sqrt(fh0_var + ln_eps)) * (0.72814404964447021) + (0.11249861866235733);
    fh_n0_30 = (((fh_l0_30) - fh0_mean) / sqrt(fh0_var + ln_eps)) * (4.2499275878071785e-05) + (-6.269751611398533e-05);
    fh_n0_31 = (((fh_l0_31) - fh0_mean) / sqrt(fh0_var + ln_eps)) * (0.46302837133407593) + (0.011631419882178307);
    fh_g0_0 = gelu_approx(fh_n0_0);
    fh_g0_1 = gelu_approx(fh_n0_1);
    fh_g0_2 = gelu_approx(fh_n0_2);
    fh_g0_3 = gelu_approx(fh_n0_3);
    fh_g0_4 = gelu_approx(fh_n0_4);
    fh_g0_5 = gelu_approx(fh_n0_5);
    fh_g0_6 = gelu_approx(fh_n0_6);
    fh_g0_7 = gelu_approx(fh_n0_7);
    fh_g0_8 = gelu_approx(fh_n0_8);
    fh_g0_9 = gelu_approx(fh_n0_9);
    fh_g0_10 = gelu_approx(fh_n0_10);
    fh_g0_11 = gelu_approx(fh_n0_11);
    fh_g0_12 = gelu_approx(fh_n0_12);
    fh_g0_13 = gelu_approx(fh_n0_13);
    fh_g0_14 = gelu_approx(fh_n0_14);
    fh_g0_15 = gelu_approx(fh_n0_15);
    fh_g0_16 = gelu_approx(fh_n0_16);
    fh_g0_17 = gelu_approx(fh_n0_17);
    fh_g0_18 = gelu_approx(fh_n0_18);
    fh_g0_19 = gelu_approx(fh_n0_19);
    fh_g0_20 = gelu_approx(fh_n0_20);
    fh_g0_21 = gelu_approx(fh_n0_21);
    fh_g0_22 = gelu_approx(fh_n0_22);
    fh_g0_23 = gelu_approx(fh_n0_23);
    fh_g0_24 = gelu_approx(fh_n0_24);
    fh_g0_25 = gelu_approx(fh_n0_25);
    fh_g0_26 = gelu_approx(fh_n0_26);
    fh_g0_27 = gelu_approx(fh_n0_27);
    fh_g0_28 = gelu_approx(fh_n0_28);
    fh_g0_29 = gelu_approx(fh_n0_29);
    fh_g0_30 = gelu_approx(fh_n0_30);
    fh_g0_31 = gelu_approx(fh_n0_31);
    fh_l1_0 = -0.16374108195304871;
    fh_l1_0 = fh_l1_0 + (6.9624530851797317e-07)*fh_g0_0;
    fh_l1_0 = fh_l1_0 + (0.017110159620642662)*fh_g0_1;
    fh_l1_0 = fh_l1_0 + (-0.0092921657487750053)*fh_g0_2;
    fh_l1_0 = fh_l1_0 + (5.7332414371558116e-07)*fh_g0_3;
    fh_l1_0 = fh_l1_0 + (1.5915093243279443e-08)*fh_g0_4;
    fh_l1_0 = fh_l1_0 + (-2.3268460154213244e-06)*fh_g0_5;
    fh_l1_0 = fh_l1_0 + (0.031539559364318848)*fh_g0_6;
    fh_l1_0 = fh_l1_0 + (0.019252942875027657)*fh_g0_7;
    fh_l1_0 = fh_l1_0 + (0.047228854149580002)*fh_g0_8;
    fh_l1_0 = fh_l1_0 + (-2.6589023036649451e-06)*fh_g0_9;
    fh_l1_0 = fh_l1_0 + (0.040373604744672775)*fh_g0_10;
    fh_l1_0 = fh_l1_0 + (9.4254064188920017e-13)*fh_g0_11;
    fh_l1_0 = fh_l1_0 + (-1.059286660165526e-06)*fh_g0_12;
    fh_l1_0 = fh_l1_0 + (6.1469828793042636e-13)*fh_g0_13;
    fh_l1_0 = fh_l1_0 + (-2.2499839360534679e-06)*fh_g0_14;
    fh_l1_0 = fh_l1_0 + (5.7295114856970031e-06)*fh_g0_15;
    fh_l1_0 = fh_l1_0 + (-1.595378495977684e-09)*fh_g0_16;
    fh_l1_0 = fh_l1_0 + (-1.3844238822002808e-07)*fh_g0_17;
    fh_l1_0 = fh_l1_0 + (-0.0040883524343371391)*fh_g0_18;
    fh_l1_0 = fh_l1_0 + (-1.0608126643774085e-07)*fh_g0_19;
    fh_l1_0 = fh_l1_0 + (-0.98752027750015259)*fh_g0_20;
    fh_l1_0 = fh_l1_0 + (4.5900949707800009e-09)*fh_g0_21;
    fh_l1_0 = fh_l1_0 + (8.8023277555748791e-08)*fh_g0_22;
    fh_l1_0 = fh_l1_0 + (0.18385264277458191)*fh_g0_23;
    fh_l1_0 = fh_l1_0 + (0.029226137325167656)*fh_g0_24;
    fh_l1_0 = fh_l1_0 + (8.4627635033029946e-07)*fh_g0_25;
    fh_l1_0 = fh_l1_0 + (-1.5547813063676585e-06)*fh_g0_26;
    fh_l1_0 = fh_l1_0 + (1.2577204415720189e-06)*fh_g0_27;
    fh_l1_0 = fh_l1_0 + (-4.9031154247813902e-08)*fh_g0_28;
    fh_l1_0 = fh_l1_0 + (0.79078638553619385)*fh_g0_29;
    fh_l1_0 = fh_l1_0 + (-2.7464959657663712e-06)*fh_g0_30;
    fh_l1_0 = fh_l1_0 + (0.11719588935375214)*fh_g0_31;
    fh_l1_1 = 0.08057112991809845;
    fh_l1_1 = fh_l1_1 + (1.9604419776442228e-07)*fh_g0_0;
    fh_l1_1 = fh_l1_1 + (-0.19696688652038574)*fh_g0_1;
    fh_l1_1 = fh_l1_1 + (-0.090311877429485321)*fh_g0_2;
    fh_l1_1 = fh_l1_1 + (4.7135285967669915e-06)*fh_g0_3;
    fh_l1_1 = fh_l1_1 + (2.5558467342534641e-08)*fh_g0_4;
    fh_l1_1 = fh_l1_1 + (-2.554014884026401e-07)*fh_g0_5;
    fh_l1_1 = fh_l1_1 + (-0.016213661059737206)*fh_g0_6;
    fh_l1_1 = fh_l1_1 + (-0.22040718793869019)*fh_g0_7;
    fh_l1_1 = fh_l1_1 + (-0.26486602425575256)*fh_g0_8;
    fh_l1_1 = fh_l1_1 + (-3.0033588700462133e-06)*fh_g0_9;
    fh_l1_1 = fh_l1_1 + (-0.24402546882629395)*fh_g0_10;
    fh_l1_1 = fh_l1_1 + (8.0219178522078494e-11)*fh_g0_11;
    fh_l1_1 = fh_l1_1 + (-4.7903185986797325e-06)*fh_g0_12;
    fh_l1_1 = fh_l1_1 + (5.8917139830055865e-13)*fh_g0_13;
    fh_l1_1 = fh_l1_1 + (-8.6734786464148783e-07)*fh_g0_14;
    fh_l1_1 = fh_l1_1 + (2.749825171122211e-06)*fh_g0_15;
    fh_l1_1 = fh_l1_1 + (-1.0478709555172827e-05)*fh_g0_16;
    fh_l1_1 = fh_l1_1 + (2.9260711187362176e-08)*fh_g0_17;
    fh_l1_1 = fh_l1_1 + (0.12703017890453339)*fh_g0_18;
    fh_l1_1 = fh_l1_1 + (-9.8882128440891393e-07)*fh_g0_19;
    fh_l1_1 = fh_l1_1 + (0.0024358669761568308)*fh_g0_20;
    fh_l1_1 = fh_l1_1 + (-2.6960631771544286e-07)*fh_g0_21;
    fh_l1_1 = fh_l1_1 + (1.46665934153134e-05)*fh_g0_22;
    fh_l1_1 = fh_l1_1 + (-0.090104222297668457)*fh_g0_23;
    fh_l1_1 = fh_l1_1 + (-0.23364810645580292)*fh_g0_24;
    fh_l1_1 = fh_l1_1 + (9.2432464953162707e-06)*fh_g0_25;
    fh_l1_1 = fh_l1_1 + (-2.9187458494561724e-07)*fh_g0_26;
    fh_l1_1 = fh_l1_1 + (2.2131830519356299e-06)*fh_g0_27;
    fh_l1_1 = fh_l1_1 + (-1.6742100683586614e-07)*fh_g0_28;
    fh_l1_1 = fh_l1_1 + (0.0068708844482898712)*fh_g0_29;
    fh_l1_1 = fh_l1_1 + (9.0394687504158355e-06)*fh_g0_30;
    fh_l1_1 = fh_l1_1 + (0.1218666210770607)*fh_g0_31;
    fh_l1_2 = 0.16294585168361664;
    fh_l1_2 = fh_l1_2 + (7.6608455401583342e-07)*fh_g0_0;
    fh_l1_2 = fh_l1_2 + (-0.030428055673837662)*fh_g0_1;
    fh_l1_2 = fh_l1_2 + (0.01449459046125412)*fh_g0_2;
    fh_l1_2 = fh_l1_2 + (-1.8846101283997996e-06)*fh_g0_3;
    fh_l1_2 = fh_l1_2 + (1.9495287162385466e-08)*fh_g0_4;
    fh_l1_2 = fh_l1_2 + (-3.9734345591568854e-06)*fh_g0_5;
    fh_l1_2 = fh_l1_2 + (0.1412847489118576)*fh_g0_6;
    fh_l1_2 = fh_l1_2 + (0.030339678749442101)*fh_g0_7;
    fh_l1_2 = fh_l1_2 + (0.0070632044225931168)*fh_g0_8;
    fh_l1_2 = fh_l1_2 + (-1.5100819155122736e-06)*fh_g0_9;
    fh_l1_2 = fh_l1_2 + (-0.020808292552828789)*fh_g0_10;
    fh_l1_2 = fh_l1_2 + (3.6020110505408098e-11)*fh_g0_11;
    fh_l1_2 = fh_l1_2 + (1.0608572154069407e-07)*fh_g0_12;
    fh_l1_2 = fh_l1_2 + (3.1546279477545625e-10)*fh_g0_13;
    fh_l1_2 = fh_l1_2 + (-1.6532958397874609e-06)*fh_g0_14;
    fh_l1_2 = fh_l1_2 + (-1.7242822991647699e-07)*fh_g0_15;
    fh_l1_2 = fh_l1_2 + (2.2672581962979166e-06)*fh_g0_16;
    fh_l1_2 = fh_l1_2 + (2.8542538998976852e-08)*fh_g0_17;
    fh_l1_2 = fh_l1_2 + (-0.097727172076702118)*fh_g0_18;
    fh_l1_2 = fh_l1_2 + (1.742209008170903e-07)*fh_g0_19;
    fh_l1_2 = fh_l1_2 + (0.11181413382291794)*fh_g0_20;
    fh_l1_2 = fh_l1_2 + (-1.0682812501272565e-07)*fh_g0_21;
    fh_l1_2 = fh_l1_2 + (3.3694195735733956e-05)*fh_g0_22;
    fh_l1_2 = fh_l1_2 + (0.056947380304336548)*fh_g0_23;
    fh_l1_2 = fh_l1_2 + (0.019918676465749741)*fh_g0_24;
    fh_l1_2 = fh_l1_2 + (-1.7297505792157608e-06)*fh_g0_25;
    fh_l1_2 = fh_l1_2 + (-1.0023635468314751e-06)*fh_g0_26;
    fh_l1_2 = fh_l1_2 + (3.334678311261996e-08)*fh_g0_27;
    fh_l1_2 = fh_l1_2 + (3.3274428545837509e-08)*fh_g0_28;
    fh_l1_2 = fh_l1_2 + (0.10912034660577774)*fh_g0_29;
    fh_l1_2 = fh_l1_2 + (-1.5276971680577844e-05)*fh_g0_30;
    fh_l1_2 = fh_l1_2 + (0.080098487436771393)*fh_g0_31;
    vt_pred = fh_l1_1;
    vdsat_raw = fh_l1_2;
    vdsat = 0.01 + 0.39 * sigmoid_lim(vdsat_raw);

    // fh_l1_0 is ML-predicted Q (same output used as Qg in sifet.py)
    q_ml_raw = fh_l1_0;
    qg = Wid * qdensity_scale * qraw_to_c * q_ml_raw;
    qs = -2.0/3.0 * qg;
    qd = -1.0/3.0 * qg;

    // Physics combination (mirrors sifet.py forward + run_twotower_sim scaling)
    cinv = 1.0e12 * eps_eff * 8.854e-12 / tox_eff;
    f_softplus = ln(1.0 + limexp((vgs_shift - vt_pred) / (n_par * 0.026)));
    log_vds = ln(vds_pos);
    log_vdsat = ln(smooth_pos(vdsat, smooth_delta));
    tmp_a = b_par * log_vdsat;
    tmp_b = b_par * log_vds;
    lse = logsumexp2_smooth(tmp_a, tmp_b, smooth_delta);
    log_id = ln(smooth_pos(cinv * n_par * 0.026, smooth_delta))
             + ln(smooth_pos(f_softplus, smooth_delta))
             + ln(smooth_pos(v0_par, smooth_delta))
             + log_vds
             - (1.0 / b_par) * lse;

    // Clamp exp argument for robust transient/DC convergence
    log_id_lim = 0.5*(log_id + log_id_max - sqrt((log_id - log_id_max)*(log_id - log_id_max) + smooth_delta));
    log_id_lim = 0.5*(log_id_lim + log_id_min + sqrt((log_id_lim - log_id_min)*(log_id_lim - log_id_min) + smooth_delta));

    // sifet.py returns exp(log_Id) * 1e-3 [A]
    ids_mag = 1.0e-3 * limexp(log_id_lim);
    ids = sign_vds * Wid * ids_mag;

    // Main branch current + small conductance for convergence
    I(d,s) <+ ids;
    I(d,s) <+ gmin_ds * V(d,s);

    I(g) <+ ddt(qg);
    I(s) <+ ddt(qs);
    I(d) <+ ddt(qd);
  end
endmodule
