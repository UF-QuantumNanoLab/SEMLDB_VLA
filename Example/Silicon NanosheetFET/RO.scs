// Design: example/3_stage_ring_osc_fringing_cap
simulator lang=spectre
global 0

// example/3_stage_ring_osc_fringing_cap/schematic
I47 (vout n2 vdd) SiNanosheetFET_PFET_ML tox=2 Lg=10 eps_ox=4 V_th=-0.2 ln_eps=1e-05 smooth_delta=1e-12 vds_floor=1e-06 vds_sign_smooth=0.001 exp_arg_limit=80 log_id_min=-120 log_id_max=80 gmin_ds=1e-12 Wid=1 qraw_to_c=1e-16 qdensity_scale=1
I41 (n1 vout vdd) SiNanosheetFET_PFET_ML tox=2 Lg=10 eps_ox=4 V_th=-0.2 ln_eps=1e-05 smooth_delta=1e-12 vds_floor=1e-06 vds_sign_smooth=0.001 exp_arg_limit=80 log_id_min=-120 log_id_max=80 gmin_ds=1e-12 Wid=1 qraw_to_c=1e-16 qdensity_scale=1
I42 (n2 n1 vdd) SiNanosheetFET_PFET_ML tox=2 Lg=10 eps_ox=4 V_th=-0.2 ln_eps=1e-05 smooth_delta=1e-12 vds_floor=1e-06 vds_sign_smooth=0.001 exp_arg_limit=80 log_id_min=-120 log_id_max=80 gmin_ds=1e-12 Wid=1 qraw_to_c=1e-16 qdensity_scale=1
V2 (vdd 0) vsource dc=500.0m type=dc
I44 (n2 n1 0) SiNanosheetFET_NFET_ML tox=2 Lg=10 eps_ox=4 V_th=0.2 ln_eps=1e-05 smooth_delta=1e-12 vds_floor=1e-06 vds_sign_smooth=0.001 exp_arg_limit=80 log_id_min=-120 log_id_max=80 gmin_ds=1e-12 Wid=1 qraw_to_c=1e-16 qdensity_scale=1
I45 (vout n2 0) SiNanosheetFET_NFET_ML tox=2 Lg=10 eps_ox=4 V_th=0.2 ln_eps=1e-05 smooth_delta=1e-12 vds_floor=1e-06 vds_sign_smooth=0.001 exp_arg_limit=80 log_id_min=-120 log_id_max=80 gmin_ds=1e-12 Wid=1 qraw_to_c=1e-16 qdensity_scale=1
I14 (n1 vout 0) SiNanosheetFET_NFET_ML tox=2 Lg=10 eps_ox=4 V_th=0.2 ln_eps=1e-05 smooth_delta=1e-12 vds_floor=1e-06 vds_sign_smooth=0.001 exp_arg_limit=80 log_id_min=-120 log_id_max=80 gmin_ds=1e-12 Wid=1 qraw_to_c=1e-16 qdensity_scale=1
C11 (n2 0) capacitor c=200.0a
C6 (n2 n1) capacitor c=200.0a
C10 (vout n2) capacitor c=200.0a
C3 (vout 0) capacitor c=200.0a
C5 (n1 n2) capacitor c=200.0a
C9 (n2 vout) capacitor c=200.0a
C4 (vdd n1) capacitor c=200.0a
C7 (n1 0) capacitor c=200.0a
C2 (n1 vout) capacitor c=200.0a
C0 (vdd vout) capacitor c=200.0a
C8 (vdd n2) capacitor c=200.0a
C1 (vout n1) capacitor c=200.0a
nodeset vout=0 n2=0.25 n1=0.5
simulatorOptions options temp=27
tran tran stop=300p maxstep=0.5p ic=node skipdc=yes
save vout n1 n2
ahdl_include "/ecel/UFAD/tanvir.ahmed/Desktop/Verilog/SiNanosheetFET/ade/example/pfet/veriloga/veriloga.va"
ahdl_include "/ecel/UFAD/tanvir.ahmed/Desktop/Verilog/SiNanosheetFET/ade/example/nfet/veriloga/veriloga.va"
