// Design: example/diamondfet_tb
simulator lang=spectre
global 0
parameters vdd=-5 vg=11
include "/apps/cds/IC618/local/GPDK045/gpdk045/../models/spectre/gpdk045.scs" section=mc

// example/diamondfet_tb/schematic
I0 (net2 vin 0) DiamondFET Lg=400 Lgs=900 Tox=17 Rc=0.9 current_mode=1 gmin_ds=1e-12 vds_sign_delta=0.0001
V1 (net2 0) vsource dc=vdd type=dc
V0 (vin 0) vsource dc=vg type=dc
simulatorOptions options temp=27
dcOp dc
dc dc param=vdd start=-12 stop=0 step=0.1
save I0:d
ahdl_include "/ecel/UFAD/tanvir.ahmed/Desktop/Verilog/DiamondFET/example/diamondfet/veriloga/veriloga.va"
