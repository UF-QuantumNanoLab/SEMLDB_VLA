// Design: example/inverter
simulator lang=spectre
global 0
parameters vdd=0.5 vg=0.5
include "/apps/cds/IC618/local/GPDK045/gpdk045/../models/spectre/gpdk045.scs" section=mc

// example/inverter/schematic
I0 (vout vin 0) CNTFET_VA tox=2 Lg=10 eps_ox=3.9 V_th=0.258 Wid=1 smooth_delta=1e-12 vds_floor=1e-06 gmin_ds=1e-12
I1 (vout vin vdd) CNTFET_PFET_VA tox=2 Lg=10 eps_ox=3.9 V_th=-0.258 Wid=1 smooth_delta=1e-12 vds_floor=1e-06 gmin_ds=1e-12
V1 (vdd 0) vsource dc=vdd type=dc
V0 (vin 0) vsource dc=vg type=dc
V2 (net2 0) vsource dc=0 type=pulse val0=0 val1=500.0m period=100p delay=0 rise=1p fall=1p width=50p
nodeset vout=0
simulatorOptions options temp=27
dcOp dc
dc dc param=vg start=0 stop=0.5 step=0.01
save vin vout
ahdl_include "/ecel/UFAD/tanvir.ahmed/Desktop/Verilog/CNTFET/example/nfet/veriloga/veriloga.va"
ahdl_include "/ecel/UFAD/tanvir.ahmed/Desktop/Verilog/CNTFET/example/pfet/veriloga/veriloga.va"
