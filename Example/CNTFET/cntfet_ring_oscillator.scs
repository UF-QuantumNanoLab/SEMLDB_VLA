// Design: example/RO
simulator lang=spectre
global 0
parameters vdd=0.5
include "/apps/cds/IC618/local/GPDK045/gpdk045/../models/spectre/gpdk045.scs" section=mc

// example/RO/schematic
V1 (vdd 0) vsource dc=vdd type=dc
I10 (vout3 vout2 0) CNTFET_VA tox=2 Lg=10 eps_ox=3.9 V_th=0.258 Wid=1 smooth_delta=1e-12 vds_floor=1e-06 gmin_ds=1e-12
I6 (vout2 vout1 0) CNTFET_VA tox=2 Lg=10 eps_ox=3.9 V_th=0.258 Wid=1 smooth_delta=1e-12 vds_floor=1e-06 gmin_ds=1e-12
I0 (vout1 vout3 0) CNTFET_VA tox=2 Lg=10 eps_ox=3.9 V_th=0.258 Wid=1 smooth_delta=1e-12 vds_floor=1e-06 gmin_ds=1e-12
I9 (vout3 vout2 vdd) CNTFET_PFET_VA tox=2 Lg=10 eps_ox=3.9 V_th=-0.258 Wid=1 smooth_delta=1e-12 vds_floor=1e-06 gmin_ds=1e-12
I8 (vout2 vout1 vdd) CNTFET_PFET_VA tox=2 Lg=10 eps_ox=3.9 V_th=-0.258 Wid=1 smooth_delta=1e-12 vds_floor=1e-06 gmin_ds=1e-12
I1 (vout1 vout3 vdd) CNTFET_PFET_VA tox=2 Lg=10 eps_ox=3.9 V_th=-0.258 Wid=1 smooth_delta=1e-12 vds_floor=1e-06 gmin_ds=1e-12
C2 (vout1 0) capacitor c=20a
C1 (vout2 0) capacitor c=20a
C0 (vout3 0) capacitor c=20a
nodeset vout3=0.5 vout2=0 vout1=0.5
simulatorOptions options temp=27
tran tran stop=120p maxstep=0.5p ic=node skipdc=yes
save vout2 vout3 vout1
ahdl_include "/ecel/UFAD/tanvir.ahmed/Desktop/Verilog/CNTFET/example/nfet/veriloga/veriloga.va"
ahdl_include "/ecel/UFAD/tanvir.ahmed/Desktop/Verilog/CNTFET/example/pfet/veriloga/veriloga.va"
