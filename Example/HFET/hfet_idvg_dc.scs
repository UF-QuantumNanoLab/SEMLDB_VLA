// Design: example/hfet_tb
simulator lang=spectre
global 0
parameters vdd=15 vg=5
include "/apps/cds/IC618/local/GPDK045/gpdk045/../models/spectre/gpdk045.scs" section=mc

// example/hfet_tb/schematic
I0 (net2 net1 0) HFETVA Lsg=1 Lgd=6 Lg=1.4 hpas=0.2 hAlGaN=0.02 hch=0.01 hg=0.11 current_mode=2 gmin_ds=1e-12 vds_sign_delta=0.0001
V1 (net2 0) vsource dc=vdd type=dc
V0 (net1 0) vsource dc=vg type=dc
simulatorOptions options temp=27
dcOp dc
dc dc param=vg start=-2 stop=8 step=0.1
save I0:d
ahdl_include "/ecel/UFAD/tanvir.ahmed/Desktop/Verilog/HFET/example/hfet/veriloga/veriloga.va"
