`include "constants.vams"
`include "disciplines.vams"

module TwoDFETVA(d, g, s);
  inout d, g, s;
  electrical d, g, s;

  // Device/model parameters
  parameter real tox = 3.0e-9;
  parameter real Lg = 12.0e-9;
  parameter real eps_ox = 20.0;
  parameter real meff = 0.5;
  parameter real D = 0.0;
  parameter real V_th = 0.0;
  parameter real Wid = 1.0 from [0:inf);

  // Numerical constants
  parameter real ln_eps = 1e-5;
  parameter real smooth_delta = 1e-12;
  parameter real vds_floor = 1e-6;
  parameter real vds_sign_smooth = 1e-3;
  parameter real log10_id_min = -20.0;
  parameter real log10_id_max = 20.0;
  parameter real id_log_eps = 1e-20;
  parameter real q_scale = 10.0;
  parameter real gmin_ds = 1e-12;

  // Internal scalars
  real vgs, vds, vgs_scaled, vds_scaled, vds_abs, sign_vds;
  real tox_scaled, lg_scaled, eps_ox_scaled, meff_scaled, d_scaled;
  real id_scaled, id_log10, id_log10_lim, ids_mag, ids;
  real q_scaled, q_ml_raw, qg, qs, qd;

  analog function real smooth_pos;
    input x, dlt;
    real x, dlt;
    begin
      smooth_pos = 0.5*(x + sqrt(x*x + dlt*dlt));
    end
  endfunction

  analog function real gelu_approx;
    input x;
    real x;
    real c;
    begin
      c = 0.79788456080286541;
      gelu_approx = 0.5 * x * (1.0 + tanh(c * (x + 0.044715*x*x*x)));
    end
  endfunction

  // Device token 0
  real dt0_l0_0;
  real dt0_l0_1;
  real dt0_l0_2;
  real dt0_l0_3;
  real dt0_l0_4;
  real dt0_l0_5;
  real dt0_l0_6;
  real dt0_l0_7;
  real dt0_l0_8;
  real dt0_l0_9;
  real dt0_l0_10;
  real dt0_l0_11;
  real dt0_l0_12;
  real dt0_l0_13;
  real dt0_l0_14;
  real dt0_l0_15;
  real dt0_l0_16;
  real dt0_l0_17;
  real dt0_l0_18;
  real dt0_l0_19;
  real dt0_l0_20;
  real dt0_l0_21;
  real dt0_l0_22;
  real dt0_l0_23;
  real dt0_l0_24;
  real dt0_l0_25;
  real dt0_l0_26;
  real dt0_l0_27;
  real dt0_l0_28;
  real dt0_l0_29;
  real dt0_l0_30;
  real dt0_l0_31;
  real dt0_n0_0;
  real dt0_n0_1;
  real dt0_n0_2;
  real dt0_n0_3;
  real dt0_n0_4;
  real dt0_n0_5;
  real dt0_n0_6;
  real dt0_n0_7;
  real dt0_n0_8;
  real dt0_n0_9;
  real dt0_n0_10;
  real dt0_n0_11;
  real dt0_n0_12;
  real dt0_n0_13;
  real dt0_n0_14;
  real dt0_n0_15;
  real dt0_n0_16;
  real dt0_n0_17;
  real dt0_n0_18;
  real dt0_n0_19;
  real dt0_n0_20;
  real dt0_n0_21;
  real dt0_n0_22;
  real dt0_n0_23;
  real dt0_n0_24;
  real dt0_n0_25;
  real dt0_n0_26;
  real dt0_n0_27;
  real dt0_n0_28;
  real dt0_n0_29;
  real dt0_n0_30;
  real dt0_n0_31;
  real dt0_g0_0;
  real dt0_g0_1;
  real dt0_g0_2;
  real dt0_g0_3;
  real dt0_g0_4;
  real dt0_g0_5;
  real dt0_g0_6;
  real dt0_g0_7;
  real dt0_g0_8;
  real dt0_g0_9;
  real dt0_g0_10;
  real dt0_g0_11;
  real dt0_g0_12;
  real dt0_g0_13;
  real dt0_g0_14;
  real dt0_g0_15;
  real dt0_g0_16;
  real dt0_g0_17;
  real dt0_g0_18;
  real dt0_g0_19;
  real dt0_g0_20;
  real dt0_g0_21;
  real dt0_g0_22;
  real dt0_g0_23;
  real dt0_g0_24;
  real dt0_g0_25;
  real dt0_g0_26;
  real dt0_g0_27;
  real dt0_g0_28;
  real dt0_g0_29;
  real dt0_g0_30;
  real dt0_g0_31;
  real dt0_l1_0;
  real dt0_l1_1;
  real dt0_l1_2;
  real dt0_l1_3;
  real dt0_l1_4;
  real dt0_l1_5;
  real dt0_l1_6;
  real dt0_l1_7;
  real dt0_l1_8;
  real dt0_l1_9;
  real dt0_l1_10;
  real dt0_l1_11;
  real dt0_l1_12;
  real dt0_l1_13;
  real dt0_l1_14;
  real dt0_l1_15;
  real dt0_mean;
  real dt0_var;

  // Device token 1
  real dt1_l0_0;
  real dt1_l0_1;
  real dt1_l0_2;
  real dt1_l0_3;
  real dt1_l0_4;
  real dt1_l0_5;
  real dt1_l0_6;
  real dt1_l0_7;
  real dt1_l0_8;
  real dt1_l0_9;
  real dt1_l0_10;
  real dt1_l0_11;
  real dt1_l0_12;
  real dt1_l0_13;
  real dt1_l0_14;
  real dt1_l0_15;
  real dt1_l0_16;
  real dt1_l0_17;
  real dt1_l0_18;
  real dt1_l0_19;
  real dt1_l0_20;
  real dt1_l0_21;
  real dt1_l0_22;
  real dt1_l0_23;
  real dt1_l0_24;
  real dt1_l0_25;
  real dt1_l0_26;
  real dt1_l0_27;
  real dt1_l0_28;
  real dt1_l0_29;
  real dt1_l0_30;
  real dt1_l0_31;
  real dt1_n0_0;
  real dt1_n0_1;
  real dt1_n0_2;
  real dt1_n0_3;
  real dt1_n0_4;
  real dt1_n0_5;
  real dt1_n0_6;
  real dt1_n0_7;
  real dt1_n0_8;
  real dt1_n0_9;
  real dt1_n0_10;
  real dt1_n0_11;
  real dt1_n0_12;
  real dt1_n0_13;
  real dt1_n0_14;
  real dt1_n0_15;
  real dt1_n0_16;
  real dt1_n0_17;
  real dt1_n0_18;
  real dt1_n0_19;
  real dt1_n0_20;
  real dt1_n0_21;
  real dt1_n0_22;
  real dt1_n0_23;
  real dt1_n0_24;
  real dt1_n0_25;
  real dt1_n0_26;
  real dt1_n0_27;
  real dt1_n0_28;
  real dt1_n0_29;
  real dt1_n0_30;
  real dt1_n0_31;
  real dt1_g0_0;
  real dt1_g0_1;
  real dt1_g0_2;
  real dt1_g0_3;
  real dt1_g0_4;
  real dt1_g0_5;
  real dt1_g0_6;
  real dt1_g0_7;
  real dt1_g0_8;
  real dt1_g0_9;
  real dt1_g0_10;
  real dt1_g0_11;
  real dt1_g0_12;
  real dt1_g0_13;
  real dt1_g0_14;
  real dt1_g0_15;
  real dt1_g0_16;
  real dt1_g0_17;
  real dt1_g0_18;
  real dt1_g0_19;
  real dt1_g0_20;
  real dt1_g0_21;
  real dt1_g0_22;
  real dt1_g0_23;
  real dt1_g0_24;
  real dt1_g0_25;
  real dt1_g0_26;
  real dt1_g0_27;
  real dt1_g0_28;
  real dt1_g0_29;
  real dt1_g0_30;
  real dt1_g0_31;
  real dt1_l1_0;
  real dt1_l1_1;
  real dt1_l1_2;
  real dt1_l1_3;
  real dt1_l1_4;
  real dt1_l1_5;
  real dt1_l1_6;
  real dt1_l1_7;
  real dt1_l1_8;
  real dt1_l1_9;
  real dt1_l1_10;
  real dt1_l1_11;
  real dt1_l1_12;
  real dt1_l1_13;
  real dt1_l1_14;
  real dt1_l1_15;
  real dt1_mean;
  real dt1_var;

  // Device token 2
  real dt2_l0_0;
  real dt2_l0_1;
  real dt2_l0_2;
  real dt2_l0_3;
  real dt2_l0_4;
  real dt2_l0_5;
  real dt2_l0_6;
  real dt2_l0_7;
  real dt2_l0_8;
  real dt2_l0_9;
  real dt2_l0_10;
  real dt2_l0_11;
  real dt2_l0_12;
  real dt2_l0_13;
  real dt2_l0_14;
  real dt2_l0_15;
  real dt2_l0_16;
  real dt2_l0_17;
  real dt2_l0_18;
  real dt2_l0_19;
  real dt2_l0_20;
  real dt2_l0_21;
  real dt2_l0_22;
  real dt2_l0_23;
  real dt2_l0_24;
  real dt2_l0_25;
  real dt2_l0_26;
  real dt2_l0_27;
  real dt2_l0_28;
  real dt2_l0_29;
  real dt2_l0_30;
  real dt2_l0_31;
  real dt2_n0_0;
  real dt2_n0_1;
  real dt2_n0_2;
  real dt2_n0_3;
  real dt2_n0_4;
  real dt2_n0_5;
  real dt2_n0_6;
  real dt2_n0_7;
  real dt2_n0_8;
  real dt2_n0_9;
  real dt2_n0_10;
  real dt2_n0_11;
  real dt2_n0_12;
  real dt2_n0_13;
  real dt2_n0_14;
  real dt2_n0_15;
  real dt2_n0_16;
  real dt2_n0_17;
  real dt2_n0_18;
  real dt2_n0_19;
  real dt2_n0_20;
  real dt2_n0_21;
  real dt2_n0_22;
  real dt2_n0_23;
  real dt2_n0_24;
  real dt2_n0_25;
  real dt2_n0_26;
  real dt2_n0_27;
  real dt2_n0_28;
  real dt2_n0_29;
  real dt2_n0_30;
  real dt2_n0_31;
  real dt2_g0_0;
  real dt2_g0_1;
  real dt2_g0_2;
  real dt2_g0_3;
  real dt2_g0_4;
  real dt2_g0_5;
  real dt2_g0_6;
  real dt2_g0_7;
  real dt2_g0_8;
  real dt2_g0_9;
  real dt2_g0_10;
  real dt2_g0_11;
  real dt2_g0_12;
  real dt2_g0_13;
  real dt2_g0_14;
  real dt2_g0_15;
  real dt2_g0_16;
  real dt2_g0_17;
  real dt2_g0_18;
  real dt2_g0_19;
  real dt2_g0_20;
  real dt2_g0_21;
  real dt2_g0_22;
  real dt2_g0_23;
  real dt2_g0_24;
  real dt2_g0_25;
  real dt2_g0_26;
  real dt2_g0_27;
  real dt2_g0_28;
  real dt2_g0_29;
  real dt2_g0_30;
  real dt2_g0_31;
  real dt2_l1_0;
  real dt2_l1_1;
  real dt2_l1_2;
  real dt2_l1_3;
  real dt2_l1_4;
  real dt2_l1_5;
  real dt2_l1_6;
  real dt2_l1_7;
  real dt2_l1_8;
  real dt2_l1_9;
  real dt2_l1_10;
  real dt2_l1_11;
  real dt2_l1_12;
  real dt2_l1_13;
  real dt2_l1_14;
  real dt2_l1_15;
  real dt2_mean;
  real dt2_var;

  // Device token 3
  real dt3_l0_0;
  real dt3_l0_1;
  real dt3_l0_2;
  real dt3_l0_3;
  real dt3_l0_4;
  real dt3_l0_5;
  real dt3_l0_6;
  real dt3_l0_7;
  real dt3_l0_8;
  real dt3_l0_9;
  real dt3_l0_10;
  real dt3_l0_11;
  real dt3_l0_12;
  real dt3_l0_13;
  real dt3_l0_14;
  real dt3_l0_15;
  real dt3_l0_16;
  real dt3_l0_17;
  real dt3_l0_18;
  real dt3_l0_19;
  real dt3_l0_20;
  real dt3_l0_21;
  real dt3_l0_22;
  real dt3_l0_23;
  real dt3_l0_24;
  real dt3_l0_25;
  real dt3_l0_26;
  real dt3_l0_27;
  real dt3_l0_28;
  real dt3_l0_29;
  real dt3_l0_30;
  real dt3_l0_31;
  real dt3_n0_0;
  real dt3_n0_1;
  real dt3_n0_2;
  real dt3_n0_3;
  real dt3_n0_4;
  real dt3_n0_5;
  real dt3_n0_6;
  real dt3_n0_7;
  real dt3_n0_8;
  real dt3_n0_9;
  real dt3_n0_10;
  real dt3_n0_11;
  real dt3_n0_12;
  real dt3_n0_13;
  real dt3_n0_14;
  real dt3_n0_15;
  real dt3_n0_16;
  real dt3_n0_17;
  real dt3_n0_18;
  real dt3_n0_19;
  real dt3_n0_20;
  real dt3_n0_21;
  real dt3_n0_22;
  real dt3_n0_23;
  real dt3_n0_24;
  real dt3_n0_25;
  real dt3_n0_26;
  real dt3_n0_27;
  real dt3_n0_28;
  real dt3_n0_29;
  real dt3_n0_30;
  real dt3_n0_31;
  real dt3_g0_0;
  real dt3_g0_1;
  real dt3_g0_2;
  real dt3_g0_3;
  real dt3_g0_4;
  real dt3_g0_5;
  real dt3_g0_6;
  real dt3_g0_7;
  real dt3_g0_8;
  real dt3_g0_9;
  real dt3_g0_10;
  real dt3_g0_11;
  real dt3_g0_12;
  real dt3_g0_13;
  real dt3_g0_14;
  real dt3_g0_15;
  real dt3_g0_16;
  real dt3_g0_17;
  real dt3_g0_18;
  real dt3_g0_19;
  real dt3_g0_20;
  real dt3_g0_21;
  real dt3_g0_22;
  real dt3_g0_23;
  real dt3_g0_24;
  real dt3_g0_25;
  real dt3_g0_26;
  real dt3_g0_27;
  real dt3_g0_28;
  real dt3_g0_29;
  real dt3_g0_30;
  real dt3_g0_31;
  real dt3_l1_0;
  real dt3_l1_1;
  real dt3_l1_2;
  real dt3_l1_3;
  real dt3_l1_4;
  real dt3_l1_5;
  real dt3_l1_6;
  real dt3_l1_7;
  real dt3_l1_8;
  real dt3_l1_9;
  real dt3_l1_10;
  real dt3_l1_11;
  real dt3_l1_12;
  real dt3_l1_13;
  real dt3_l1_14;
  real dt3_l1_15;
  real dt3_mean;
  real dt3_var;

  // Device token 4
  real dt4_l0_0;
  real dt4_l0_1;
  real dt4_l0_2;
  real dt4_l0_3;
  real dt4_l0_4;
  real dt4_l0_5;
  real dt4_l0_6;
  real dt4_l0_7;
  real dt4_l0_8;
  real dt4_l0_9;
  real dt4_l0_10;
  real dt4_l0_11;
  real dt4_l0_12;
  real dt4_l0_13;
  real dt4_l0_14;
  real dt4_l0_15;
  real dt4_l0_16;
  real dt4_l0_17;
  real dt4_l0_18;
  real dt4_l0_19;
  real dt4_l0_20;
  real dt4_l0_21;
  real dt4_l0_22;
  real dt4_l0_23;
  real dt4_l0_24;
  real dt4_l0_25;
  real dt4_l0_26;
  real dt4_l0_27;
  real dt4_l0_28;
  real dt4_l0_29;
  real dt4_l0_30;
  real dt4_l0_31;
  real dt4_n0_0;
  real dt4_n0_1;
  real dt4_n0_2;
  real dt4_n0_3;
  real dt4_n0_4;
  real dt4_n0_5;
  real dt4_n0_6;
  real dt4_n0_7;
  real dt4_n0_8;
  real dt4_n0_9;
  real dt4_n0_10;
  real dt4_n0_11;
  real dt4_n0_12;
  real dt4_n0_13;
  real dt4_n0_14;
  real dt4_n0_15;
  real dt4_n0_16;
  real dt4_n0_17;
  real dt4_n0_18;
  real dt4_n0_19;
  real dt4_n0_20;
  real dt4_n0_21;
  real dt4_n0_22;
  real dt4_n0_23;
  real dt4_n0_24;
  real dt4_n0_25;
  real dt4_n0_26;
  real dt4_n0_27;
  real dt4_n0_28;
  real dt4_n0_29;
  real dt4_n0_30;
  real dt4_n0_31;
  real dt4_g0_0;
  real dt4_g0_1;
  real dt4_g0_2;
  real dt4_g0_3;
  real dt4_g0_4;
  real dt4_g0_5;
  real dt4_g0_6;
  real dt4_g0_7;
  real dt4_g0_8;
  real dt4_g0_9;
  real dt4_g0_10;
  real dt4_g0_11;
  real dt4_g0_12;
  real dt4_g0_13;
  real dt4_g0_14;
  real dt4_g0_15;
  real dt4_g0_16;
  real dt4_g0_17;
  real dt4_g0_18;
  real dt4_g0_19;
  real dt4_g0_20;
  real dt4_g0_21;
  real dt4_g0_22;
  real dt4_g0_23;
  real dt4_g0_24;
  real dt4_g0_25;
  real dt4_g0_26;
  real dt4_g0_27;
  real dt4_g0_28;
  real dt4_g0_29;
  real dt4_g0_30;
  real dt4_g0_31;
  real dt4_l1_0;
  real dt4_l1_1;
  real dt4_l1_2;
  real dt4_l1_3;
  real dt4_l1_4;
  real dt4_l1_5;
  real dt4_l1_6;
  real dt4_l1_7;
  real dt4_l1_8;
  real dt4_l1_9;
  real dt4_l1_10;
  real dt4_l1_11;
  real dt4_l1_12;
  real dt4_l1_13;
  real dt4_l1_14;
  real dt4_l1_15;
  real dt4_mean;
  real dt4_var;

  real hp_0;
  real hp_1;
  real hp_2;
  real hp_3;
  real hp_4;
  real hp_5;
  real hp_6;
  real hp_7;
  real hp_8;
  real hp_9;
  real hp_10;
  real hp_11;
  real hp_12;
  real hp_13;
  real hp_14;
  real hp_15;
  real hpn_0;
  real hpn_1;
  real hpn_2;
  real hpn_3;
  real hpn_4;
  real hpn_5;
  real hpn_6;
  real hpn_7;
  real hpn_8;
  real hpn_9;
  real hpn_10;
  real hpn_11;
  real hpn_12;
  real hpn_13;
  real hpn_14;
  real hpn_15;
  real hp_mean;
  real hp_var;

  real bt_l0_0;
  real bt_l0_1;
  real bt_l0_2;
  real bt_l0_3;
  real bt_l0_4;
  real bt_l0_5;
  real bt_l0_6;
  real bt_l0_7;
  real bt_l0_8;
  real bt_l0_9;
  real bt_l0_10;
  real bt_l0_11;
  real bt_l0_12;
  real bt_l0_13;
  real bt_l0_14;
  real bt_l0_15;
  real bt_l0_16;
  real bt_l0_17;
  real bt_l0_18;
  real bt_l0_19;
  real bt_l0_20;
  real bt_l0_21;
  real bt_l0_22;
  real bt_l0_23;
  real bt_l0_24;
  real bt_l0_25;
  real bt_l0_26;
  real bt_l0_27;
  real bt_l0_28;
  real bt_l0_29;
  real bt_l0_30;
  real bt_l0_31;
  real bt_l0_32;
  real bt_l0_33;
  real bt_l0_34;
  real bt_l0_35;
  real bt_l0_36;
  real bt_l0_37;
  real bt_l0_38;
  real bt_l0_39;
  real bt_l0_40;
  real bt_l0_41;
  real bt_l0_42;
  real bt_l0_43;
  real bt_l0_44;
  real bt_l0_45;
  real bt_l0_46;
  real bt_l0_47;
  real bt_l0_48;
  real bt_l0_49;
  real bt_l0_50;
  real bt_l0_51;
  real bt_l0_52;
  real bt_l0_53;
  real bt_l0_54;
  real bt_l0_55;
  real bt_l0_56;
  real bt_l0_57;
  real bt_l0_58;
  real bt_l0_59;
  real bt_l0_60;
  real bt_l0_61;
  real bt_l0_62;
  real bt_l0_63;
  real bt_n0_0;
  real bt_n0_1;
  real bt_n0_2;
  real bt_n0_3;
  real bt_n0_4;
  real bt_n0_5;
  real bt_n0_6;
  real bt_n0_7;
  real bt_n0_8;
  real bt_n0_9;
  real bt_n0_10;
  real bt_n0_11;
  real bt_n0_12;
  real bt_n0_13;
  real bt_n0_14;
  real bt_n0_15;
  real bt_n0_16;
  real bt_n0_17;
  real bt_n0_18;
  real bt_n0_19;
  real bt_n0_20;
  real bt_n0_21;
  real bt_n0_22;
  real bt_n0_23;
  real bt_n0_24;
  real bt_n0_25;
  real bt_n0_26;
  real bt_n0_27;
  real bt_n0_28;
  real bt_n0_29;
  real bt_n0_30;
  real bt_n0_31;
  real bt_n0_32;
  real bt_n0_33;
  real bt_n0_34;
  real bt_n0_35;
  real bt_n0_36;
  real bt_n0_37;
  real bt_n0_38;
  real bt_n0_39;
  real bt_n0_40;
  real bt_n0_41;
  real bt_n0_42;
  real bt_n0_43;
  real bt_n0_44;
  real bt_n0_45;
  real bt_n0_46;
  real bt_n0_47;
  real bt_n0_48;
  real bt_n0_49;
  real bt_n0_50;
  real bt_n0_51;
  real bt_n0_52;
  real bt_n0_53;
  real bt_n0_54;
  real bt_n0_55;
  real bt_n0_56;
  real bt_n0_57;
  real bt_n0_58;
  real bt_n0_59;
  real bt_n0_60;
  real bt_n0_61;
  real bt_n0_62;
  real bt_n0_63;
  real bt_g0_0;
  real bt_g0_1;
  real bt_g0_2;
  real bt_g0_3;
  real bt_g0_4;
  real bt_g0_5;
  real bt_g0_6;
  real bt_g0_7;
  real bt_g0_8;
  real bt_g0_9;
  real bt_g0_10;
  real bt_g0_11;
  real bt_g0_12;
  real bt_g0_13;
  real bt_g0_14;
  real bt_g0_15;
  real bt_g0_16;
  real bt_g0_17;
  real bt_g0_18;
  real bt_g0_19;
  real bt_g0_20;
  real bt_g0_21;
  real bt_g0_22;
  real bt_g0_23;
  real bt_g0_24;
  real bt_g0_25;
  real bt_g0_26;
  real bt_g0_27;
  real bt_g0_28;
  real bt_g0_29;
  real bt_g0_30;
  real bt_g0_31;
  real bt_g0_32;
  real bt_g0_33;
  real bt_g0_34;
  real bt_g0_35;
  real bt_g0_36;
  real bt_g0_37;
  real bt_g0_38;
  real bt_g0_39;
  real bt_g0_40;
  real bt_g0_41;
  real bt_g0_42;
  real bt_g0_43;
  real bt_g0_44;
  real bt_g0_45;
  real bt_g0_46;
  real bt_g0_47;
  real bt_g0_48;
  real bt_g0_49;
  real bt_g0_50;
  real bt_g0_51;
  real bt_g0_52;
  real bt_g0_53;
  real bt_g0_54;
  real bt_g0_55;
  real bt_g0_56;
  real bt_g0_57;
  real bt_g0_58;
  real bt_g0_59;
  real bt_g0_60;
  real bt_g0_61;
  real bt_g0_62;
  real bt_g0_63;
  real bt_l1_0;
  real bt_l1_1;
  real bt_l1_2;
  real bt_l1_3;
  real bt_l1_4;
  real bt_l1_5;
  real bt_l1_6;
  real bt_l1_7;
  real bt_l1_8;
  real bt_l1_9;
  real bt_l1_10;
  real bt_l1_11;
  real bt_l1_12;
  real bt_l1_13;
  real bt_l1_14;
  real bt_l1_15;
  real bt_l1_16;
  real bt_l1_17;
  real bt_l1_18;
  real bt_l1_19;
  real bt_l1_20;
  real bt_l1_21;
  real bt_l1_22;
  real bt_l1_23;
  real bt_l1_24;
  real bt_l1_25;
  real bt_l1_26;
  real bt_l1_27;
  real bt_l1_28;
  real bt_l1_29;
  real bt_l1_30;
  real bt_l1_31;
  real bt_l1_32;
  real bt_l1_33;
  real bt_l1_34;
  real bt_l1_35;
  real bt_l1_36;
  real bt_l1_37;
  real bt_l1_38;
  real bt_l1_39;
  real bt_l1_40;
  real bt_l1_41;
  real bt_l1_42;
  real bt_l1_43;
  real bt_l1_44;
  real bt_l1_45;
  real bt_l1_46;
  real bt_l1_47;
  real bt_l1_48;
  real bt_l1_49;
  real bt_l1_50;
  real bt_l1_51;
  real bt_l1_52;
  real bt_l1_53;
  real bt_l1_54;
  real bt_l1_55;
  real bt_l1_56;
  real bt_l1_57;
  real bt_l1_58;
  real bt_l1_59;
  real bt_l1_60;
  real bt_l1_61;
  real bt_l1_62;
  real bt_l1_63;
  real bt_n1_0;
  real bt_n1_1;
  real bt_n1_2;
  real bt_n1_3;
  real bt_n1_4;
  real bt_n1_5;
  real bt_n1_6;
  real bt_n1_7;
  real bt_n1_8;
  real bt_n1_9;
  real bt_n1_10;
  real bt_n1_11;
  real bt_n1_12;
  real bt_n1_13;
  real bt_n1_14;
  real bt_n1_15;
  real bt_n1_16;
  real bt_n1_17;
  real bt_n1_18;
  real bt_n1_19;
  real bt_n1_20;
  real bt_n1_21;
  real bt_n1_22;
  real bt_n1_23;
  real bt_n1_24;
  real bt_n1_25;
  real bt_n1_26;
  real bt_n1_27;
  real bt_n1_28;
  real bt_n1_29;
  real bt_n1_30;
  real bt_n1_31;
  real bt_n1_32;
  real bt_n1_33;
  real bt_n1_34;
  real bt_n1_35;
  real bt_n1_36;
  real bt_n1_37;
  real bt_n1_38;
  real bt_n1_39;
  real bt_n1_40;
  real bt_n1_41;
  real bt_n1_42;
  real bt_n1_43;
  real bt_n1_44;
  real bt_n1_45;
  real bt_n1_46;
  real bt_n1_47;
  real bt_n1_48;
  real bt_n1_49;
  real bt_n1_50;
  real bt_n1_51;
  real bt_n1_52;
  real bt_n1_53;
  real bt_n1_54;
  real bt_n1_55;
  real bt_n1_56;
  real bt_n1_57;
  real bt_n1_58;
  real bt_n1_59;
  real bt_n1_60;
  real bt_n1_61;
  real bt_n1_62;
  real bt_n1_63;
  real bt_g1_0;
  real bt_g1_1;
  real bt_g1_2;
  real bt_g1_3;
  real bt_g1_4;
  real bt_g1_5;
  real bt_g1_6;
  real bt_g1_7;
  real bt_g1_8;
  real bt_g1_9;
  real bt_g1_10;
  real bt_g1_11;
  real bt_g1_12;
  real bt_g1_13;
  real bt_g1_14;
  real bt_g1_15;
  real bt_g1_16;
  real bt_g1_17;
  real bt_g1_18;
  real bt_g1_19;
  real bt_g1_20;
  real bt_g1_21;
  real bt_g1_22;
  real bt_g1_23;
  real bt_g1_24;
  real bt_g1_25;
  real bt_g1_26;
  real bt_g1_27;
  real bt_g1_28;
  real bt_g1_29;
  real bt_g1_30;
  real bt_g1_31;
  real bt_g1_32;
  real bt_g1_33;
  real bt_g1_34;
  real bt_g1_35;
  real bt_g1_36;
  real bt_g1_37;
  real bt_g1_38;
  real bt_g1_39;
  real bt_g1_40;
  real bt_g1_41;
  real bt_g1_42;
  real bt_g1_43;
  real bt_g1_44;
  real bt_g1_45;
  real bt_g1_46;
  real bt_g1_47;
  real bt_g1_48;
  real bt_g1_49;
  real bt_g1_50;
  real bt_g1_51;
  real bt_g1_52;
  real bt_g1_53;
  real bt_g1_54;
  real bt_g1_55;
  real bt_g1_56;
  real bt_g1_57;
  real bt_g1_58;
  real bt_g1_59;
  real bt_g1_60;
  real bt_g1_61;
  real bt_g1_62;
  real bt_g1_63;
  real hv_0;
  real hv_1;
  real hv_2;
  real hv_3;
  real hv_4;
  real hv_5;
  real hv_6;
  real hv_7;
  real hv_8;
  real hv_9;
  real hv_10;
  real hv_11;
  real hv_12;
  real hv_13;
  real hv_14;
  real hv_15;
  real bt0_mean;
  real bt0_var;
  real bt1_mean;
  real bt1_var;

  real film_0;
  real film_1;
  real film_2;
  real film_3;
  real film_4;
  real film_5;
  real film_6;
  real film_7;
  real film_8;
  real film_9;
  real film_10;
  real film_11;
  real film_12;
  real film_13;
  real film_14;
  real film_15;
  real film_16;
  real film_17;
  real film_18;
  real film_19;
  real film_20;
  real film_21;
  real film_22;
  real film_23;
  real film_24;
  real film_25;
  real film_26;
  real film_27;
  real film_28;
  real film_29;
  real film_30;
  real film_31;
  real hfp_0;
  real hfp_1;
  real hfp_2;
  real hfp_3;
  real hfp_4;
  real hfp_5;
  real hfp_6;
  real hfp_7;
  real hfp_8;
  real hfp_9;
  real hfp_10;
  real hfp_11;
  real hfp_12;
  real hfp_13;
  real hfp_14;
  real hfp_15;
  real hfn_0;
  real hfn_1;
  real hfn_2;
  real hfn_3;
  real hfn_4;
  real hfn_5;
  real hfn_6;
  real hfn_7;
  real hfn_8;
  real hfn_9;
  real hfn_10;
  real hfn_11;
  real hfn_12;
  real hfn_13;
  real hfn_14;
  real hfn_15;
  real fh_l0_0;
  real fh_l0_1;
  real fh_l0_2;
  real fh_l0_3;
  real fh_l0_4;
  real fh_l0_5;
  real fh_l0_6;
  real fh_l0_7;
  real fh_l0_8;
  real fh_l0_9;
  real fh_l0_10;
  real fh_l0_11;
  real fh_l0_12;
  real fh_l0_13;
  real fh_l0_14;
  real fh_l0_15;
  real fh_l0_16;
  real fh_l0_17;
  real fh_l0_18;
  real fh_l0_19;
  real fh_l0_20;
  real fh_l0_21;
  real fh_l0_22;
  real fh_l0_23;
  real fh_l0_24;
  real fh_l0_25;
  real fh_l0_26;
  real fh_l0_27;
  real fh_l0_28;
  real fh_l0_29;
  real fh_l0_30;
  real fh_l0_31;
  real fh_l0_32;
  real fh_l0_33;
  real fh_l0_34;
  real fh_l0_35;
  real fh_l0_36;
  real fh_l0_37;
  real fh_l0_38;
  real fh_l0_39;
  real fh_l0_40;
  real fh_l0_41;
  real fh_l0_42;
  real fh_l0_43;
  real fh_l0_44;
  real fh_l0_45;
  real fh_l0_46;
  real fh_l0_47;
  real fh_l0_48;
  real fh_l0_49;
  real fh_l0_50;
  real fh_l0_51;
  real fh_l0_52;
  real fh_l0_53;
  real fh_l0_54;
  real fh_l0_55;
  real fh_l0_56;
  real fh_l0_57;
  real fh_l0_58;
  real fh_l0_59;
  real fh_l0_60;
  real fh_l0_61;
  real fh_l0_62;
  real fh_l0_63;
  real fh_n0_0;
  real fh_n0_1;
  real fh_n0_2;
  real fh_n0_3;
  real fh_n0_4;
  real fh_n0_5;
  real fh_n0_6;
  real fh_n0_7;
  real fh_n0_8;
  real fh_n0_9;
  real fh_n0_10;
  real fh_n0_11;
  real fh_n0_12;
  real fh_n0_13;
  real fh_n0_14;
  real fh_n0_15;
  real fh_n0_16;
  real fh_n0_17;
  real fh_n0_18;
  real fh_n0_19;
  real fh_n0_20;
  real fh_n0_21;
  real fh_n0_22;
  real fh_n0_23;
  real fh_n0_24;
  real fh_n0_25;
  real fh_n0_26;
  real fh_n0_27;
  real fh_n0_28;
  real fh_n0_29;
  real fh_n0_30;
  real fh_n0_31;
  real fh_n0_32;
  real fh_n0_33;
  real fh_n0_34;
  real fh_n0_35;
  real fh_n0_36;
  real fh_n0_37;
  real fh_n0_38;
  real fh_n0_39;
  real fh_n0_40;
  real fh_n0_41;
  real fh_n0_42;
  real fh_n0_43;
  real fh_n0_44;
  real fh_n0_45;
  real fh_n0_46;
  real fh_n0_47;
  real fh_n0_48;
  real fh_n0_49;
  real fh_n0_50;
  real fh_n0_51;
  real fh_n0_52;
  real fh_n0_53;
  real fh_n0_54;
  real fh_n0_55;
  real fh_n0_56;
  real fh_n0_57;
  real fh_n0_58;
  real fh_n0_59;
  real fh_n0_60;
  real fh_n0_61;
  real fh_n0_62;
  real fh_n0_63;
  real fh_g0_0;
  real fh_g0_1;
  real fh_g0_2;
  real fh_g0_3;
  real fh_g0_4;
  real fh_g0_5;
  real fh_g0_6;
  real fh_g0_7;
  real fh_g0_8;
  real fh_g0_9;
  real fh_g0_10;
  real fh_g0_11;
  real fh_g0_12;
  real fh_g0_13;
  real fh_g0_14;
  real fh_g0_15;
  real fh_g0_16;
  real fh_g0_17;
  real fh_g0_18;
  real fh_g0_19;
  real fh_g0_20;
  real fh_g0_21;
  real fh_g0_22;
  real fh_g0_23;
  real fh_g0_24;
  real fh_g0_25;
  real fh_g0_26;
  real fh_g0_27;
  real fh_g0_28;
  real fh_g0_29;
  real fh_g0_30;
  real fh_g0_31;
  real fh_g0_32;
  real fh_g0_33;
  real fh_g0_34;
  real fh_g0_35;
  real fh_g0_36;
  real fh_g0_37;
  real fh_g0_38;
  real fh_g0_39;
  real fh_g0_40;
  real fh_g0_41;
  real fh_g0_42;
  real fh_g0_43;
  real fh_g0_44;
  real fh_g0_45;
  real fh_g0_46;
  real fh_g0_47;
  real fh_g0_48;
  real fh_g0_49;
  real fh_g0_50;
  real fh_g0_51;
  real fh_g0_52;
  real fh_g0_53;
  real fh_g0_54;
  real fh_g0_55;
  real fh_g0_56;
  real fh_g0_57;
  real fh_g0_58;
  real fh_g0_59;
  real fh_g0_60;
  real fh_g0_61;
  real fh_g0_62;
  real fh_g0_63;
  real fh_l1_0;
  real fh_l1_1;
  real hf_mean;
  real hf_var;
  real fh0_mean;
  real fh0_var;

  analog begin
    vgs = V(g,s);
    vds = V(d,s);
    vds_abs = sqrt(vds*vds + vds_floor*vds_floor);
    sign_vds = vds / sqrt(vds*vds + vds_sign_smooth*vds_sign_smooth);

    // Match the StandardScaler objects saved by the training pipeline.
    tox_scaled = (tox - (1.9500666999999998e-09)) / (7.0785899200000001e-10);
    lg_scaled = (Lg - (1.44512793e-08)) / (8.5283887199999998e-09);
    eps_ox_scaled = (eps_ox - (14.085744399999999)) / (7.4167798899999999);
    meff_scaled = (meff - (0.5)) / (1);
    d_scaled = (D - (0)) / (1);
    vgs_scaled = (vgs - (0.22494833)) / (0.2200616);
    vds_scaled = (vds - (0.25100971)) / (0.14791061);

    // Device tower token 0
    dt0_l0_0 = (-0.8023525082587728) + (0.34432113170623779)*tox_scaled;
    dt0_l0_1 = (1.182430794400591) + (0.47822898626327515)*tox_scaled;
    dt0_l0_2 = (-0.10836726072198438) + (0.24066966772079468)*tox_scaled;
    dt0_l0_3 = (0.13846467006729224) + (0.048484642058610916)*tox_scaled;
    dt0_l0_4 = (0.16364279918559532) + (0.13176910579204559)*tox_scaled;
    dt0_l0_5 = (-0.44950437326971782) + (-0.30407708883285522)*tox_scaled;
    dt0_l0_6 = (1.0000458914764527) + (-0.11684082448482513)*tox_scaled;
    dt0_l0_7 = (0.18781458011366642) + (0.040982868522405624)*tox_scaled;
    dt0_l0_8 = (0.66435803052822484) + (0.61334097385406494)*tox_scaled;
    dt0_l0_9 = (0.53842760343352325) + (0.14561383426189423)*tox_scaled;
    dt0_l0_10 = (0.60123736955655827) + (0.45312285423278809)*tox_scaled;
    dt0_l0_11 = (0.50792064044126706) + (-0.057421129196882248)*tox_scaled;
    dt0_l0_12 = (0.24944808926927897) + (0.076745271682739258)*tox_scaled;
    dt0_l0_13 = (0.98067643362561574) + (0.11903565376996994)*tox_scaled;
    dt0_l0_14 = (0.18430518679767749) + (0.049182634800672531)*tox_scaled;
    dt0_l0_15 = (-0.11654510646304561) + (0.39639326930046082)*tox_scaled;
    dt0_l0_16 = (-0.83294163829167822) + (-0.5463671088218689)*tox_scaled;
    dt0_l0_17 = (1.9416807345416589) + (-0.34476840496063232)*tox_scaled;
    dt0_l0_18 = (-0.0035504757598052716) + (0.042969517409801483)*tox_scaled;
    dt0_l0_19 = (-0.57286729417833526) + (-0.30303272604942322)*tox_scaled;
    dt0_l0_20 = (0.55658716407008813) + (0.073118828237056732)*tox_scaled;
    dt0_l0_21 = (0.077784225191353251) + (0.060475107282400131)*tox_scaled;
    dt0_l0_22 = (0.73506343569293453) + (0.23183275759220123)*tox_scaled;
    dt0_l0_23 = (0.17980478821865875) + (0.0091169727966189384)*tox_scaled;
    dt0_l0_24 = (-0.33546897643725127) + (-0.022656848654150963)*tox_scaled;
    dt0_l0_25 = (0.36824164057682363) + (0.13182426989078522)*tox_scaled;
    dt0_l0_26 = (-0.095212549255361822) + (-0.41274189949035645)*tox_scaled;
    dt0_l0_27 = (-0.75920021345997446) + (0.14568156003952026)*tox_scaled;
    dt0_l0_28 = (-0.16765339563447584) + (-0.67684346437454224)*tox_scaled;
    dt0_l0_29 = (0.14338330963398693) + (0.01818244531750679)*tox_scaled;
    dt0_l0_30 = (0.61117950499625273) + (0.22900021076202393)*tox_scaled;
    dt0_l0_31 = (0.69205028181873385) + (-0.24716407060623169)*tox_scaled;
    dt0_mean = (dt0_l0_0 + dt0_l0_1 + dt0_l0_2 + dt0_l0_3 + dt0_l0_4 + dt0_l0_5 + dt0_l0_6 + dt0_l0_7 + dt0_l0_8 + dt0_l0_9 + dt0_l0_10 + dt0_l0_11 + dt0_l0_12 + dt0_l0_13 + dt0_l0_14 + dt0_l0_15 + dt0_l0_16 + dt0_l0_17 + dt0_l0_18 + dt0_l0_19 + dt0_l0_20 + dt0_l0_21 + dt0_l0_22 + dt0_l0_23 + dt0_l0_24 + dt0_l0_25 + dt0_l0_26 + dt0_l0_27 + dt0_l0_28 + dt0_l0_29 + dt0_l0_30 + dt0_l0_31) / 32;
    dt0_var = (((dt0_l0_0) - dt0_mean)*((dt0_l0_0) - dt0_mean) + ((dt0_l0_1) - dt0_mean)*((dt0_l0_1) - dt0_mean) + ((dt0_l0_2) - dt0_mean)*((dt0_l0_2) - dt0_mean) + ((dt0_l0_3) - dt0_mean)*((dt0_l0_3) - dt0_mean) + ((dt0_l0_4) - dt0_mean)*((dt0_l0_4) - dt0_mean) + ((dt0_l0_5) - dt0_mean)*((dt0_l0_5) - dt0_mean) + ((dt0_l0_6) - dt0_mean)*((dt0_l0_6) - dt0_mean) + ((dt0_l0_7) - dt0_mean)*((dt0_l0_7) - dt0_mean) + ((dt0_l0_8) - dt0_mean)*((dt0_l0_8) - dt0_mean) + ((dt0_l0_9) - dt0_mean)*((dt0_l0_9) - dt0_mean) + ((dt0_l0_10) - dt0_mean)*((dt0_l0_10) - dt0_mean) + ((dt0_l0_11) - dt0_mean)*((dt0_l0_11) - dt0_mean) + ((dt0_l0_12) - dt0_mean)*((dt0_l0_12) - dt0_mean) + ((dt0_l0_13) - dt0_mean)*((dt0_l0_13) - dt0_mean) + ((dt0_l0_14) - dt0_mean)*((dt0_l0_14) - dt0_mean) + ((dt0_l0_15) - dt0_mean)*((dt0_l0_15) - dt0_mean) + ((dt0_l0_16) - dt0_mean)*((dt0_l0_16) - dt0_mean) + ((dt0_l0_17) - dt0_mean)*((dt0_l0_17) - dt0_mean) + ((dt0_l0_18) - dt0_mean)*((dt0_l0_18) - dt0_mean) + ((dt0_l0_19) - dt0_mean)*((dt0_l0_19) - dt0_mean) + ((dt0_l0_20) - dt0_mean)*((dt0_l0_20) - dt0_mean) + ((dt0_l0_21) - dt0_mean)*((dt0_l0_21) - dt0_mean) + ((dt0_l0_22) - dt0_mean)*((dt0_l0_22) - dt0_mean) + ((dt0_l0_23) - dt0_mean)*((dt0_l0_23) - dt0_mean) + ((dt0_l0_24) - dt0_mean)*((dt0_l0_24) - dt0_mean) + ((dt0_l0_25) - dt0_mean)*((dt0_l0_25) - dt0_mean) + ((dt0_l0_26) - dt0_mean)*((dt0_l0_26) - dt0_mean) + ((dt0_l0_27) - dt0_mean)*((dt0_l0_27) - dt0_mean) + ((dt0_l0_28) - dt0_mean)*((dt0_l0_28) - dt0_mean) + ((dt0_l0_29) - dt0_mean)*((dt0_l0_29) - dt0_mean) + ((dt0_l0_30) - dt0_mean)*((dt0_l0_30) - dt0_mean) + ((dt0_l0_31) - dt0_mean)*((dt0_l0_31) - dt0_mean)) / 32;
    dt0_n0_0 = (((dt0_l0_0) - dt0_mean) / sqrt(dt0_var + ln_eps)) * (1.1696591377258301) + (-0.11109431833028793);
    dt0_g0_0 = gelu_approx(dt0_n0_0);
    dt0_n0_1 = (((dt0_l0_1) - dt0_mean) / sqrt(dt0_var + ln_eps)) * (1.1050513982772827) + (-0.035068709403276443);
    dt0_g0_1 = gelu_approx(dt0_n0_1);
    dt0_n0_2 = (((dt0_l0_2) - dt0_mean) / sqrt(dt0_var + ln_eps)) * (1.04068922996521) + (-0.089032895863056183);
    dt0_g0_2 = gelu_approx(dt0_n0_2);
    dt0_n0_3 = (((dt0_l0_3) - dt0_mean) / sqrt(dt0_var + ln_eps)) * (0.67314571142196655) + (-0.25178694725036621);
    dt0_g0_3 = gelu_approx(dt0_n0_3);
    dt0_n0_4 = (((dt0_l0_4) - dt0_mean) / sqrt(dt0_var + ln_eps)) * (0.85388195514678955) + (-0.12780840694904327);
    dt0_g0_4 = gelu_approx(dt0_n0_4);
    dt0_n0_5 = (((dt0_l0_5) - dt0_mean) / sqrt(dt0_var + ln_eps)) * (1.2238403558731079) + (-0.017596408724784851);
    dt0_g0_5 = gelu_approx(dt0_n0_5);
    dt0_n0_6 = (((dt0_l0_6) - dt0_mean) / sqrt(dt0_var + ln_eps)) * (0.98674929141998291) + (-0.047802694141864777);
    dt0_g0_6 = gelu_approx(dt0_n0_6);
    dt0_n0_7 = (((dt0_l0_7) - dt0_mean) / sqrt(dt0_var + ln_eps)) * (0.73881924152374268) + (-0.26099607348442078);
    dt0_g0_7 = gelu_approx(dt0_n0_7);
    dt0_n0_8 = (((dt0_l0_8) - dt0_mean) / sqrt(dt0_var + ln_eps)) * (1.0608246326446533) + (-0.078888535499572754);
    dt0_g0_8 = gelu_approx(dt0_n0_8);
    dt0_n0_9 = (((dt0_l0_9) - dt0_mean) / sqrt(dt0_var + ln_eps)) * (0.785602867603302) + (-0.15794672071933746);
    dt0_g0_9 = gelu_approx(dt0_n0_9);
    dt0_n0_10 = (((dt0_l0_10) - dt0_mean) / sqrt(dt0_var + ln_eps)) * (1.020018458366394) + (-0.036895915865898132);
    dt0_g0_10 = gelu_approx(dt0_n0_10);
    dt0_n0_11 = (((dt0_l0_11) - dt0_mean) / sqrt(dt0_var + ln_eps)) * (0.85727518796920776) + (-0.12107124924659729);
    dt0_g0_11 = gelu_approx(dt0_n0_11);
    dt0_n0_12 = (((dt0_l0_12) - dt0_mean) / sqrt(dt0_var + ln_eps)) * (0.72308427095413208) + (-0.25479298830032349);
    dt0_g0_12 = gelu_approx(dt0_n0_12);
    dt0_n0_13 = (((dt0_l0_13) - dt0_mean) / sqrt(dt0_var + ln_eps)) * (0.86266148090362549) + (-0.14110274612903595);
    dt0_g0_13 = gelu_approx(dt0_n0_13);
    dt0_n0_14 = (((dt0_l0_14) - dt0_mean) / sqrt(dt0_var + ln_eps)) * (0.74258971214294434) + (-0.25694161653518677);
    dt0_g0_14 = gelu_approx(dt0_n0_14);
    dt0_n0_15 = (((dt0_l0_15) - dt0_mean) / sqrt(dt0_var + ln_eps)) * (1.0297513008117676) + (-0.048506777733564377);
    dt0_g0_15 = gelu_approx(dt0_n0_15);
    dt0_n0_16 = (((dt0_l0_16) - dt0_mean) / sqrt(dt0_var + ln_eps)) * (1.6998714208602905) + (0.031608574092388153);
    dt0_g0_16 = gelu_approx(dt0_n0_16);
    dt0_n0_17 = (((dt0_l0_17) - dt0_mean) / sqrt(dt0_var + ln_eps)) * (1.0622228384017944) + (-0.10873574018478394);
    dt0_g0_17 = gelu_approx(dt0_n0_17);
    dt0_n0_18 = (((dt0_l0_18) - dt0_mean) / sqrt(dt0_var + ln_eps)) * (0.84898489713668823) + (-0.16742095351219177);
    dt0_g0_18 = gelu_approx(dt0_n0_18);
    dt0_n0_19 = (((dt0_l0_19) - dt0_mean) / sqrt(dt0_var + ln_eps)) * (1.0004963874816895) + (-0.040494922548532486);
    dt0_g0_19 = gelu_approx(dt0_n0_19);
    dt0_n0_20 = (((dt0_l0_20) - dt0_mean) / sqrt(dt0_var + ln_eps)) * (0.81684249639511108) + (-0.19029967486858368);
    dt0_g0_20 = gelu_approx(dt0_n0_20);
    dt0_n0_21 = (((dt0_l0_21) - dt0_mean) / sqrt(dt0_var + ln_eps)) * (0.78132253885269165) + (-0.19372616708278656);
    dt0_g0_21 = gelu_approx(dt0_n0_21);
    dt0_n0_22 = (((dt0_l0_22) - dt0_mean) / sqrt(dt0_var + ln_eps)) * (1.074562668800354) + (-0.079838313162326813);
    dt0_g0_22 = gelu_approx(dt0_n0_22);
    dt0_n0_23 = (((dt0_l0_23) - dt0_mean) / sqrt(dt0_var + ln_eps)) * (0.83421492576599121) + (-0.17514687776565552);
    dt0_g0_23 = gelu_approx(dt0_n0_23);
    dt0_n0_24 = (((dt0_l0_24) - dt0_mean) / sqrt(dt0_var + ln_eps)) * (1.1784040927886963) + (-0.0051487316377460957);
    dt0_g0_24 = gelu_approx(dt0_n0_24);
    dt0_n0_25 = (((dt0_l0_25) - dt0_mean) / sqrt(dt0_var + ln_eps)) * (0.83455449342727661) + (-0.13809368014335632);
    dt0_g0_25 = gelu_approx(dt0_n0_25);
    dt0_n0_26 = (((dt0_l0_26) - dt0_mean) / sqrt(dt0_var + ln_eps)) * (1.1395912170410156) + (-0.027733271941542625);
    dt0_g0_26 = gelu_approx(dt0_n0_26);
    dt0_n0_27 = (((dt0_l0_27) - dt0_mean) / sqrt(dt0_var + ln_eps)) * (0.98487979173660278) + (-0.08256356418132782);
    dt0_g0_27 = gelu_approx(dt0_n0_27);
    dt0_n0_28 = (((dt0_l0_28) - dt0_mean) / sqrt(dt0_var + ln_eps)) * (1.519499659538269) + (-0.030904548242688179);
    dt0_g0_28 = gelu_approx(dt0_n0_28);
    dt0_n0_29 = (((dt0_l0_29) - dt0_mean) / sqrt(dt0_var + ln_eps)) * (0.75068819522857666) + (-0.20771928131580353);
    dt0_g0_29 = gelu_approx(dt0_n0_29);
    dt0_n0_30 = (((dt0_l0_30) - dt0_mean) / sqrt(dt0_var + ln_eps)) * (0.88442128896713257) + (-0.090217843651771545);
    dt0_g0_30 = gelu_approx(dt0_n0_30);
    dt0_n0_31 = (((dt0_l0_31) - dt0_mean) / sqrt(dt0_var + ln_eps)) * (0.94935429096221924) + (-0.040492460131645203);
    dt0_g0_31 = gelu_approx(dt0_n0_31);
    dt0_l1_0 = -0.046900030225515366;
    dt0_l1_0 = dt0_l1_0 + (-0.16293072700500488)*dt0_g0_0;
    dt0_l1_0 = dt0_l1_0 + (-0.16474521160125732)*dt0_g0_1;
    dt0_l1_0 = dt0_l1_0 + (0.26976498961448669)*dt0_g0_2;
    dt0_l1_0 = dt0_l1_0 + (-0.091086529195308685)*dt0_g0_3;
    dt0_l1_0 = dt0_l1_0 + (0.039857111871242523)*dt0_g0_4;
    dt0_l1_0 = dt0_l1_0 + (-0.36768817901611328)*dt0_g0_5;
    dt0_l1_0 = dt0_l1_0 + (0.029776940122246742)*dt0_g0_6;
    dt0_l1_0 = dt0_l1_0 + (0.0019191652536392212)*dt0_g0_7;
    dt0_l1_0 = dt0_l1_0 + (0.22635605931282043)*dt0_g0_8;
    dt0_l1_0 = dt0_l1_0 + (0.0014309659600257874)*dt0_g0_9;
    dt0_l1_0 = dt0_l1_0 + (-0.18940156698226929)*dt0_g0_10;
    dt0_l1_0 = dt0_l1_0 + (0.001589158084243536)*dt0_g0_11;
    dt0_l1_0 = dt0_l1_0 + (-0.079506546258926392)*dt0_g0_12;
    dt0_l1_0 = dt0_l1_0 + (-0.1057610958814621)*dt0_g0_13;
    dt0_l1_0 = dt0_l1_0 + (0.073466688394546509)*dt0_g0_14;
    dt0_l1_0 = dt0_l1_0 + (0.071385860443115234)*dt0_g0_15;
    dt0_l1_0 = dt0_l1_0 + (-0.085049651563167572)*dt0_g0_16;
    dt0_l1_0 = dt0_l1_0 + (0.048108115792274475)*dt0_g0_17;
    dt0_l1_0 = dt0_l1_0 + (0.037839200347661972)*dt0_g0_18;
    dt0_l1_0 = dt0_l1_0 + (0.008063427172601223)*dt0_g0_19;
    dt0_l1_0 = dt0_l1_0 + (-0.035607509315013885)*dt0_g0_20;
    dt0_l1_0 = dt0_l1_0 + (-0.0510379858314991)*dt0_g0_21;
    dt0_l1_0 = dt0_l1_0 + (0.048532266169786453)*dt0_g0_22;
    dt0_l1_0 = dt0_l1_0 + (0.096789225935935974)*dt0_g0_23;
    dt0_l1_0 = dt0_l1_0 + (0.2037883996963501)*dt0_g0_24;
    dt0_l1_0 = dt0_l1_0 + (0.13214650750160217)*dt0_g0_25;
    dt0_l1_0 = dt0_l1_0 + (0.1620766818523407)*dt0_g0_26;
    dt0_l1_0 = dt0_l1_0 + (0.10560188442468643)*dt0_g0_27;
    dt0_l1_0 = dt0_l1_0 + (-0.38243672251701355)*dt0_g0_28;
    dt0_l1_0 = dt0_l1_0 + (0.036945246160030365)*dt0_g0_29;
    dt0_l1_0 = dt0_l1_0 + (0.017235111445188522)*dt0_g0_30;
    dt0_l1_0 = dt0_l1_0 + (-0.0079529397189617157)*dt0_g0_31;
    dt0_l1_1 = -0.1650557667016983;
    dt0_l1_1 = dt0_l1_1 + (-0.28834861516952515)*dt0_g0_0;
    dt0_l1_1 = dt0_l1_1 + (-0.25788521766662598)*dt0_g0_1;
    dt0_l1_1 = dt0_l1_1 + (0.15913346409797668)*dt0_g0_2;
    dt0_l1_1 = dt0_l1_1 + (0.027718981727957726)*dt0_g0_3;
    dt0_l1_1 = dt0_l1_1 + (0.10900557786226273)*dt0_g0_4;
    dt0_l1_1 = dt0_l1_1 + (0.11376988142728806)*dt0_g0_5;
    dt0_l1_1 = dt0_l1_1 + (0.19892121851444244)*dt0_g0_6;
    dt0_l1_1 = dt0_l1_1 + (0.089453563094139099)*dt0_g0_7;
    dt0_l1_1 = dt0_l1_1 + (0.14389055967330933)*dt0_g0_8;
    dt0_l1_1 = dt0_l1_1 + (-0.030847437679767609)*dt0_g0_9;
    dt0_l1_1 = dt0_l1_1 + (-0.047776956111192703)*dt0_g0_10;
    dt0_l1_1 = dt0_l1_1 + (0.040948741137981415)*dt0_g0_11;
    dt0_l1_1 = dt0_l1_1 + (0.023026715964078903)*dt0_g0_12;
    dt0_l1_1 = dt0_l1_1 + (-0.019706688821315765)*dt0_g0_13;
    dt0_l1_1 = dt0_l1_1 + (-0.096261724829673767)*dt0_g0_14;
    dt0_l1_1 = dt0_l1_1 + (-0.20225909352302551)*dt0_g0_15;
    dt0_l1_1 = dt0_l1_1 + (-0.13004162907600403)*dt0_g0_16;
    dt0_l1_1 = dt0_l1_1 + (0.066044040024280548)*dt0_g0_17;
    dt0_l1_1 = dt0_l1_1 + (0.15169130265712738)*dt0_g0_18;
    dt0_l1_1 = dt0_l1_1 + (-0.079691514372825623)*dt0_g0_19;
    dt0_l1_1 = dt0_l1_1 + (-0.15136595070362091)*dt0_g0_20;
    dt0_l1_1 = dt0_l1_1 + (-0.11996348202228546)*dt0_g0_21;
    dt0_l1_1 = dt0_l1_1 + (0.096818938851356506)*dt0_g0_22;
    dt0_l1_1 = dt0_l1_1 + (0.017230300232768059)*dt0_g0_23;
    dt0_l1_1 = dt0_l1_1 + (-0.23509146273136139)*dt0_g0_24;
    dt0_l1_1 = dt0_l1_1 + (-0.053033959120512009)*dt0_g0_25;
    dt0_l1_1 = dt0_l1_1 + (0.35057505965232849)*dt0_g0_26;
    dt0_l1_1 = dt0_l1_1 + (-0.11318153887987137)*dt0_g0_27;
    dt0_l1_1 = dt0_l1_1 + (0.25067627429962158)*dt0_g0_28;
    dt0_l1_1 = dt0_l1_1 + (0.060550738126039505)*dt0_g0_29;
    dt0_l1_1 = dt0_l1_1 + (-0.11033059656620026)*dt0_g0_30;
    dt0_l1_1 = dt0_l1_1 + (0.10683048516511917)*dt0_g0_31;
    dt0_l1_2 = 0.040588255971670151;
    dt0_l1_2 = dt0_l1_2 + (0.01313297264277935)*dt0_g0_0;
    dt0_l1_2 = dt0_l1_2 + (0.21187171339988708)*dt0_g0_1;
    dt0_l1_2 = dt0_l1_2 + (0.055051211267709732)*dt0_g0_2;
    dt0_l1_2 = dt0_l1_2 + (0.081240192055702209)*dt0_g0_3;
    dt0_l1_2 = dt0_l1_2 + (0.11177189648151398)*dt0_g0_4;
    dt0_l1_2 = dt0_l1_2 + (-0.023280186578631401)*dt0_g0_5;
    dt0_l1_2 = dt0_l1_2 + (0.10673881322145462)*dt0_g0_6;
    dt0_l1_2 = dt0_l1_2 + (0.0054689659737050533)*dt0_g0_7;
    dt0_l1_2 = dt0_l1_2 + (-0.190908282995224)*dt0_g0_8;
    dt0_l1_2 = dt0_l1_2 + (-0.13047152757644653)*dt0_g0_9;
    dt0_l1_2 = dt0_l1_2 + (0.10141438245773315)*dt0_g0_10;
    dt0_l1_2 = dt0_l1_2 + (0.12788000702857971)*dt0_g0_11;
    dt0_l1_2 = dt0_l1_2 + (-0.078461281955242157)*dt0_g0_12;
    dt0_l1_2 = dt0_l1_2 + (0.05843580886721611)*dt0_g0_13;
    dt0_l1_2 = dt0_l1_2 + (0.055245514959096909)*dt0_g0_14;
    dt0_l1_2 = dt0_l1_2 + (0.026272119954228401)*dt0_g0_15;
    dt0_l1_2 = dt0_l1_2 + (-0.31216931343078613)*dt0_g0_16;
    dt0_l1_2 = dt0_l1_2 + (0.1585162878036499)*dt0_g0_17;
    dt0_l1_2 = dt0_l1_2 + (-0.047532562166452408)*dt0_g0_18;
    dt0_l1_2 = dt0_l1_2 + (0.0034459442831575871)*dt0_g0_19;
    dt0_l1_2 = dt0_l1_2 + (-0.073009148240089417)*dt0_g0_20;
    dt0_l1_2 = dt0_l1_2 + (0.063850387930870056)*dt0_g0_21;
    dt0_l1_2 = dt0_l1_2 + (0.20695371925830841)*dt0_g0_22;
    dt0_l1_2 = dt0_l1_2 + (0.084927849471569061)*dt0_g0_23;
    dt0_l1_2 = dt0_l1_2 + (-0.17805205285549164)*dt0_g0_24;
    dt0_l1_2 = dt0_l1_2 + (0.043571438640356064)*dt0_g0_25;
    dt0_l1_2 = dt0_l1_2 + (-0.28430473804473877)*dt0_g0_26;
    dt0_l1_2 = dt0_l1_2 + (0.046519283205270767)*dt0_g0_27;
    dt0_l1_2 = dt0_l1_2 + (0.13506217300891876)*dt0_g0_28;
    dt0_l1_2 = dt0_l1_2 + (0.080001845955848694)*dt0_g0_29;
    dt0_l1_2 = dt0_l1_2 + (0.094780534505844116)*dt0_g0_30;
    dt0_l1_2 = dt0_l1_2 + (-0.14838580787181854)*dt0_g0_31;
    dt0_l1_3 = 0.03006674163043499;
    dt0_l1_3 = dt0_l1_3 + (-0.35364684462547302)*dt0_g0_0;
    dt0_l1_3 = dt0_l1_3 + (-0.17629177868366241)*dt0_g0_1;
    dt0_l1_3 = dt0_l1_3 + (0.022153474390506744)*dt0_g0_2;
    dt0_l1_3 = dt0_l1_3 + (0.18007884919643402)*dt0_g0_3;
    dt0_l1_3 = dt0_l1_3 + (0.10401297360658646)*dt0_g0_4;
    dt0_l1_3 = dt0_l1_3 + (0.051684357225894928)*dt0_g0_5;
    dt0_l1_3 = dt0_l1_3 + (-0.075068175792694092)*dt0_g0_6;
    dt0_l1_3 = dt0_l1_3 + (-0.059393569827079773)*dt0_g0_7;
    dt0_l1_3 = dt0_l1_3 + (0.15978445112705231)*dt0_g0_8;
    dt0_l1_3 = dt0_l1_3 + (-0.12649829685688019)*dt0_g0_9;
    dt0_l1_3 = dt0_l1_3 + (-0.262550950050354)*dt0_g0_10;
    dt0_l1_3 = dt0_l1_3 + (0.061393164098262787)*dt0_g0_11;
    dt0_l1_3 = dt0_l1_3 + (0.065222702920436859)*dt0_g0_12;
    dt0_l1_3 = dt0_l1_3 + (-0.062185466289520264)*dt0_g0_13;
    dt0_l1_3 = dt0_l1_3 + (-0.067431561648845673)*dt0_g0_14;
    dt0_l1_3 = dt0_l1_3 + (-0.19861984252929688)*dt0_g0_15;
    dt0_l1_3 = dt0_l1_3 + (0.64975041151046753)*dt0_g0_16;
    dt0_l1_3 = dt0_l1_3 + (-0.10373525321483612)*dt0_g0_17;
    dt0_l1_3 = dt0_l1_3 + (-0.051274355500936508)*dt0_g0_18;
    dt0_l1_3 = dt0_l1_3 + (0.1738811731338501)*dt0_g0_19;
    dt0_l1_3 = dt0_l1_3 + (-0.064860448241233826)*dt0_g0_20;
    dt0_l1_3 = dt0_l1_3 + (0.13006292283535004)*dt0_g0_21;
    dt0_l1_3 = dt0_l1_3 + (0.039197433739900589)*dt0_g0_22;
    dt0_l1_3 = dt0_l1_3 + (0.11295291036367416)*dt0_g0_23;
    dt0_l1_3 = dt0_l1_3 + (0.039528913795948029)*dt0_g0_24;
    dt0_l1_3 = dt0_l1_3 + (0.13462246954441071)*dt0_g0_25;
    dt0_l1_3 = dt0_l1_3 + (0.074103392660617828)*dt0_g0_26;
    dt0_l1_3 = dt0_l1_3 + (-0.0064598540775477886)*dt0_g0_27;
    dt0_l1_3 = dt0_l1_3 + (-0.24211853742599487)*dt0_g0_28;
    dt0_l1_3 = dt0_l1_3 + (0.093256272375583649)*dt0_g0_29;
    dt0_l1_3 = dt0_l1_3 + (-0.17873191833496094)*dt0_g0_30;
    dt0_l1_3 = dt0_l1_3 + (0.13665640354156494)*dt0_g0_31;
    dt0_l1_4 = 0.12263526022434235;
    dt0_l1_4 = dt0_l1_4 + (0.17370125651359558)*dt0_g0_0;
    dt0_l1_4 = dt0_l1_4 + (-0.083672083914279938)*dt0_g0_1;
    dt0_l1_4 = dt0_l1_4 + (-0.058013491332530975)*dt0_g0_2;
    dt0_l1_4 = dt0_l1_4 + (0.030379418283700943)*dt0_g0_3;
    dt0_l1_4 = dt0_l1_4 + (-0.03496987372636795)*dt0_g0_4;
    dt0_l1_4 = dt0_l1_4 + (-0.34480535984039307)*dt0_g0_5;
    dt0_l1_4 = dt0_l1_4 + (0.18003655970096588)*dt0_g0_6;
    dt0_l1_4 = dt0_l1_4 + (-0.012501563876867294)*dt0_g0_7;
    dt0_l1_4 = dt0_l1_4 + (0.10306855291128159)*dt0_g0_8;
    dt0_l1_4 = dt0_l1_4 + (0.0010572918690741062)*dt0_g0_9;
    dt0_l1_4 = dt0_l1_4 + (0.22152738273143768)*dt0_g0_10;
    dt0_l1_4 = dt0_l1_4 + (-0.046255137771368027)*dt0_g0_11;
    dt0_l1_4 = dt0_l1_4 + (0.078009523451328278)*dt0_g0_12;
    dt0_l1_4 = dt0_l1_4 + (0.066000305116176605)*dt0_g0_13;
    dt0_l1_4 = dt0_l1_4 + (-0.13832651078701019)*dt0_g0_14;
    dt0_l1_4 = dt0_l1_4 + (0.15796451270580292)*dt0_g0_15;
    dt0_l1_4 = dt0_l1_4 + (0.050529871135950089)*dt0_g0_16;
    dt0_l1_4 = dt0_l1_4 + (0.21294906735420227)*dt0_g0_17;
    dt0_l1_4 = dt0_l1_4 + (-0.12090930342674255)*dt0_g0_18;
    dt0_l1_4 = dt0_l1_4 + (-0.068031854927539825)*dt0_g0_19;
    dt0_l1_4 = dt0_l1_4 + (-0.10580087453126907)*dt0_g0_20;
    dt0_l1_4 = dt0_l1_4 + (-0.0046419226564466953)*dt0_g0_21;
    dt0_l1_4 = dt0_l1_4 + (-0.082880429923534393)*dt0_g0_22;
    dt0_l1_4 = dt0_l1_4 + (-0.032585814595222473)*dt0_g0_23;
    dt0_l1_4 = dt0_l1_4 + (-0.10039889067411423)*dt0_g0_24;
    dt0_l1_4 = dt0_l1_4 + (0.11109044402837753)*dt0_g0_25;
    dt0_l1_4 = dt0_l1_4 + (-0.080455757677555084)*dt0_g0_26;
    dt0_l1_4 = dt0_l1_4 + (0.0014013194013386965)*dt0_g0_27;
    dt0_l1_4 = dt0_l1_4 + (-0.15381021797657013)*dt0_g0_28;
    dt0_l1_4 = dt0_l1_4 + (0.05111057311296463)*dt0_g0_29;
    dt0_l1_4 = dt0_l1_4 + (0.076669268310070038)*dt0_g0_30;
    dt0_l1_4 = dt0_l1_4 + (-0.17469201982021332)*dt0_g0_31;
    dt0_l1_5 = -0.051718160510063171;
    dt0_l1_5 = dt0_l1_5 + (0.12622646987438202)*dt0_g0_0;
    dt0_l1_5 = dt0_l1_5 + (0.15407618880271912)*dt0_g0_1;
    dt0_l1_5 = dt0_l1_5 + (0.1102263480424881)*dt0_g0_2;
    dt0_l1_5 = dt0_l1_5 + (0.081044577062129974)*dt0_g0_3;
    dt0_l1_5 = dt0_l1_5 + (0.15326599776744843)*dt0_g0_4;
    dt0_l1_5 = dt0_l1_5 + (0.064281925559043884)*dt0_g0_5;
    dt0_l1_5 = dt0_l1_5 + (-0.21500757336616516)*dt0_g0_6;
    dt0_l1_5 = dt0_l1_5 + (0.098096363246440887)*dt0_g0_7;
    dt0_l1_5 = dt0_l1_5 + (-0.035208825021982193)*dt0_g0_8;
    dt0_l1_5 = dt0_l1_5 + (-0.029627483338117599)*dt0_g0_9;
    dt0_l1_5 = dt0_l1_5 + (0.23539173603057861)*dt0_g0_10;
    dt0_l1_5 = dt0_l1_5 + (-0.059684157371520996)*dt0_g0_11;
    dt0_l1_5 = dt0_l1_5 + (0.18764948844909668)*dt0_g0_12;
    dt0_l1_5 = dt0_l1_5 + (-0.10946971923112869)*dt0_g0_13;
    dt0_l1_5 = dt0_l1_5 + (-0.058492869138717651)*dt0_g0_14;
    dt0_l1_5 = dt0_l1_5 + (0.29810228943824768)*dt0_g0_15;
    dt0_l1_5 = dt0_l1_5 + (-0.25540083646774292)*dt0_g0_16;
    dt0_l1_5 = dt0_l1_5 + (-0.25962957739830017)*dt0_g0_17;
    dt0_l1_5 = dt0_l1_5 + (0.07244226336479187)*dt0_g0_18;
    dt0_l1_5 = dt0_l1_5 + (-0.015826232731342316)*dt0_g0_19;
    dt0_l1_5 = dt0_l1_5 + (-0.13939377665519714)*dt0_g0_20;
    dt0_l1_5 = dt0_l1_5 + (-0.034775912761688232)*dt0_g0_21;
    dt0_l1_5 = dt0_l1_5 + (-0.21197742223739624)*dt0_g0_22;
    dt0_l1_5 = dt0_l1_5 + (-0.10610435903072357)*dt0_g0_23;
    dt0_l1_5 = dt0_l1_5 + (0.053570564836263657)*dt0_g0_24;
    dt0_l1_5 = dt0_l1_5 + (0.040605675429105759)*dt0_g0_25;
    dt0_l1_5 = dt0_l1_5 + (0.023010404780507088)*dt0_g0_26;
    dt0_l1_5 = dt0_l1_5 + (0.12137638777494431)*dt0_g0_27;
    dt0_l1_5 = dt0_l1_5 + (0.23015812039375305)*dt0_g0_28;
    dt0_l1_5 = dt0_l1_5 + (0.06396755576133728)*dt0_g0_29;
    dt0_l1_5 = dt0_l1_5 + (-0.11600128561258316)*dt0_g0_30;
    dt0_l1_5 = dt0_l1_5 + (0.0018161108018830419)*dt0_g0_31;
    dt0_l1_6 = -0.14502783119678497;
    dt0_l1_6 = dt0_l1_6 + (-0.21617880463600159)*dt0_g0_0;
    dt0_l1_6 = dt0_l1_6 + (0.024907056242227554)*dt0_g0_1;
    dt0_l1_6 = dt0_l1_6 + (0.28527197241783142)*dt0_g0_2;
    dt0_l1_6 = dt0_l1_6 + (-0.10465603321790695)*dt0_g0_3;
    dt0_l1_6 = dt0_l1_6 + (0.004011248704046011)*dt0_g0_4;
    dt0_l1_6 = dt0_l1_6 + (0.11178028583526611)*dt0_g0_5;
    dt0_l1_6 = dt0_l1_6 + (0.13247388601303101)*dt0_g0_6;
    dt0_l1_6 = dt0_l1_6 + (0.17205116152763367)*dt0_g0_7;
    dt0_l1_6 = dt0_l1_6 + (0.017789272591471672)*dt0_g0_8;
    dt0_l1_6 = dt0_l1_6 + (0.0079919397830963135)*dt0_g0_9;
    dt0_l1_6 = dt0_l1_6 + (-0.17143863439559937)*dt0_g0_10;
    dt0_l1_6 = dt0_l1_6 + (-0.090974859893321991)*dt0_g0_11;
    dt0_l1_6 = dt0_l1_6 + (0.00026911767781712115)*dt0_g0_12;
    dt0_l1_6 = dt0_l1_6 + (0.12699028849601746)*dt0_g0_13;
    dt0_l1_6 = dt0_l1_6 + (0.012657118029892445)*dt0_g0_14;
    dt0_l1_6 = dt0_l1_6 + (0.014249536208808422)*dt0_g0_15;
    dt0_l1_6 = dt0_l1_6 + (0.29837688803672791)*dt0_g0_16;
    dt0_l1_6 = dt0_l1_6 + (0.10275484621524811)*dt0_g0_17;
    dt0_l1_6 = dt0_l1_6 + (-0.052840493619441986)*dt0_g0_18;
    dt0_l1_6 = dt0_l1_6 + (-0.064061515033245087)*dt0_g0_19;
    dt0_l1_6 = dt0_l1_6 + (0.084928445518016815)*dt0_g0_20;
    dt0_l1_6 = dt0_l1_6 + (-0.10871539264917374)*dt0_g0_21;
    dt0_l1_6 = dt0_l1_6 + (0.17323924601078033)*dt0_g0_22;
    dt0_l1_6 = dt0_l1_6 + (0.063852109014987946)*dt0_g0_23;
    dt0_l1_6 = dt0_l1_6 + (-0.054064754396677017)*dt0_g0_24;
    dt0_l1_6 = dt0_l1_6 + (-0.096406780183315277)*dt0_g0_25;
    dt0_l1_6 = dt0_l1_6 + (0.034694094210863113)*dt0_g0_26;
    dt0_l1_6 = dt0_l1_6 + (-0.040985178202390671)*dt0_g0_27;
    dt0_l1_6 = dt0_l1_6 + (-0.1414448469877243)*dt0_g0_28;
    dt0_l1_6 = dt0_l1_6 + (-0.18324244022369385)*dt0_g0_29;
    dt0_l1_6 = dt0_l1_6 + (-0.0061641675420105457)*dt0_g0_30;
    dt0_l1_6 = dt0_l1_6 + (0.14373365044593811)*dt0_g0_31;
    dt0_l1_7 = 0.15039798617362976;
    dt0_l1_7 = dt0_l1_7 + (0.047673169523477554)*dt0_g0_0;
    dt0_l1_7 = dt0_l1_7 + (0.072389706969261169)*dt0_g0_1;
    dt0_l1_7 = dt0_l1_7 + (-0.065495222806930542)*dt0_g0_2;
    dt0_l1_7 = dt0_l1_7 + (-0.037528026849031448)*dt0_g0_3;
    dt0_l1_7 = dt0_l1_7 + (-0.10889255255460739)*dt0_g0_4;
    dt0_l1_7 = dt0_l1_7 + (0.11605526506900787)*dt0_g0_5;
    dt0_l1_7 = dt0_l1_7 + (-0.026777036488056183)*dt0_g0_6;
    dt0_l1_7 = dt0_l1_7 + (-0.028399230912327766)*dt0_g0_7;
    dt0_l1_7 = dt0_l1_7 + (0.047372490167617798)*dt0_g0_8;
    dt0_l1_7 = dt0_l1_7 + (-0.012069370597600937)*dt0_g0_9;
    dt0_l1_7 = dt0_l1_7 + (-0.083184346556663513)*dt0_g0_10;
    dt0_l1_7 = dt0_l1_7 + (0.02154984325170517)*dt0_g0_11;
    dt0_l1_7 = dt0_l1_7 + (-0.040346946567296982)*dt0_g0_12;
    dt0_l1_7 = dt0_l1_7 + (-0.16211129724979401)*dt0_g0_13;
    dt0_l1_7 = dt0_l1_7 + (0.13870799541473389)*dt0_g0_14;
    dt0_l1_7 = dt0_l1_7 + (-0.19581884145736694)*dt0_g0_15;
    dt0_l1_7 = dt0_l1_7 + (-0.1117430180311203)*dt0_g0_16;
    dt0_l1_7 = dt0_l1_7 + (0.17394495010375977)*dt0_g0_17;
    dt0_l1_7 = dt0_l1_7 + (-0.00035679028951562941)*dt0_g0_18;
    dt0_l1_7 = dt0_l1_7 + (-0.048673704266548157)*dt0_g0_19;
    dt0_l1_7 = dt0_l1_7 + (0.15421126782894135)*dt0_g0_20;
    dt0_l1_7 = dt0_l1_7 + (0.13505768775939941)*dt0_g0_21;
    dt0_l1_7 = dt0_l1_7 + (0.036396581679582596)*dt0_g0_22;
    dt0_l1_7 = dt0_l1_7 + (0.0034029996022582054)*dt0_g0_23;
    dt0_l1_7 = dt0_l1_7 + (-0.24609997868537903)*dt0_g0_24;
    dt0_l1_7 = dt0_l1_7 + (0.15485222637653351)*dt0_g0_25;
    dt0_l1_7 = dt0_l1_7 + (-0.073318503797054291)*dt0_g0_26;
    dt0_l1_7 = dt0_l1_7 + (0.050975963473320007)*dt0_g0_27;
    dt0_l1_7 = dt0_l1_7 + (0.016177339479327202)*dt0_g0_28;
    dt0_l1_7 = dt0_l1_7 + (0.069688819348812103)*dt0_g0_29;
    dt0_l1_7 = dt0_l1_7 + (0.070944041013717651)*dt0_g0_30;
    dt0_l1_7 = dt0_l1_7 + (0.11156594753265381)*dt0_g0_31;
    dt0_l1_8 = 0.17791567742824554;
    dt0_l1_8 = dt0_l1_8 + (-0.071427121758460999)*dt0_g0_0;
    dt0_l1_8 = dt0_l1_8 + (-0.014428609050810337)*dt0_g0_1;
    dt0_l1_8 = dt0_l1_8 + (-0.1958298534154892)*dt0_g0_2;
    dt0_l1_8 = dt0_l1_8 + (-0.16039794683456421)*dt0_g0_3;
    dt0_l1_8 = dt0_l1_8 + (-0.13343974947929382)*dt0_g0_4;
    dt0_l1_8 = dt0_l1_8 + (0.26373711228370667)*dt0_g0_5;
    dt0_l1_8 = dt0_l1_8 + (0.017795341089367867)*dt0_g0_6;
    dt0_l1_8 = dt0_l1_8 + (-0.021144472062587738)*dt0_g0_7;
    dt0_l1_8 = dt0_l1_8 + (-0.23094122111797333)*dt0_g0_8;
    dt0_l1_8 = dt0_l1_8 + (0.073461614549160004)*dt0_g0_9;
    dt0_l1_8 = dt0_l1_8 + (0.11966696381568909)*dt0_g0_10;
    dt0_l1_8 = dt0_l1_8 + (0.17676906287670135)*dt0_g0_11;
    dt0_l1_8 = dt0_l1_8 + (-0.048930056393146515)*dt0_g0_12;
    dt0_l1_8 = dt0_l1_8 + (-0.14716175198554993)*dt0_g0_13;
    dt0_l1_8 = dt0_l1_8 + (0.11388258635997772)*dt0_g0_14;
    dt0_l1_8 = dt0_l1_8 + (0.082485564053058624)*dt0_g0_15;
    dt0_l1_8 = dt0_l1_8 + (0.46304497122764587)*dt0_g0_16;
    dt0_l1_8 = dt0_l1_8 + (0.00068784336326643825)*dt0_g0_17;
    dt0_l1_8 = dt0_l1_8 + (0.10457544773817062)*dt0_g0_18;
    dt0_l1_8 = dt0_l1_8 + (-0.0063994922675192356)*dt0_g0_19;
    dt0_l1_8 = dt0_l1_8 + (-0.14240989089012146)*dt0_g0_20;
    dt0_l1_8 = dt0_l1_8 + (-0.048434056341648102)*dt0_g0_21;
    dt0_l1_8 = dt0_l1_8 + (0.16329094767570496)*dt0_g0_22;
    dt0_l1_8 = dt0_l1_8 + (-0.080508217215538025)*dt0_g0_23;
    dt0_l1_8 = dt0_l1_8 + (0.18204766511917114)*dt0_g0_24;
    dt0_l1_8 = dt0_l1_8 + (-0.094055630266666412)*dt0_g0_25;
    dt0_l1_8 = dt0_l1_8 + (-0.12780973315238953)*dt0_g0_26;
    dt0_l1_8 = dt0_l1_8 + (-0.11680302768945694)*dt0_g0_27;
    dt0_l1_8 = dt0_l1_8 + (0.25664985179901123)*dt0_g0_28;
    dt0_l1_8 = dt0_l1_8 + (0.050704926252365112)*dt0_g0_29;
    dt0_l1_8 = dt0_l1_8 + (0.1178852841258049)*dt0_g0_30;
    dt0_l1_8 = dt0_l1_8 + (0.23110063374042511)*dt0_g0_31;
    dt0_l1_9 = -0.13868293166160583;
    dt0_l1_9 = dt0_l1_9 + (0.023834094405174255)*dt0_g0_0;
    dt0_l1_9 = dt0_l1_9 + (0.13403761386871338)*dt0_g0_1;
    dt0_l1_9 = dt0_l1_9 + (0.15153506398200989)*dt0_g0_2;
    dt0_l1_9 = dt0_l1_9 + (0.017937421798706055)*dt0_g0_3;
    dt0_l1_9 = dt0_l1_9 + (0.156947061419487)*dt0_g0_4;
    dt0_l1_9 = dt0_l1_9 + (-0.23003552854061127)*dt0_g0_5;
    dt0_l1_9 = dt0_l1_9 + (-0.11289767175912857)*dt0_g0_6;
    dt0_l1_9 = dt0_l1_9 + (0.049387767910957336)*dt0_g0_7;
    dt0_l1_9 = dt0_l1_9 + (0.21174226701259613)*dt0_g0_8;
    dt0_l1_9 = dt0_l1_9 + (0.18910692632198334)*dt0_g0_9;
    dt0_l1_9 = dt0_l1_9 + (0.10178250819444656)*dt0_g0_10;
    dt0_l1_9 = dt0_l1_9 + (-0.13315603137016296)*dt0_g0_11;
    dt0_l1_9 = dt0_l1_9 + (0.10240495204925537)*dt0_g0_12;
    dt0_l1_9 = dt0_l1_9 + (0.045188978314399719)*dt0_g0_13;
    dt0_l1_9 = dt0_l1_9 + (0.12674446403980255)*dt0_g0_14;
    dt0_l1_9 = dt0_l1_9 + (-0.018667533993721008)*dt0_g0_15;
    dt0_l1_9 = dt0_l1_9 + (0.054173573851585388)*dt0_g0_16;
    dt0_l1_9 = dt0_l1_9 + (-0.050129134207963943)*dt0_g0_17;
    dt0_l1_9 = dt0_l1_9 + (0.10595974326133728)*dt0_g0_18;
    dt0_l1_9 = dt0_l1_9 + (-0.029256910085678101)*dt0_g0_19;
    dt0_l1_9 = dt0_l1_9 + (-0.0041289492510259151)*dt0_g0_20;
    dt0_l1_9 = dt0_l1_9 + (0.067040741443634033)*dt0_g0_21;
    dt0_l1_9 = dt0_l1_9 + (0.28273269534111023)*dt0_g0_22;
    dt0_l1_9 = dt0_l1_9 + (-0.08960222452878952)*dt0_g0_23;
    dt0_l1_9 = dt0_l1_9 + (0.23507948219776154)*dt0_g0_24;
    dt0_l1_9 = dt0_l1_9 + (0.11662031710147858)*dt0_g0_25;
    dt0_l1_9 = dt0_l1_9 + (-0.1481965184211731)*dt0_g0_26;
    dt0_l1_9 = dt0_l1_9 + (0.068826325237751007)*dt0_g0_27;
    dt0_l1_9 = dt0_l1_9 + (-0.41048020124435425)*dt0_g0_28;
    dt0_l1_9 = dt0_l1_9 + (0.028586402535438538)*dt0_g0_29;
    dt0_l1_9 = dt0_l1_9 + (0.093711540102958679)*dt0_g0_30;
    dt0_l1_9 = dt0_l1_9 + (-0.16042201220989227)*dt0_g0_31;
    dt0_l1_10 = -0.078292421996593475;
    dt0_l1_10 = dt0_l1_10 + (0.38613796234130859)*dt0_g0_0;
    dt0_l1_10 = dt0_l1_10 + (0.16861145198345184)*dt0_g0_1;
    dt0_l1_10 = dt0_l1_10 + (-0.034250523895025253)*dt0_g0_2;
    dt0_l1_10 = dt0_l1_10 + (0.12220780551433563)*dt0_g0_3;
    dt0_l1_10 = dt0_l1_10 + (0.076330028474330902)*dt0_g0_4;
    dt0_l1_10 = dt0_l1_10 + (0.45561903715133667)*dt0_g0_5;
    dt0_l1_10 = dt0_l1_10 + (0.09523686021566391)*dt0_g0_6;
    dt0_l1_10 = dt0_l1_10 + (-0.031291704624891281)*dt0_g0_7;
    dt0_l1_10 = dt0_l1_10 + (-0.16195787489414215)*dt0_g0_8;
    dt0_l1_10 = dt0_l1_10 + (-0.12284358590841293)*dt0_g0_9;
    dt0_l1_10 = dt0_l1_10 + (0.19868870079517365)*dt0_g0_10;
    dt0_l1_10 = dt0_l1_10 + (-0.059839930385351181)*dt0_g0_11;
    dt0_l1_10 = dt0_l1_10 + (0.016507105901837349)*dt0_g0_12;
    dt0_l1_10 = dt0_l1_10 + (0.089055366814136505)*dt0_g0_13;
    dt0_l1_10 = dt0_l1_10 + (-0.073398031294345856)*dt0_g0_14;
    dt0_l1_10 = dt0_l1_10 + (0.12010634690523148)*dt0_g0_15;
    dt0_l1_10 = dt0_l1_10 + (-0.56620091199874878)*dt0_g0_16;
    dt0_l1_10 = dt0_l1_10 + (0.032096225768327713)*dt0_g0_17;
    dt0_l1_10 = dt0_l1_10 + (0.060803625732660294)*dt0_g0_18;
    dt0_l1_10 = dt0_l1_10 + (-0.1705658882856369)*dt0_g0_19;
    dt0_l1_10 = dt0_l1_10 + (-0.13755302131175995)*dt0_g0_20;
    dt0_l1_10 = dt0_l1_10 + (-0.087579868733882904)*dt0_g0_21;
    dt0_l1_10 = dt0_l1_10 + (-0.1278015673160553)*dt0_g0_22;
    dt0_l1_10 = dt0_l1_10 + (0.18843105435371399)*dt0_g0_23;
    dt0_l1_10 = dt0_l1_10 + (0.1520625501871109)*dt0_g0_24;
    dt0_l1_10 = dt0_l1_10 + (0.079296454787254333)*dt0_g0_25;
    dt0_l1_10 = dt0_l1_10 + (-0.24782979488372803)*dt0_g0_26;
    dt0_l1_10 = dt0_l1_10 + (-0.039584934711456299)*dt0_g0_27;
    dt0_l1_10 = dt0_l1_10 + (0.37787425518035889)*dt0_g0_28;
    dt0_l1_10 = dt0_l1_10 + (0.11145026236772537)*dt0_g0_29;
    dt0_l1_10 = dt0_l1_10 + (-0.16598974168300629)*dt0_g0_30;
    dt0_l1_10 = dt0_l1_10 + (0.0084111606702208519)*dt0_g0_31;
    dt0_l1_11 = -0.062137391418218613;
    dt0_l1_11 = dt0_l1_11 + (-0.17376498878002167)*dt0_g0_0;
    dt0_l1_11 = dt0_l1_11 + (0.096284717321395874)*dt0_g0_1;
    dt0_l1_11 = dt0_l1_11 + (-0.091086395084857941)*dt0_g0_2;
    dt0_l1_11 = dt0_l1_11 + (-0.098921611905097961)*dt0_g0_3;
    dt0_l1_11 = dt0_l1_11 + (-0.13950799405574799)*dt0_g0_4;
    dt0_l1_11 = dt0_l1_11 + (-0.21119497716426849)*dt0_g0_5;
    dt0_l1_11 = dt0_l1_11 + (-0.29174453020095825)*dt0_g0_6;
    dt0_l1_11 = dt0_l1_11 + (-0.041246883571147919)*dt0_g0_7;
    dt0_l1_11 = dt0_l1_11 + (-0.19079685211181641)*dt0_g0_8;
    dt0_l1_11 = dt0_l1_11 + (-0.063988305628299713)*dt0_g0_9;
    dt0_l1_11 = dt0_l1_11 + (0.19126258790493011)*dt0_g0_10;
    dt0_l1_11 = dt0_l1_11 + (-0.17825838923454285)*dt0_g0_11;
    dt0_l1_11 = dt0_l1_11 + (-0.15225179493427277)*dt0_g0_12;
    dt0_l1_11 = dt0_l1_11 + (-0.16363492608070374)*dt0_g0_13;
    dt0_l1_11 = dt0_l1_11 + (-0.10237506777048111)*dt0_g0_14;
    dt0_l1_11 = dt0_l1_11 + (0.18985816836357117)*dt0_g0_15;
    dt0_l1_11 = dt0_l1_11 + (0.11689111590385437)*dt0_g0_16;
    dt0_l1_11 = dt0_l1_11 + (-0.27802398800849915)*dt0_g0_17;
    dt0_l1_11 = dt0_l1_11 + (0.030934391543269157)*dt0_g0_18;
    dt0_l1_11 = dt0_l1_11 + (0.1008097305893898)*dt0_g0_19;
    dt0_l1_11 = dt0_l1_11 + (0.098364770412445068)*dt0_g0_20;
    dt0_l1_11 = dt0_l1_11 + (-0.010569779202342033)*dt0_g0_21;
    dt0_l1_11 = dt0_l1_11 + (0.0079128220677375793)*dt0_g0_22;
    dt0_l1_11 = dt0_l1_11 + (-0.079806827008724213)*dt0_g0_23;
    dt0_l1_11 = dt0_l1_11 + (0.27011299133300781)*dt0_g0_24;
    dt0_l1_11 = dt0_l1_11 + (0.070469021797180176)*dt0_g0_25;
    dt0_l1_11 = dt0_l1_11 + (-0.38286259770393372)*dt0_g0_26;
    dt0_l1_11 = dt0_l1_11 + (-0.14456358551979065)*dt0_g0_27;
    dt0_l1_11 = dt0_l1_11 + (-0.52179837226867676)*dt0_g0_28;
    dt0_l1_11 = dt0_l1_11 + (-0.073391132056713104)*dt0_g0_29;
    dt0_l1_11 = dt0_l1_11 + (0.10099390894174576)*dt0_g0_30;
    dt0_l1_11 = dt0_l1_11 + (-0.2381131649017334)*dt0_g0_31;
    dt0_l1_12 = -0.077903278172016144;
    dt0_l1_12 = dt0_l1_12 + (-0.024478539824485779)*dt0_g0_0;
    dt0_l1_12 = dt0_l1_12 + (0.15509465336799622)*dt0_g0_1;
    dt0_l1_12 = dt0_l1_12 + (0.021082784980535507)*dt0_g0_2;
    dt0_l1_12 = dt0_l1_12 + (-0.089185543358325958)*dt0_g0_3;
    dt0_l1_12 = dt0_l1_12 + (0.0031038988381624222)*dt0_g0_4;
    dt0_l1_12 = dt0_l1_12 + (0.10395709425210953)*dt0_g0_5;
    dt0_l1_12 = dt0_l1_12 + (-0.26505029201507568)*dt0_g0_6;
    dt0_l1_12 = dt0_l1_12 + (-0.10546328872442245)*dt0_g0_7;
    dt0_l1_12 = dt0_l1_12 + (-0.12884120643138885)*dt0_g0_8;
    dt0_l1_12 = dt0_l1_12 + (0.11630596220493317)*dt0_g0_9;
    dt0_l1_12 = dt0_l1_12 + (0.0063452315516769886)*dt0_g0_10;
    dt0_l1_12 = dt0_l1_12 + (-0.0063953367061913013)*dt0_g0_11;
    dt0_l1_12 = dt0_l1_12 + (-0.021227281540632248)*dt0_g0_12;
    dt0_l1_12 = dt0_l1_12 + (-0.10694406181573868)*dt0_g0_13;
    dt0_l1_12 = dt0_l1_12 + (-0.051671974360942841)*dt0_g0_14;
    dt0_l1_12 = dt0_l1_12 + (0.014918405562639236)*dt0_g0_15;
    dt0_l1_12 = dt0_l1_12 + (-0.33986765146255493)*dt0_g0_16;
    dt0_l1_12 = dt0_l1_12 + (0.024092648178339005)*dt0_g0_17;
    dt0_l1_12 = dt0_l1_12 + (0.090858824551105499)*dt0_g0_18;
    dt0_l1_12 = dt0_l1_12 + (0.19264908134937286)*dt0_g0_19;
    dt0_l1_12 = dt0_l1_12 + (-0.082039140164852142)*dt0_g0_20;
    dt0_l1_12 = dt0_l1_12 + (0.0058428267948329449)*dt0_g0_21;
    dt0_l1_12 = dt0_l1_12 + (0.25755473971366882)*dt0_g0_22;
    dt0_l1_12 = dt0_l1_12 + (0.048122107982635498)*dt0_g0_23;
    dt0_l1_12 = dt0_l1_12 + (-0.25055438280105591)*dt0_g0_24;
    dt0_l1_12 = dt0_l1_12 + (0.016316866502165794)*dt0_g0_25;
    dt0_l1_12 = dt0_l1_12 + (-0.081792674958705902)*dt0_g0_26;
    dt0_l1_12 = dt0_l1_12 + (-0.063519790768623352)*dt0_g0_27;
    dt0_l1_12 = dt0_l1_12 + (0.50614690780639648)*dt0_g0_28;
    dt0_l1_12 = dt0_l1_12 + (-0.066375598311424255)*dt0_g0_29;
    dt0_l1_12 = dt0_l1_12 + (0.090680874884128571)*dt0_g0_30;
    dt0_l1_12 = dt0_l1_12 + (-0.073922984302043915)*dt0_g0_31;
    dt0_l1_13 = -0.12205866724252701;
    dt0_l1_13 = dt0_l1_13 + (-0.25504162907600403)*dt0_g0_0;
    dt0_l1_13 = dt0_l1_13 + (-0.049930181354284286)*dt0_g0_1;
    dt0_l1_13 = dt0_l1_13 + (0.14232224225997925)*dt0_g0_2;
    dt0_l1_13 = dt0_l1_13 + (0.15969088673591614)*dt0_g0_3;
    dt0_l1_13 = dt0_l1_13 + (0.14399471879005432)*dt0_g0_4;
    dt0_l1_13 = dt0_l1_13 + (-0.058044787496328354)*dt0_g0_5;
    dt0_l1_13 = dt0_l1_13 + (0.11529924720525742)*dt0_g0_6;
    dt0_l1_13 = dt0_l1_13 + (0.039351854473352432)*dt0_g0_7;
    dt0_l1_13 = dt0_l1_13 + (0.12985527515411377)*dt0_g0_8;
    dt0_l1_13 = dt0_l1_13 + (-0.055830512195825577)*dt0_g0_9;
    dt0_l1_13 = dt0_l1_13 + (-0.11088638752698898)*dt0_g0_10;
    dt0_l1_13 = dt0_l1_13 + (-0.071301668882369995)*dt0_g0_11;
    dt0_l1_13 = dt0_l1_13 + (0.059834972023963928)*dt0_g0_12;
    dt0_l1_13 = dt0_l1_13 + (-0.026034511625766754)*dt0_g0_13;
    dt0_l1_13 = dt0_l1_13 + (0.18610493838787079)*dt0_g0_14;
    dt0_l1_13 = dt0_l1_13 + (-0.070099622011184692)*dt0_g0_15;
    dt0_l1_13 = dt0_l1_13 + (0.2838326096534729)*dt0_g0_16;
    dt0_l1_13 = dt0_l1_13 + (-0.037520397454500198)*dt0_g0_17;
    dt0_l1_13 = dt0_l1_13 + (0.13068065047264099)*dt0_g0_18;
    dt0_l1_13 = dt0_l1_13 + (0.066525585949420929)*dt0_g0_19;
    dt0_l1_13 = dt0_l1_13 + (-0.049645096063613892)*dt0_g0_20;
    dt0_l1_13 = dt0_l1_13 + (0.054189886897802353)*dt0_g0_21;
    dt0_l1_13 = dt0_l1_13 + (-0.17614948749542236)*dt0_g0_22;
    dt0_l1_13 = dt0_l1_13 + (0.0069473623298108578)*dt0_g0_23;
    dt0_l1_13 = dt0_l1_13 + (-0.071386918425559998)*dt0_g0_24;
    dt0_l1_13 = dt0_l1_13 + (-0.1061040461063385)*dt0_g0_25;
    dt0_l1_13 = dt0_l1_13 + (0.24330644309520721)*dt0_g0_26;
    dt0_l1_13 = dt0_l1_13 + (0.13288405537605286)*dt0_g0_27;
    dt0_l1_13 = dt0_l1_13 + (-0.095819815993309021)*dt0_g0_28;
    dt0_l1_13 = dt0_l1_13 + (0.1976703405380249)*dt0_g0_29;
    dt0_l1_13 = dt0_l1_13 + (-0.10413108766078949)*dt0_g0_30;
    dt0_l1_13 = dt0_l1_13 + (-0.066180601716041565)*dt0_g0_31;
    dt0_l1_14 = 0.10435187816619873;
    dt0_l1_14 = dt0_l1_14 + (0.066092170774936676)*dt0_g0_0;
    dt0_l1_14 = dt0_l1_14 + (-0.14066116511821747)*dt0_g0_1;
    dt0_l1_14 = dt0_l1_14 + (0.0070511805824935436)*dt0_g0_2;
    dt0_l1_14 = dt0_l1_14 + (0.016216622665524483)*dt0_g0_3;
    dt0_l1_14 = dt0_l1_14 + (-0.077155455946922302)*dt0_g0_4;
    dt0_l1_14 = dt0_l1_14 + (-0.0035024809185415506)*dt0_g0_5;
    dt0_l1_14 = dt0_l1_14 + (0.16614776849746704)*dt0_g0_6;
    dt0_l1_14 = dt0_l1_14 + (-0.097305327653884888)*dt0_g0_7;
    dt0_l1_14 = dt0_l1_14 + (0.049758661538362503)*dt0_g0_8;
    dt0_l1_14 = dt0_l1_14 + (-0.10961616039276123)*dt0_g0_9;
    dt0_l1_14 = dt0_l1_14 + (0.082717306911945343)*dt0_g0_10;
    dt0_l1_14 = dt0_l1_14 + (0.080690205097198486)*dt0_g0_11;
    dt0_l1_14 = dt0_l1_14 + (-0.019630759954452515)*dt0_g0_12;
    dt0_l1_14 = dt0_l1_14 + (-0.14077238738536835)*dt0_g0_13;
    dt0_l1_14 = dt0_l1_14 + (-0.14777269959449768)*dt0_g0_14;
    dt0_l1_14 = dt0_l1_14 + (0.1627192497253418)*dt0_g0_15;
    dt0_l1_14 = dt0_l1_14 + (-0.27055931091308594)*dt0_g0_16;
    dt0_l1_14 = dt0_l1_14 + (0.24675653874874115)*dt0_g0_17;
    dt0_l1_14 = dt0_l1_14 + (-0.13080167770385742)*dt0_g0_18;
    dt0_l1_14 = dt0_l1_14 + (-0.12526585161685944)*dt0_g0_19;
    dt0_l1_14 = dt0_l1_14 + (0.026029074564576149)*dt0_g0_20;
    dt0_l1_14 = dt0_l1_14 + (0.00069717544829472899)*dt0_g0_21;
    dt0_l1_14 = dt0_l1_14 + (-0.24566978216171265)*dt0_g0_22;
    dt0_l1_14 = dt0_l1_14 + (-0.03789505735039711)*dt0_g0_23;
    dt0_l1_14 = dt0_l1_14 + (0.031554587185382843)*dt0_g0_24;
    dt0_l1_14 = dt0_l1_14 + (-0.16307400166988373)*dt0_g0_25;
    dt0_l1_14 = dt0_l1_14 + (0.18186207115650177)*dt0_g0_26;
    dt0_l1_14 = dt0_l1_14 + (0.10117419809103012)*dt0_g0_27;
    dt0_l1_14 = dt0_l1_14 + (0.71069341897964478)*dt0_g0_28;
    dt0_l1_14 = dt0_l1_14 + (-0.094877868890762329)*dt0_g0_29;
    dt0_l1_14 = dt0_l1_14 + (-0.10863464325666428)*dt0_g0_30;
    dt0_l1_14 = dt0_l1_14 + (0.044603679329156876)*dt0_g0_31;
    dt0_l1_15 = 0.054931297898292542;
    dt0_l1_15 = dt0_l1_15 + (-0.12308650463819504)*dt0_g0_0;
    dt0_l1_15 = dt0_l1_15 + (0.10122453421354294)*dt0_g0_1;
    dt0_l1_15 = dt0_l1_15 + (-0.036758832633495331)*dt0_g0_2;
    dt0_l1_15 = dt0_l1_15 + (-0.055523984134197235)*dt0_g0_3;
    dt0_l1_15 = dt0_l1_15 + (0.024221815168857574)*dt0_g0_4;
    dt0_l1_15 = dt0_l1_15 + (0.36427092552185059)*dt0_g0_5;
    dt0_l1_15 = dt0_l1_15 + (0.013182561844587326)*dt0_g0_6;
    dt0_l1_15 = dt0_l1_15 + (-0.084676198661327362)*dt0_g0_7;
    dt0_l1_15 = dt0_l1_15 + (0.094983756542205811)*dt0_g0_8;
    dt0_l1_15 = dt0_l1_15 + (-0.044733546674251556)*dt0_g0_9;
    dt0_l1_15 = dt0_l1_15 + (-0.068374097347259521)*dt0_g0_10;
    dt0_l1_15 = dt0_l1_15 + (0.073864951729774475)*dt0_g0_11;
    dt0_l1_15 = dt0_l1_15 + (0.040122237056493759)*dt0_g0_12;
    dt0_l1_15 = dt0_l1_15 + (-0.11484098434448242)*dt0_g0_13;
    dt0_l1_15 = dt0_l1_15 + (0.029558604583144188)*dt0_g0_14;
    dt0_l1_15 = dt0_l1_15 + (-0.12961806356906891)*dt0_g0_15;
    dt0_l1_15 = dt0_l1_15 + (-0.68139654397964478)*dt0_g0_16;
    dt0_l1_15 = dt0_l1_15 + (-0.090533196926116943)*dt0_g0_17;
    dt0_l1_15 = dt0_l1_15 + (-0.055364329367876053)*dt0_g0_18;
    dt0_l1_15 = dt0_l1_15 + (-0.037381157279014587)*dt0_g0_19;
    dt0_l1_15 = dt0_l1_15 + (-0.013406396843492985)*dt0_g0_20;
    dt0_l1_15 = dt0_l1_15 + (0.067575834691524506)*dt0_g0_21;
    dt0_l1_15 = dt0_l1_15 + (-0.080908246338367462)*dt0_g0_22;
    dt0_l1_15 = dt0_l1_15 + (0.05767367035150528)*dt0_g0_23;
    dt0_l1_15 = dt0_l1_15 + (0.042280886322259903)*dt0_g0_24;
    dt0_l1_15 = dt0_l1_15 + (-0.18634659051895142)*dt0_g0_25;
    dt0_l1_15 = dt0_l1_15 + (0.31346985697746277)*dt0_g0_26;
    dt0_l1_15 = dt0_l1_15 + (0.038848195225000381)*dt0_g0_27;
    dt0_l1_15 = dt0_l1_15 + (0.23577156662940979)*dt0_g0_28;
    dt0_l1_15 = dt0_l1_15 + (-0.014047614298760891)*dt0_g0_29;
    dt0_l1_15 = dt0_l1_15 + (0.096515163779258728)*dt0_g0_30;
    dt0_l1_15 = dt0_l1_15 + (-0.062498938292264938)*dt0_g0_31;
    // Device tower token 1
    dt1_l0_0 = (0.74648329536510838) + (0.34432113170623779)*lg_scaled;
    dt1_l0_1 = (0.86522502100038312) + (0.47822898626327515)*lg_scaled;
    dt1_l0_2 = (0.34024394290791882) + (0.24066966772079468)*lg_scaled;
    dt1_l0_3 = (0.21239363130860034) + (0.048484642058610916)*lg_scaled;
    dt1_l0_4 = (0.27121257124042597) + (0.13176910579204559)*lg_scaled;
    dt1_l0_5 = (-0.26754089539560988) + (-0.30407708883285522)*lg_scaled;
    dt1_l0_6 = (-0.02716541046496268) + (-0.11684082448482513)*lg_scaled;
    dt1_l0_7 = (0.20110583108130733) + (0.040982868522405624)*lg_scaled;
    dt1_l0_8 = (0.62276338735337622) + (0.61334097385406494)*lg_scaled;
    dt1_l0_9 = (0.32035153532932004) + (0.14561383426189423)*lg_scaled;
    dt1_l0_10 = (0.8696053935974617) + (0.45312285423278809)*lg_scaled;
    dt1_l0_11 = (0.086758889698423935) + (-0.057421129196882248)*lg_scaled;
    dt1_l0_12 = (0.23466408111881898) + (0.076745271682739258)*lg_scaled;
    dt1_l0_13 = (0.3042857247094658) + (0.11903565376996994)*lg_scaled;
    dt1_l0_14 = (0.19599106919883158) + (0.049182634800672531)*lg_scaled;
    dt1_l0_15 = (0.79957951572019303) + (0.39639326930046082)*lg_scaled;
    dt1_l0_16 = (-0.1640822288435016) + (-0.5463671088218689)*lg_scaled;
    dt1_l0_17 = (-0.2906479940259058) + (-0.34476840496063232)*lg_scaled;
    dt1_l0_18 = (0.21258979650391313) + (0.042969517409801483)*lg_scaled;
    dt1_l0_19 = (0.26606089013976342) + (-0.30303272604942322)*lg_scaled;
    dt1_l0_20 = (0.23688608986244919) + (0.073118828237056732)*lg_scaled;
    dt1_l0_21 = (0.20746633360228262) + (0.060475107282400131)*lg_scaled;
    dt1_l0_22 = (0.27533296009596364) + (0.23183275759220123)*lg_scaled;
    dt1_l0_23 = (0.15855005091785579) + (0.0091169727966189384)*lg_scaled;
    dt1_l0_24 = (1.3295932891711273) + (-0.022656848654150963)*lg_scaled;
    dt1_l0_25 = (0.29303682500927675) + (0.13182426989078522)*lg_scaled;
    dt1_l0_26 = (-0.035620109126951072) + (-0.41274189949035645)*lg_scaled;
    dt1_l0_27 = (0.301722881888558) + (0.14568156003952026)*lg_scaled;
    dt1_l0_28 = (-0.64959430851191846) + (-0.67684346437454224)*lg_scaled;
    dt1_l0_29 = (0.17135839050627288) + (0.01818244531750679)*lg_scaled;
    dt1_l0_30 = (0.45790348458186902) + (0.22900021076202393)*lg_scaled;
    dt1_l0_31 = (-0.055307399680598834) + (-0.24716407060623169)*lg_scaled;
    dt1_mean = (dt1_l0_0 + dt1_l0_1 + dt1_l0_2 + dt1_l0_3 + dt1_l0_4 + dt1_l0_5 + dt1_l0_6 + dt1_l0_7 + dt1_l0_8 + dt1_l0_9 + dt1_l0_10 + dt1_l0_11 + dt1_l0_12 + dt1_l0_13 + dt1_l0_14 + dt1_l0_15 + dt1_l0_16 + dt1_l0_17 + dt1_l0_18 + dt1_l0_19 + dt1_l0_20 + dt1_l0_21 + dt1_l0_22 + dt1_l0_23 + dt1_l0_24 + dt1_l0_25 + dt1_l0_26 + dt1_l0_27 + dt1_l0_28 + dt1_l0_29 + dt1_l0_30 + dt1_l0_31) / 32;
    dt1_var = (((dt1_l0_0) - dt1_mean)*((dt1_l0_0) - dt1_mean) + ((dt1_l0_1) - dt1_mean)*((dt1_l0_1) - dt1_mean) + ((dt1_l0_2) - dt1_mean)*((dt1_l0_2) - dt1_mean) + ((dt1_l0_3) - dt1_mean)*((dt1_l0_3) - dt1_mean) + ((dt1_l0_4) - dt1_mean)*((dt1_l0_4) - dt1_mean) + ((dt1_l0_5) - dt1_mean)*((dt1_l0_5) - dt1_mean) + ((dt1_l0_6) - dt1_mean)*((dt1_l0_6) - dt1_mean) + ((dt1_l0_7) - dt1_mean)*((dt1_l0_7) - dt1_mean) + ((dt1_l0_8) - dt1_mean)*((dt1_l0_8) - dt1_mean) + ((dt1_l0_9) - dt1_mean)*((dt1_l0_9) - dt1_mean) + ((dt1_l0_10) - dt1_mean)*((dt1_l0_10) - dt1_mean) + ((dt1_l0_11) - dt1_mean)*((dt1_l0_11) - dt1_mean) + ((dt1_l0_12) - dt1_mean)*((dt1_l0_12) - dt1_mean) + ((dt1_l0_13) - dt1_mean)*((dt1_l0_13) - dt1_mean) + ((dt1_l0_14) - dt1_mean)*((dt1_l0_14) - dt1_mean) + ((dt1_l0_15) - dt1_mean)*((dt1_l0_15) - dt1_mean) + ((dt1_l0_16) - dt1_mean)*((dt1_l0_16) - dt1_mean) + ((dt1_l0_17) - dt1_mean)*((dt1_l0_17) - dt1_mean) + ((dt1_l0_18) - dt1_mean)*((dt1_l0_18) - dt1_mean) + ((dt1_l0_19) - dt1_mean)*((dt1_l0_19) - dt1_mean) + ((dt1_l0_20) - dt1_mean)*((dt1_l0_20) - dt1_mean) + ((dt1_l0_21) - dt1_mean)*((dt1_l0_21) - dt1_mean) + ((dt1_l0_22) - dt1_mean)*((dt1_l0_22) - dt1_mean) + ((dt1_l0_23) - dt1_mean)*((dt1_l0_23) - dt1_mean) + ((dt1_l0_24) - dt1_mean)*((dt1_l0_24) - dt1_mean) + ((dt1_l0_25) - dt1_mean)*((dt1_l0_25) - dt1_mean) + ((dt1_l0_26) - dt1_mean)*((dt1_l0_26) - dt1_mean) + ((dt1_l0_27) - dt1_mean)*((dt1_l0_27) - dt1_mean) + ((dt1_l0_28) - dt1_mean)*((dt1_l0_28) - dt1_mean) + ((dt1_l0_29) - dt1_mean)*((dt1_l0_29) - dt1_mean) + ((dt1_l0_30) - dt1_mean)*((dt1_l0_30) - dt1_mean) + ((dt1_l0_31) - dt1_mean)*((dt1_l0_31) - dt1_mean)) / 32;
    dt1_n0_0 = (((dt1_l0_0) - dt1_mean) / sqrt(dt1_var + ln_eps)) * (1.1696591377258301) + (-0.11109431833028793);
    dt1_g0_0 = gelu_approx(dt1_n0_0);
    dt1_n0_1 = (((dt1_l0_1) - dt1_mean) / sqrt(dt1_var + ln_eps)) * (1.1050513982772827) + (-0.035068709403276443);
    dt1_g0_1 = gelu_approx(dt1_n0_1);
    dt1_n0_2 = (((dt1_l0_2) - dt1_mean) / sqrt(dt1_var + ln_eps)) * (1.04068922996521) + (-0.089032895863056183);
    dt1_g0_2 = gelu_approx(dt1_n0_2);
    dt1_n0_3 = (((dt1_l0_3) - dt1_mean) / sqrt(dt1_var + ln_eps)) * (0.67314571142196655) + (-0.25178694725036621);
    dt1_g0_3 = gelu_approx(dt1_n0_3);
    dt1_n0_4 = (((dt1_l0_4) - dt1_mean) / sqrt(dt1_var + ln_eps)) * (0.85388195514678955) + (-0.12780840694904327);
    dt1_g0_4 = gelu_approx(dt1_n0_4);
    dt1_n0_5 = (((dt1_l0_5) - dt1_mean) / sqrt(dt1_var + ln_eps)) * (1.2238403558731079) + (-0.017596408724784851);
    dt1_g0_5 = gelu_approx(dt1_n0_5);
    dt1_n0_6 = (((dt1_l0_6) - dt1_mean) / sqrt(dt1_var + ln_eps)) * (0.98674929141998291) + (-0.047802694141864777);
    dt1_g0_6 = gelu_approx(dt1_n0_6);
    dt1_n0_7 = (((dt1_l0_7) - dt1_mean) / sqrt(dt1_var + ln_eps)) * (0.73881924152374268) + (-0.26099607348442078);
    dt1_g0_7 = gelu_approx(dt1_n0_7);
    dt1_n0_8 = (((dt1_l0_8) - dt1_mean) / sqrt(dt1_var + ln_eps)) * (1.0608246326446533) + (-0.078888535499572754);
    dt1_g0_8 = gelu_approx(dt1_n0_8);
    dt1_n0_9 = (((dt1_l0_9) - dt1_mean) / sqrt(dt1_var + ln_eps)) * (0.785602867603302) + (-0.15794672071933746);
    dt1_g0_9 = gelu_approx(dt1_n0_9);
    dt1_n0_10 = (((dt1_l0_10) - dt1_mean) / sqrt(dt1_var + ln_eps)) * (1.020018458366394) + (-0.036895915865898132);
    dt1_g0_10 = gelu_approx(dt1_n0_10);
    dt1_n0_11 = (((dt1_l0_11) - dt1_mean) / sqrt(dt1_var + ln_eps)) * (0.85727518796920776) + (-0.12107124924659729);
    dt1_g0_11 = gelu_approx(dt1_n0_11);
    dt1_n0_12 = (((dt1_l0_12) - dt1_mean) / sqrt(dt1_var + ln_eps)) * (0.72308427095413208) + (-0.25479298830032349);
    dt1_g0_12 = gelu_approx(dt1_n0_12);
    dt1_n0_13 = (((dt1_l0_13) - dt1_mean) / sqrt(dt1_var + ln_eps)) * (0.86266148090362549) + (-0.14110274612903595);
    dt1_g0_13 = gelu_approx(dt1_n0_13);
    dt1_n0_14 = (((dt1_l0_14) - dt1_mean) / sqrt(dt1_var + ln_eps)) * (0.74258971214294434) + (-0.25694161653518677);
    dt1_g0_14 = gelu_approx(dt1_n0_14);
    dt1_n0_15 = (((dt1_l0_15) - dt1_mean) / sqrt(dt1_var + ln_eps)) * (1.0297513008117676) + (-0.048506777733564377);
    dt1_g0_15 = gelu_approx(dt1_n0_15);
    dt1_n0_16 = (((dt1_l0_16) - dt1_mean) / sqrt(dt1_var + ln_eps)) * (1.6998714208602905) + (0.031608574092388153);
    dt1_g0_16 = gelu_approx(dt1_n0_16);
    dt1_n0_17 = (((dt1_l0_17) - dt1_mean) / sqrt(dt1_var + ln_eps)) * (1.0622228384017944) + (-0.10873574018478394);
    dt1_g0_17 = gelu_approx(dt1_n0_17);
    dt1_n0_18 = (((dt1_l0_18) - dt1_mean) / sqrt(dt1_var + ln_eps)) * (0.84898489713668823) + (-0.16742095351219177);
    dt1_g0_18 = gelu_approx(dt1_n0_18);
    dt1_n0_19 = (((dt1_l0_19) - dt1_mean) / sqrt(dt1_var + ln_eps)) * (1.0004963874816895) + (-0.040494922548532486);
    dt1_g0_19 = gelu_approx(dt1_n0_19);
    dt1_n0_20 = (((dt1_l0_20) - dt1_mean) / sqrt(dt1_var + ln_eps)) * (0.81684249639511108) + (-0.19029967486858368);
    dt1_g0_20 = gelu_approx(dt1_n0_20);
    dt1_n0_21 = (((dt1_l0_21) - dt1_mean) / sqrt(dt1_var + ln_eps)) * (0.78132253885269165) + (-0.19372616708278656);
    dt1_g0_21 = gelu_approx(dt1_n0_21);
    dt1_n0_22 = (((dt1_l0_22) - dt1_mean) / sqrt(dt1_var + ln_eps)) * (1.074562668800354) + (-0.079838313162326813);
    dt1_g0_22 = gelu_approx(dt1_n0_22);
    dt1_n0_23 = (((dt1_l0_23) - dt1_mean) / sqrt(dt1_var + ln_eps)) * (0.83421492576599121) + (-0.17514687776565552);
    dt1_g0_23 = gelu_approx(dt1_n0_23);
    dt1_n0_24 = (((dt1_l0_24) - dt1_mean) / sqrt(dt1_var + ln_eps)) * (1.1784040927886963) + (-0.0051487316377460957);
    dt1_g0_24 = gelu_approx(dt1_n0_24);
    dt1_n0_25 = (((dt1_l0_25) - dt1_mean) / sqrt(dt1_var + ln_eps)) * (0.83455449342727661) + (-0.13809368014335632);
    dt1_g0_25 = gelu_approx(dt1_n0_25);
    dt1_n0_26 = (((dt1_l0_26) - dt1_mean) / sqrt(dt1_var + ln_eps)) * (1.1395912170410156) + (-0.027733271941542625);
    dt1_g0_26 = gelu_approx(dt1_n0_26);
    dt1_n0_27 = (((dt1_l0_27) - dt1_mean) / sqrt(dt1_var + ln_eps)) * (0.98487979173660278) + (-0.08256356418132782);
    dt1_g0_27 = gelu_approx(dt1_n0_27);
    dt1_n0_28 = (((dt1_l0_28) - dt1_mean) / sqrt(dt1_var + ln_eps)) * (1.519499659538269) + (-0.030904548242688179);
    dt1_g0_28 = gelu_approx(dt1_n0_28);
    dt1_n0_29 = (((dt1_l0_29) - dt1_mean) / sqrt(dt1_var + ln_eps)) * (0.75068819522857666) + (-0.20771928131580353);
    dt1_g0_29 = gelu_approx(dt1_n0_29);
    dt1_n0_30 = (((dt1_l0_30) - dt1_mean) / sqrt(dt1_var + ln_eps)) * (0.88442128896713257) + (-0.090217843651771545);
    dt1_g0_30 = gelu_approx(dt1_n0_30);
    dt1_n0_31 = (((dt1_l0_31) - dt1_mean) / sqrt(dt1_var + ln_eps)) * (0.94935429096221924) + (-0.040492460131645203);
    dt1_g0_31 = gelu_approx(dt1_n0_31);
    dt1_l1_0 = -0.046900030225515366;
    dt1_l1_0 = dt1_l1_0 + (-0.16293072700500488)*dt1_g0_0;
    dt1_l1_0 = dt1_l1_0 + (-0.16474521160125732)*dt1_g0_1;
    dt1_l1_0 = dt1_l1_0 + (0.26976498961448669)*dt1_g0_2;
    dt1_l1_0 = dt1_l1_0 + (-0.091086529195308685)*dt1_g0_3;
    dt1_l1_0 = dt1_l1_0 + (0.039857111871242523)*dt1_g0_4;
    dt1_l1_0 = dt1_l1_0 + (-0.36768817901611328)*dt1_g0_5;
    dt1_l1_0 = dt1_l1_0 + (0.029776940122246742)*dt1_g0_6;
    dt1_l1_0 = dt1_l1_0 + (0.0019191652536392212)*dt1_g0_7;
    dt1_l1_0 = dt1_l1_0 + (0.22635605931282043)*dt1_g0_8;
    dt1_l1_0 = dt1_l1_0 + (0.0014309659600257874)*dt1_g0_9;
    dt1_l1_0 = dt1_l1_0 + (-0.18940156698226929)*dt1_g0_10;
    dt1_l1_0 = dt1_l1_0 + (0.001589158084243536)*dt1_g0_11;
    dt1_l1_0 = dt1_l1_0 + (-0.079506546258926392)*dt1_g0_12;
    dt1_l1_0 = dt1_l1_0 + (-0.1057610958814621)*dt1_g0_13;
    dt1_l1_0 = dt1_l1_0 + (0.073466688394546509)*dt1_g0_14;
    dt1_l1_0 = dt1_l1_0 + (0.071385860443115234)*dt1_g0_15;
    dt1_l1_0 = dt1_l1_0 + (-0.085049651563167572)*dt1_g0_16;
    dt1_l1_0 = dt1_l1_0 + (0.048108115792274475)*dt1_g0_17;
    dt1_l1_0 = dt1_l1_0 + (0.037839200347661972)*dt1_g0_18;
    dt1_l1_0 = dt1_l1_0 + (0.008063427172601223)*dt1_g0_19;
    dt1_l1_0 = dt1_l1_0 + (-0.035607509315013885)*dt1_g0_20;
    dt1_l1_0 = dt1_l1_0 + (-0.0510379858314991)*dt1_g0_21;
    dt1_l1_0 = dt1_l1_0 + (0.048532266169786453)*dt1_g0_22;
    dt1_l1_0 = dt1_l1_0 + (0.096789225935935974)*dt1_g0_23;
    dt1_l1_0 = dt1_l1_0 + (0.2037883996963501)*dt1_g0_24;
    dt1_l1_0 = dt1_l1_0 + (0.13214650750160217)*dt1_g0_25;
    dt1_l1_0 = dt1_l1_0 + (0.1620766818523407)*dt1_g0_26;
    dt1_l1_0 = dt1_l1_0 + (0.10560188442468643)*dt1_g0_27;
    dt1_l1_0 = dt1_l1_0 + (-0.38243672251701355)*dt1_g0_28;
    dt1_l1_0 = dt1_l1_0 + (0.036945246160030365)*dt1_g0_29;
    dt1_l1_0 = dt1_l1_0 + (0.017235111445188522)*dt1_g0_30;
    dt1_l1_0 = dt1_l1_0 + (-0.0079529397189617157)*dt1_g0_31;
    dt1_l1_1 = -0.1650557667016983;
    dt1_l1_1 = dt1_l1_1 + (-0.28834861516952515)*dt1_g0_0;
    dt1_l1_1 = dt1_l1_1 + (-0.25788521766662598)*dt1_g0_1;
    dt1_l1_1 = dt1_l1_1 + (0.15913346409797668)*dt1_g0_2;
    dt1_l1_1 = dt1_l1_1 + (0.027718981727957726)*dt1_g0_3;
    dt1_l1_1 = dt1_l1_1 + (0.10900557786226273)*dt1_g0_4;
    dt1_l1_1 = dt1_l1_1 + (0.11376988142728806)*dt1_g0_5;
    dt1_l1_1 = dt1_l1_1 + (0.19892121851444244)*dt1_g0_6;
    dt1_l1_1 = dt1_l1_1 + (0.089453563094139099)*dt1_g0_7;
    dt1_l1_1 = dt1_l1_1 + (0.14389055967330933)*dt1_g0_8;
    dt1_l1_1 = dt1_l1_1 + (-0.030847437679767609)*dt1_g0_9;
    dt1_l1_1 = dt1_l1_1 + (-0.047776956111192703)*dt1_g0_10;
    dt1_l1_1 = dt1_l1_1 + (0.040948741137981415)*dt1_g0_11;
    dt1_l1_1 = dt1_l1_1 + (0.023026715964078903)*dt1_g0_12;
    dt1_l1_1 = dt1_l1_1 + (-0.019706688821315765)*dt1_g0_13;
    dt1_l1_1 = dt1_l1_1 + (-0.096261724829673767)*dt1_g0_14;
    dt1_l1_1 = dt1_l1_1 + (-0.20225909352302551)*dt1_g0_15;
    dt1_l1_1 = dt1_l1_1 + (-0.13004162907600403)*dt1_g0_16;
    dt1_l1_1 = dt1_l1_1 + (0.066044040024280548)*dt1_g0_17;
    dt1_l1_1 = dt1_l1_1 + (0.15169130265712738)*dt1_g0_18;
    dt1_l1_1 = dt1_l1_1 + (-0.079691514372825623)*dt1_g0_19;
    dt1_l1_1 = dt1_l1_1 + (-0.15136595070362091)*dt1_g0_20;
    dt1_l1_1 = dt1_l1_1 + (-0.11996348202228546)*dt1_g0_21;
    dt1_l1_1 = dt1_l1_1 + (0.096818938851356506)*dt1_g0_22;
    dt1_l1_1 = dt1_l1_1 + (0.017230300232768059)*dt1_g0_23;
    dt1_l1_1 = dt1_l1_1 + (-0.23509146273136139)*dt1_g0_24;
    dt1_l1_1 = dt1_l1_1 + (-0.053033959120512009)*dt1_g0_25;
    dt1_l1_1 = dt1_l1_1 + (0.35057505965232849)*dt1_g0_26;
    dt1_l1_1 = dt1_l1_1 + (-0.11318153887987137)*dt1_g0_27;
    dt1_l1_1 = dt1_l1_1 + (0.25067627429962158)*dt1_g0_28;
    dt1_l1_1 = dt1_l1_1 + (0.060550738126039505)*dt1_g0_29;
    dt1_l1_1 = dt1_l1_1 + (-0.11033059656620026)*dt1_g0_30;
    dt1_l1_1 = dt1_l1_1 + (0.10683048516511917)*dt1_g0_31;
    dt1_l1_2 = 0.040588255971670151;
    dt1_l1_2 = dt1_l1_2 + (0.01313297264277935)*dt1_g0_0;
    dt1_l1_2 = dt1_l1_2 + (0.21187171339988708)*dt1_g0_1;
    dt1_l1_2 = dt1_l1_2 + (0.055051211267709732)*dt1_g0_2;
    dt1_l1_2 = dt1_l1_2 + (0.081240192055702209)*dt1_g0_3;
    dt1_l1_2 = dt1_l1_2 + (0.11177189648151398)*dt1_g0_4;
    dt1_l1_2 = dt1_l1_2 + (-0.023280186578631401)*dt1_g0_5;
    dt1_l1_2 = dt1_l1_2 + (0.10673881322145462)*dt1_g0_6;
    dt1_l1_2 = dt1_l1_2 + (0.0054689659737050533)*dt1_g0_7;
    dt1_l1_2 = dt1_l1_2 + (-0.190908282995224)*dt1_g0_8;
    dt1_l1_2 = dt1_l1_2 + (-0.13047152757644653)*dt1_g0_9;
    dt1_l1_2 = dt1_l1_2 + (0.10141438245773315)*dt1_g0_10;
    dt1_l1_2 = dt1_l1_2 + (0.12788000702857971)*dt1_g0_11;
    dt1_l1_2 = dt1_l1_2 + (-0.078461281955242157)*dt1_g0_12;
    dt1_l1_2 = dt1_l1_2 + (0.05843580886721611)*dt1_g0_13;
    dt1_l1_2 = dt1_l1_2 + (0.055245514959096909)*dt1_g0_14;
    dt1_l1_2 = dt1_l1_2 + (0.026272119954228401)*dt1_g0_15;
    dt1_l1_2 = dt1_l1_2 + (-0.31216931343078613)*dt1_g0_16;
    dt1_l1_2 = dt1_l1_2 + (0.1585162878036499)*dt1_g0_17;
    dt1_l1_2 = dt1_l1_2 + (-0.047532562166452408)*dt1_g0_18;
    dt1_l1_2 = dt1_l1_2 + (0.0034459442831575871)*dt1_g0_19;
    dt1_l1_2 = dt1_l1_2 + (-0.073009148240089417)*dt1_g0_20;
    dt1_l1_2 = dt1_l1_2 + (0.063850387930870056)*dt1_g0_21;
    dt1_l1_2 = dt1_l1_2 + (0.20695371925830841)*dt1_g0_22;
    dt1_l1_2 = dt1_l1_2 + (0.084927849471569061)*dt1_g0_23;
    dt1_l1_2 = dt1_l1_2 + (-0.17805205285549164)*dt1_g0_24;
    dt1_l1_2 = dt1_l1_2 + (0.043571438640356064)*dt1_g0_25;
    dt1_l1_2 = dt1_l1_2 + (-0.28430473804473877)*dt1_g0_26;
    dt1_l1_2 = dt1_l1_2 + (0.046519283205270767)*dt1_g0_27;
    dt1_l1_2 = dt1_l1_2 + (0.13506217300891876)*dt1_g0_28;
    dt1_l1_2 = dt1_l1_2 + (0.080001845955848694)*dt1_g0_29;
    dt1_l1_2 = dt1_l1_2 + (0.094780534505844116)*dt1_g0_30;
    dt1_l1_2 = dt1_l1_2 + (-0.14838580787181854)*dt1_g0_31;
    dt1_l1_3 = 0.03006674163043499;
    dt1_l1_3 = dt1_l1_3 + (-0.35364684462547302)*dt1_g0_0;
    dt1_l1_3 = dt1_l1_3 + (-0.17629177868366241)*dt1_g0_1;
    dt1_l1_3 = dt1_l1_3 + (0.022153474390506744)*dt1_g0_2;
    dt1_l1_3 = dt1_l1_3 + (0.18007884919643402)*dt1_g0_3;
    dt1_l1_3 = dt1_l1_3 + (0.10401297360658646)*dt1_g0_4;
    dt1_l1_3 = dt1_l1_3 + (0.051684357225894928)*dt1_g0_5;
    dt1_l1_3 = dt1_l1_3 + (-0.075068175792694092)*dt1_g0_6;
    dt1_l1_3 = dt1_l1_3 + (-0.059393569827079773)*dt1_g0_7;
    dt1_l1_3 = dt1_l1_3 + (0.15978445112705231)*dt1_g0_8;
    dt1_l1_3 = dt1_l1_3 + (-0.12649829685688019)*dt1_g0_9;
    dt1_l1_3 = dt1_l1_3 + (-0.262550950050354)*dt1_g0_10;
    dt1_l1_3 = dt1_l1_3 + (0.061393164098262787)*dt1_g0_11;
    dt1_l1_3 = dt1_l1_3 + (0.065222702920436859)*dt1_g0_12;
    dt1_l1_3 = dt1_l1_3 + (-0.062185466289520264)*dt1_g0_13;
    dt1_l1_3 = dt1_l1_3 + (-0.067431561648845673)*dt1_g0_14;
    dt1_l1_3 = dt1_l1_3 + (-0.19861984252929688)*dt1_g0_15;
    dt1_l1_3 = dt1_l1_3 + (0.64975041151046753)*dt1_g0_16;
    dt1_l1_3 = dt1_l1_3 + (-0.10373525321483612)*dt1_g0_17;
    dt1_l1_3 = dt1_l1_3 + (-0.051274355500936508)*dt1_g0_18;
    dt1_l1_3 = dt1_l1_3 + (0.1738811731338501)*dt1_g0_19;
    dt1_l1_3 = dt1_l1_3 + (-0.064860448241233826)*dt1_g0_20;
    dt1_l1_3 = dt1_l1_3 + (0.13006292283535004)*dt1_g0_21;
    dt1_l1_3 = dt1_l1_3 + (0.039197433739900589)*dt1_g0_22;
    dt1_l1_3 = dt1_l1_3 + (0.11295291036367416)*dt1_g0_23;
    dt1_l1_3 = dt1_l1_3 + (0.039528913795948029)*dt1_g0_24;
    dt1_l1_3 = dt1_l1_3 + (0.13462246954441071)*dt1_g0_25;
    dt1_l1_3 = dt1_l1_3 + (0.074103392660617828)*dt1_g0_26;
    dt1_l1_3 = dt1_l1_3 + (-0.0064598540775477886)*dt1_g0_27;
    dt1_l1_3 = dt1_l1_3 + (-0.24211853742599487)*dt1_g0_28;
    dt1_l1_3 = dt1_l1_3 + (0.093256272375583649)*dt1_g0_29;
    dt1_l1_3 = dt1_l1_3 + (-0.17873191833496094)*dt1_g0_30;
    dt1_l1_3 = dt1_l1_3 + (0.13665640354156494)*dt1_g0_31;
    dt1_l1_4 = 0.12263526022434235;
    dt1_l1_4 = dt1_l1_4 + (0.17370125651359558)*dt1_g0_0;
    dt1_l1_4 = dt1_l1_4 + (-0.083672083914279938)*dt1_g0_1;
    dt1_l1_4 = dt1_l1_4 + (-0.058013491332530975)*dt1_g0_2;
    dt1_l1_4 = dt1_l1_4 + (0.030379418283700943)*dt1_g0_3;
    dt1_l1_4 = dt1_l1_4 + (-0.03496987372636795)*dt1_g0_4;
    dt1_l1_4 = dt1_l1_4 + (-0.34480535984039307)*dt1_g0_5;
    dt1_l1_4 = dt1_l1_4 + (0.18003655970096588)*dt1_g0_6;
    dt1_l1_4 = dt1_l1_4 + (-0.012501563876867294)*dt1_g0_7;
    dt1_l1_4 = dt1_l1_4 + (0.10306855291128159)*dt1_g0_8;
    dt1_l1_4 = dt1_l1_4 + (0.0010572918690741062)*dt1_g0_9;
    dt1_l1_4 = dt1_l1_4 + (0.22152738273143768)*dt1_g0_10;
    dt1_l1_4 = dt1_l1_4 + (-0.046255137771368027)*dt1_g0_11;
    dt1_l1_4 = dt1_l1_4 + (0.078009523451328278)*dt1_g0_12;
    dt1_l1_4 = dt1_l1_4 + (0.066000305116176605)*dt1_g0_13;
    dt1_l1_4 = dt1_l1_4 + (-0.13832651078701019)*dt1_g0_14;
    dt1_l1_4 = dt1_l1_4 + (0.15796451270580292)*dt1_g0_15;
    dt1_l1_4 = dt1_l1_4 + (0.050529871135950089)*dt1_g0_16;
    dt1_l1_4 = dt1_l1_4 + (0.21294906735420227)*dt1_g0_17;
    dt1_l1_4 = dt1_l1_4 + (-0.12090930342674255)*dt1_g0_18;
    dt1_l1_4 = dt1_l1_4 + (-0.068031854927539825)*dt1_g0_19;
    dt1_l1_4 = dt1_l1_4 + (-0.10580087453126907)*dt1_g0_20;
    dt1_l1_4 = dt1_l1_4 + (-0.0046419226564466953)*dt1_g0_21;
    dt1_l1_4 = dt1_l1_4 + (-0.082880429923534393)*dt1_g0_22;
    dt1_l1_4 = dt1_l1_4 + (-0.032585814595222473)*dt1_g0_23;
    dt1_l1_4 = dt1_l1_4 + (-0.10039889067411423)*dt1_g0_24;
    dt1_l1_4 = dt1_l1_4 + (0.11109044402837753)*dt1_g0_25;
    dt1_l1_4 = dt1_l1_4 + (-0.080455757677555084)*dt1_g0_26;
    dt1_l1_4 = dt1_l1_4 + (0.0014013194013386965)*dt1_g0_27;
    dt1_l1_4 = dt1_l1_4 + (-0.15381021797657013)*dt1_g0_28;
    dt1_l1_4 = dt1_l1_4 + (0.05111057311296463)*dt1_g0_29;
    dt1_l1_4 = dt1_l1_4 + (0.076669268310070038)*dt1_g0_30;
    dt1_l1_4 = dt1_l1_4 + (-0.17469201982021332)*dt1_g0_31;
    dt1_l1_5 = -0.051718160510063171;
    dt1_l1_5 = dt1_l1_5 + (0.12622646987438202)*dt1_g0_0;
    dt1_l1_5 = dt1_l1_5 + (0.15407618880271912)*dt1_g0_1;
    dt1_l1_5 = dt1_l1_5 + (0.1102263480424881)*dt1_g0_2;
    dt1_l1_5 = dt1_l1_5 + (0.081044577062129974)*dt1_g0_3;
    dt1_l1_5 = dt1_l1_5 + (0.15326599776744843)*dt1_g0_4;
    dt1_l1_5 = dt1_l1_5 + (0.064281925559043884)*dt1_g0_5;
    dt1_l1_5 = dt1_l1_5 + (-0.21500757336616516)*dt1_g0_6;
    dt1_l1_5 = dt1_l1_5 + (0.098096363246440887)*dt1_g0_7;
    dt1_l1_5 = dt1_l1_5 + (-0.035208825021982193)*dt1_g0_8;
    dt1_l1_5 = dt1_l1_5 + (-0.029627483338117599)*dt1_g0_9;
    dt1_l1_5 = dt1_l1_5 + (0.23539173603057861)*dt1_g0_10;
    dt1_l1_5 = dt1_l1_5 + (-0.059684157371520996)*dt1_g0_11;
    dt1_l1_5 = dt1_l1_5 + (0.18764948844909668)*dt1_g0_12;
    dt1_l1_5 = dt1_l1_5 + (-0.10946971923112869)*dt1_g0_13;
    dt1_l1_5 = dt1_l1_5 + (-0.058492869138717651)*dt1_g0_14;
    dt1_l1_5 = dt1_l1_5 + (0.29810228943824768)*dt1_g0_15;
    dt1_l1_5 = dt1_l1_5 + (-0.25540083646774292)*dt1_g0_16;
    dt1_l1_5 = dt1_l1_5 + (-0.25962957739830017)*dt1_g0_17;
    dt1_l1_5 = dt1_l1_5 + (0.07244226336479187)*dt1_g0_18;
    dt1_l1_5 = dt1_l1_5 + (-0.015826232731342316)*dt1_g0_19;
    dt1_l1_5 = dt1_l1_5 + (-0.13939377665519714)*dt1_g0_20;
    dt1_l1_5 = dt1_l1_5 + (-0.034775912761688232)*dt1_g0_21;
    dt1_l1_5 = dt1_l1_5 + (-0.21197742223739624)*dt1_g0_22;
    dt1_l1_5 = dt1_l1_5 + (-0.10610435903072357)*dt1_g0_23;
    dt1_l1_5 = dt1_l1_5 + (0.053570564836263657)*dt1_g0_24;
    dt1_l1_5 = dt1_l1_5 + (0.040605675429105759)*dt1_g0_25;
    dt1_l1_5 = dt1_l1_5 + (0.023010404780507088)*dt1_g0_26;
    dt1_l1_5 = dt1_l1_5 + (0.12137638777494431)*dt1_g0_27;
    dt1_l1_5 = dt1_l1_5 + (0.23015812039375305)*dt1_g0_28;
    dt1_l1_5 = dt1_l1_5 + (0.06396755576133728)*dt1_g0_29;
    dt1_l1_5 = dt1_l1_5 + (-0.11600128561258316)*dt1_g0_30;
    dt1_l1_5 = dt1_l1_5 + (0.0018161108018830419)*dt1_g0_31;
    dt1_l1_6 = -0.14502783119678497;
    dt1_l1_6 = dt1_l1_6 + (-0.21617880463600159)*dt1_g0_0;
    dt1_l1_6 = dt1_l1_6 + (0.024907056242227554)*dt1_g0_1;
    dt1_l1_6 = dt1_l1_6 + (0.28527197241783142)*dt1_g0_2;
    dt1_l1_6 = dt1_l1_6 + (-0.10465603321790695)*dt1_g0_3;
    dt1_l1_6 = dt1_l1_6 + (0.004011248704046011)*dt1_g0_4;
    dt1_l1_6 = dt1_l1_6 + (0.11178028583526611)*dt1_g0_5;
    dt1_l1_6 = dt1_l1_6 + (0.13247388601303101)*dt1_g0_6;
    dt1_l1_6 = dt1_l1_6 + (0.17205116152763367)*dt1_g0_7;
    dt1_l1_6 = dt1_l1_6 + (0.017789272591471672)*dt1_g0_8;
    dt1_l1_6 = dt1_l1_6 + (0.0079919397830963135)*dt1_g0_9;
    dt1_l1_6 = dt1_l1_6 + (-0.17143863439559937)*dt1_g0_10;
    dt1_l1_6 = dt1_l1_6 + (-0.090974859893321991)*dt1_g0_11;
    dt1_l1_6 = dt1_l1_6 + (0.00026911767781712115)*dt1_g0_12;
    dt1_l1_6 = dt1_l1_6 + (0.12699028849601746)*dt1_g0_13;
    dt1_l1_6 = dt1_l1_6 + (0.012657118029892445)*dt1_g0_14;
    dt1_l1_6 = dt1_l1_6 + (0.014249536208808422)*dt1_g0_15;
    dt1_l1_6 = dt1_l1_6 + (0.29837688803672791)*dt1_g0_16;
    dt1_l1_6 = dt1_l1_6 + (0.10275484621524811)*dt1_g0_17;
    dt1_l1_6 = dt1_l1_6 + (-0.052840493619441986)*dt1_g0_18;
    dt1_l1_6 = dt1_l1_6 + (-0.064061515033245087)*dt1_g0_19;
    dt1_l1_6 = dt1_l1_6 + (0.084928445518016815)*dt1_g0_20;
    dt1_l1_6 = dt1_l1_6 + (-0.10871539264917374)*dt1_g0_21;
    dt1_l1_6 = dt1_l1_6 + (0.17323924601078033)*dt1_g0_22;
    dt1_l1_6 = dt1_l1_6 + (0.063852109014987946)*dt1_g0_23;
    dt1_l1_6 = dt1_l1_6 + (-0.054064754396677017)*dt1_g0_24;
    dt1_l1_6 = dt1_l1_6 + (-0.096406780183315277)*dt1_g0_25;
    dt1_l1_6 = dt1_l1_6 + (0.034694094210863113)*dt1_g0_26;
    dt1_l1_6 = dt1_l1_6 + (-0.040985178202390671)*dt1_g0_27;
    dt1_l1_6 = dt1_l1_6 + (-0.1414448469877243)*dt1_g0_28;
    dt1_l1_6 = dt1_l1_6 + (-0.18324244022369385)*dt1_g0_29;
    dt1_l1_6 = dt1_l1_6 + (-0.0061641675420105457)*dt1_g0_30;
    dt1_l1_6 = dt1_l1_6 + (0.14373365044593811)*dt1_g0_31;
    dt1_l1_7 = 0.15039798617362976;
    dt1_l1_7 = dt1_l1_7 + (0.047673169523477554)*dt1_g0_0;
    dt1_l1_7 = dt1_l1_7 + (0.072389706969261169)*dt1_g0_1;
    dt1_l1_7 = dt1_l1_7 + (-0.065495222806930542)*dt1_g0_2;
    dt1_l1_7 = dt1_l1_7 + (-0.037528026849031448)*dt1_g0_3;
    dt1_l1_7 = dt1_l1_7 + (-0.10889255255460739)*dt1_g0_4;
    dt1_l1_7 = dt1_l1_7 + (0.11605526506900787)*dt1_g0_5;
    dt1_l1_7 = dt1_l1_7 + (-0.026777036488056183)*dt1_g0_6;
    dt1_l1_7 = dt1_l1_7 + (-0.028399230912327766)*dt1_g0_7;
    dt1_l1_7 = dt1_l1_7 + (0.047372490167617798)*dt1_g0_8;
    dt1_l1_7 = dt1_l1_7 + (-0.012069370597600937)*dt1_g0_9;
    dt1_l1_7 = dt1_l1_7 + (-0.083184346556663513)*dt1_g0_10;
    dt1_l1_7 = dt1_l1_7 + (0.02154984325170517)*dt1_g0_11;
    dt1_l1_7 = dt1_l1_7 + (-0.040346946567296982)*dt1_g0_12;
    dt1_l1_7 = dt1_l1_7 + (-0.16211129724979401)*dt1_g0_13;
    dt1_l1_7 = dt1_l1_7 + (0.13870799541473389)*dt1_g0_14;
    dt1_l1_7 = dt1_l1_7 + (-0.19581884145736694)*dt1_g0_15;
    dt1_l1_7 = dt1_l1_7 + (-0.1117430180311203)*dt1_g0_16;
    dt1_l1_7 = dt1_l1_7 + (0.17394495010375977)*dt1_g0_17;
    dt1_l1_7 = dt1_l1_7 + (-0.00035679028951562941)*dt1_g0_18;
    dt1_l1_7 = dt1_l1_7 + (-0.048673704266548157)*dt1_g0_19;
    dt1_l1_7 = dt1_l1_7 + (0.15421126782894135)*dt1_g0_20;
    dt1_l1_7 = dt1_l1_7 + (0.13505768775939941)*dt1_g0_21;
    dt1_l1_7 = dt1_l1_7 + (0.036396581679582596)*dt1_g0_22;
    dt1_l1_7 = dt1_l1_7 + (0.0034029996022582054)*dt1_g0_23;
    dt1_l1_7 = dt1_l1_7 + (-0.24609997868537903)*dt1_g0_24;
    dt1_l1_7 = dt1_l1_7 + (0.15485222637653351)*dt1_g0_25;
    dt1_l1_7 = dt1_l1_7 + (-0.073318503797054291)*dt1_g0_26;
    dt1_l1_7 = dt1_l1_7 + (0.050975963473320007)*dt1_g0_27;
    dt1_l1_7 = dt1_l1_7 + (0.016177339479327202)*dt1_g0_28;
    dt1_l1_7 = dt1_l1_7 + (0.069688819348812103)*dt1_g0_29;
    dt1_l1_7 = dt1_l1_7 + (0.070944041013717651)*dt1_g0_30;
    dt1_l1_7 = dt1_l1_7 + (0.11156594753265381)*dt1_g0_31;
    dt1_l1_8 = 0.17791567742824554;
    dt1_l1_8 = dt1_l1_8 + (-0.071427121758460999)*dt1_g0_0;
    dt1_l1_8 = dt1_l1_8 + (-0.014428609050810337)*dt1_g0_1;
    dt1_l1_8 = dt1_l1_8 + (-0.1958298534154892)*dt1_g0_2;
    dt1_l1_8 = dt1_l1_8 + (-0.16039794683456421)*dt1_g0_3;
    dt1_l1_8 = dt1_l1_8 + (-0.13343974947929382)*dt1_g0_4;
    dt1_l1_8 = dt1_l1_8 + (0.26373711228370667)*dt1_g0_5;
    dt1_l1_8 = dt1_l1_8 + (0.017795341089367867)*dt1_g0_6;
    dt1_l1_8 = dt1_l1_8 + (-0.021144472062587738)*dt1_g0_7;
    dt1_l1_8 = dt1_l1_8 + (-0.23094122111797333)*dt1_g0_8;
    dt1_l1_8 = dt1_l1_8 + (0.073461614549160004)*dt1_g0_9;
    dt1_l1_8 = dt1_l1_8 + (0.11966696381568909)*dt1_g0_10;
    dt1_l1_8 = dt1_l1_8 + (0.17676906287670135)*dt1_g0_11;
    dt1_l1_8 = dt1_l1_8 + (-0.048930056393146515)*dt1_g0_12;
    dt1_l1_8 = dt1_l1_8 + (-0.14716175198554993)*dt1_g0_13;
    dt1_l1_8 = dt1_l1_8 + (0.11388258635997772)*dt1_g0_14;
    dt1_l1_8 = dt1_l1_8 + (0.082485564053058624)*dt1_g0_15;
    dt1_l1_8 = dt1_l1_8 + (0.46304497122764587)*dt1_g0_16;
    dt1_l1_8 = dt1_l1_8 + (0.00068784336326643825)*dt1_g0_17;
    dt1_l1_8 = dt1_l1_8 + (0.10457544773817062)*dt1_g0_18;
    dt1_l1_8 = dt1_l1_8 + (-0.0063994922675192356)*dt1_g0_19;
    dt1_l1_8 = dt1_l1_8 + (-0.14240989089012146)*dt1_g0_20;
    dt1_l1_8 = dt1_l1_8 + (-0.048434056341648102)*dt1_g0_21;
    dt1_l1_8 = dt1_l1_8 + (0.16329094767570496)*dt1_g0_22;
    dt1_l1_8 = dt1_l1_8 + (-0.080508217215538025)*dt1_g0_23;
    dt1_l1_8 = dt1_l1_8 + (0.18204766511917114)*dt1_g0_24;
    dt1_l1_8 = dt1_l1_8 + (-0.094055630266666412)*dt1_g0_25;
    dt1_l1_8 = dt1_l1_8 + (-0.12780973315238953)*dt1_g0_26;
    dt1_l1_8 = dt1_l1_8 + (-0.11680302768945694)*dt1_g0_27;
    dt1_l1_8 = dt1_l1_8 + (0.25664985179901123)*dt1_g0_28;
    dt1_l1_8 = dt1_l1_8 + (0.050704926252365112)*dt1_g0_29;
    dt1_l1_8 = dt1_l1_8 + (0.1178852841258049)*dt1_g0_30;
    dt1_l1_8 = dt1_l1_8 + (0.23110063374042511)*dt1_g0_31;
    dt1_l1_9 = -0.13868293166160583;
    dt1_l1_9 = dt1_l1_9 + (0.023834094405174255)*dt1_g0_0;
    dt1_l1_9 = dt1_l1_9 + (0.13403761386871338)*dt1_g0_1;
    dt1_l1_9 = dt1_l1_9 + (0.15153506398200989)*dt1_g0_2;
    dt1_l1_9 = dt1_l1_9 + (0.017937421798706055)*dt1_g0_3;
    dt1_l1_9 = dt1_l1_9 + (0.156947061419487)*dt1_g0_4;
    dt1_l1_9 = dt1_l1_9 + (-0.23003552854061127)*dt1_g0_5;
    dt1_l1_9 = dt1_l1_9 + (-0.11289767175912857)*dt1_g0_6;
    dt1_l1_9 = dt1_l1_9 + (0.049387767910957336)*dt1_g0_7;
    dt1_l1_9 = dt1_l1_9 + (0.21174226701259613)*dt1_g0_8;
    dt1_l1_9 = dt1_l1_9 + (0.18910692632198334)*dt1_g0_9;
    dt1_l1_9 = dt1_l1_9 + (0.10178250819444656)*dt1_g0_10;
    dt1_l1_9 = dt1_l1_9 + (-0.13315603137016296)*dt1_g0_11;
    dt1_l1_9 = dt1_l1_9 + (0.10240495204925537)*dt1_g0_12;
    dt1_l1_9 = dt1_l1_9 + (0.045188978314399719)*dt1_g0_13;
    dt1_l1_9 = dt1_l1_9 + (0.12674446403980255)*dt1_g0_14;
    dt1_l1_9 = dt1_l1_9 + (-0.018667533993721008)*dt1_g0_15;
    dt1_l1_9 = dt1_l1_9 + (0.054173573851585388)*dt1_g0_16;
    dt1_l1_9 = dt1_l1_9 + (-0.050129134207963943)*dt1_g0_17;
    dt1_l1_9 = dt1_l1_9 + (0.10595974326133728)*dt1_g0_18;
    dt1_l1_9 = dt1_l1_9 + (-0.029256910085678101)*dt1_g0_19;
    dt1_l1_9 = dt1_l1_9 + (-0.0041289492510259151)*dt1_g0_20;
    dt1_l1_9 = dt1_l1_9 + (0.067040741443634033)*dt1_g0_21;
    dt1_l1_9 = dt1_l1_9 + (0.28273269534111023)*dt1_g0_22;
    dt1_l1_9 = dt1_l1_9 + (-0.08960222452878952)*dt1_g0_23;
    dt1_l1_9 = dt1_l1_9 + (0.23507948219776154)*dt1_g0_24;
    dt1_l1_9 = dt1_l1_9 + (0.11662031710147858)*dt1_g0_25;
    dt1_l1_9 = dt1_l1_9 + (-0.1481965184211731)*dt1_g0_26;
    dt1_l1_9 = dt1_l1_9 + (0.068826325237751007)*dt1_g0_27;
    dt1_l1_9 = dt1_l1_9 + (-0.41048020124435425)*dt1_g0_28;
    dt1_l1_9 = dt1_l1_9 + (0.028586402535438538)*dt1_g0_29;
    dt1_l1_9 = dt1_l1_9 + (0.093711540102958679)*dt1_g0_30;
    dt1_l1_9 = dt1_l1_9 + (-0.16042201220989227)*dt1_g0_31;
    dt1_l1_10 = -0.078292421996593475;
    dt1_l1_10 = dt1_l1_10 + (0.38613796234130859)*dt1_g0_0;
    dt1_l1_10 = dt1_l1_10 + (0.16861145198345184)*dt1_g0_1;
    dt1_l1_10 = dt1_l1_10 + (-0.034250523895025253)*dt1_g0_2;
    dt1_l1_10 = dt1_l1_10 + (0.12220780551433563)*dt1_g0_3;
    dt1_l1_10 = dt1_l1_10 + (0.076330028474330902)*dt1_g0_4;
    dt1_l1_10 = dt1_l1_10 + (0.45561903715133667)*dt1_g0_5;
    dt1_l1_10 = dt1_l1_10 + (0.09523686021566391)*dt1_g0_6;
    dt1_l1_10 = dt1_l1_10 + (-0.031291704624891281)*dt1_g0_7;
    dt1_l1_10 = dt1_l1_10 + (-0.16195787489414215)*dt1_g0_8;
    dt1_l1_10 = dt1_l1_10 + (-0.12284358590841293)*dt1_g0_9;
    dt1_l1_10 = dt1_l1_10 + (0.19868870079517365)*dt1_g0_10;
    dt1_l1_10 = dt1_l1_10 + (-0.059839930385351181)*dt1_g0_11;
    dt1_l1_10 = dt1_l1_10 + (0.016507105901837349)*dt1_g0_12;
    dt1_l1_10 = dt1_l1_10 + (0.089055366814136505)*dt1_g0_13;
    dt1_l1_10 = dt1_l1_10 + (-0.073398031294345856)*dt1_g0_14;
    dt1_l1_10 = dt1_l1_10 + (0.12010634690523148)*dt1_g0_15;
    dt1_l1_10 = dt1_l1_10 + (-0.56620091199874878)*dt1_g0_16;
    dt1_l1_10 = dt1_l1_10 + (0.032096225768327713)*dt1_g0_17;
    dt1_l1_10 = dt1_l1_10 + (0.060803625732660294)*dt1_g0_18;
    dt1_l1_10 = dt1_l1_10 + (-0.1705658882856369)*dt1_g0_19;
    dt1_l1_10 = dt1_l1_10 + (-0.13755302131175995)*dt1_g0_20;
    dt1_l1_10 = dt1_l1_10 + (-0.087579868733882904)*dt1_g0_21;
    dt1_l1_10 = dt1_l1_10 + (-0.1278015673160553)*dt1_g0_22;
    dt1_l1_10 = dt1_l1_10 + (0.18843105435371399)*dt1_g0_23;
    dt1_l1_10 = dt1_l1_10 + (0.1520625501871109)*dt1_g0_24;
    dt1_l1_10 = dt1_l1_10 + (0.079296454787254333)*dt1_g0_25;
    dt1_l1_10 = dt1_l1_10 + (-0.24782979488372803)*dt1_g0_26;
    dt1_l1_10 = dt1_l1_10 + (-0.039584934711456299)*dt1_g0_27;
    dt1_l1_10 = dt1_l1_10 + (0.37787425518035889)*dt1_g0_28;
    dt1_l1_10 = dt1_l1_10 + (0.11145026236772537)*dt1_g0_29;
    dt1_l1_10 = dt1_l1_10 + (-0.16598974168300629)*dt1_g0_30;
    dt1_l1_10 = dt1_l1_10 + (0.0084111606702208519)*dt1_g0_31;
    dt1_l1_11 = -0.062137391418218613;
    dt1_l1_11 = dt1_l1_11 + (-0.17376498878002167)*dt1_g0_0;
    dt1_l1_11 = dt1_l1_11 + (0.096284717321395874)*dt1_g0_1;
    dt1_l1_11 = dt1_l1_11 + (-0.091086395084857941)*dt1_g0_2;
    dt1_l1_11 = dt1_l1_11 + (-0.098921611905097961)*dt1_g0_3;
    dt1_l1_11 = dt1_l1_11 + (-0.13950799405574799)*dt1_g0_4;
    dt1_l1_11 = dt1_l1_11 + (-0.21119497716426849)*dt1_g0_5;
    dt1_l1_11 = dt1_l1_11 + (-0.29174453020095825)*dt1_g0_6;
    dt1_l1_11 = dt1_l1_11 + (-0.041246883571147919)*dt1_g0_7;
    dt1_l1_11 = dt1_l1_11 + (-0.19079685211181641)*dt1_g0_8;
    dt1_l1_11 = dt1_l1_11 + (-0.063988305628299713)*dt1_g0_9;
    dt1_l1_11 = dt1_l1_11 + (0.19126258790493011)*dt1_g0_10;
    dt1_l1_11 = dt1_l1_11 + (-0.17825838923454285)*dt1_g0_11;
    dt1_l1_11 = dt1_l1_11 + (-0.15225179493427277)*dt1_g0_12;
    dt1_l1_11 = dt1_l1_11 + (-0.16363492608070374)*dt1_g0_13;
    dt1_l1_11 = dt1_l1_11 + (-0.10237506777048111)*dt1_g0_14;
    dt1_l1_11 = dt1_l1_11 + (0.18985816836357117)*dt1_g0_15;
    dt1_l1_11 = dt1_l1_11 + (0.11689111590385437)*dt1_g0_16;
    dt1_l1_11 = dt1_l1_11 + (-0.27802398800849915)*dt1_g0_17;
    dt1_l1_11 = dt1_l1_11 + (0.030934391543269157)*dt1_g0_18;
    dt1_l1_11 = dt1_l1_11 + (0.1008097305893898)*dt1_g0_19;
    dt1_l1_11 = dt1_l1_11 + (0.098364770412445068)*dt1_g0_20;
    dt1_l1_11 = dt1_l1_11 + (-0.010569779202342033)*dt1_g0_21;
    dt1_l1_11 = dt1_l1_11 + (0.0079128220677375793)*dt1_g0_22;
    dt1_l1_11 = dt1_l1_11 + (-0.079806827008724213)*dt1_g0_23;
    dt1_l1_11 = dt1_l1_11 + (0.27011299133300781)*dt1_g0_24;
    dt1_l1_11 = dt1_l1_11 + (0.070469021797180176)*dt1_g0_25;
    dt1_l1_11 = dt1_l1_11 + (-0.38286259770393372)*dt1_g0_26;
    dt1_l1_11 = dt1_l1_11 + (-0.14456358551979065)*dt1_g0_27;
    dt1_l1_11 = dt1_l1_11 + (-0.52179837226867676)*dt1_g0_28;
    dt1_l1_11 = dt1_l1_11 + (-0.073391132056713104)*dt1_g0_29;
    dt1_l1_11 = dt1_l1_11 + (0.10099390894174576)*dt1_g0_30;
    dt1_l1_11 = dt1_l1_11 + (-0.2381131649017334)*dt1_g0_31;
    dt1_l1_12 = -0.077903278172016144;
    dt1_l1_12 = dt1_l1_12 + (-0.024478539824485779)*dt1_g0_0;
    dt1_l1_12 = dt1_l1_12 + (0.15509465336799622)*dt1_g0_1;
    dt1_l1_12 = dt1_l1_12 + (0.021082784980535507)*dt1_g0_2;
    dt1_l1_12 = dt1_l1_12 + (-0.089185543358325958)*dt1_g0_3;
    dt1_l1_12 = dt1_l1_12 + (0.0031038988381624222)*dt1_g0_4;
    dt1_l1_12 = dt1_l1_12 + (0.10395709425210953)*dt1_g0_5;
    dt1_l1_12 = dt1_l1_12 + (-0.26505029201507568)*dt1_g0_6;
    dt1_l1_12 = dt1_l1_12 + (-0.10546328872442245)*dt1_g0_7;
    dt1_l1_12 = dt1_l1_12 + (-0.12884120643138885)*dt1_g0_8;
    dt1_l1_12 = dt1_l1_12 + (0.11630596220493317)*dt1_g0_9;
    dt1_l1_12 = dt1_l1_12 + (0.0063452315516769886)*dt1_g0_10;
    dt1_l1_12 = dt1_l1_12 + (-0.0063953367061913013)*dt1_g0_11;
    dt1_l1_12 = dt1_l1_12 + (-0.021227281540632248)*dt1_g0_12;
    dt1_l1_12 = dt1_l1_12 + (-0.10694406181573868)*dt1_g0_13;
    dt1_l1_12 = dt1_l1_12 + (-0.051671974360942841)*dt1_g0_14;
    dt1_l1_12 = dt1_l1_12 + (0.014918405562639236)*dt1_g0_15;
    dt1_l1_12 = dt1_l1_12 + (-0.33986765146255493)*dt1_g0_16;
    dt1_l1_12 = dt1_l1_12 + (0.024092648178339005)*dt1_g0_17;
    dt1_l1_12 = dt1_l1_12 + (0.090858824551105499)*dt1_g0_18;
    dt1_l1_12 = dt1_l1_12 + (0.19264908134937286)*dt1_g0_19;
    dt1_l1_12 = dt1_l1_12 + (-0.082039140164852142)*dt1_g0_20;
    dt1_l1_12 = dt1_l1_12 + (0.0058428267948329449)*dt1_g0_21;
    dt1_l1_12 = dt1_l1_12 + (0.25755473971366882)*dt1_g0_22;
    dt1_l1_12 = dt1_l1_12 + (0.048122107982635498)*dt1_g0_23;
    dt1_l1_12 = dt1_l1_12 + (-0.25055438280105591)*dt1_g0_24;
    dt1_l1_12 = dt1_l1_12 + (0.016316866502165794)*dt1_g0_25;
    dt1_l1_12 = dt1_l1_12 + (-0.081792674958705902)*dt1_g0_26;
    dt1_l1_12 = dt1_l1_12 + (-0.063519790768623352)*dt1_g0_27;
    dt1_l1_12 = dt1_l1_12 + (0.50614690780639648)*dt1_g0_28;
    dt1_l1_12 = dt1_l1_12 + (-0.066375598311424255)*dt1_g0_29;
    dt1_l1_12 = dt1_l1_12 + (0.090680874884128571)*dt1_g0_30;
    dt1_l1_12 = dt1_l1_12 + (-0.073922984302043915)*dt1_g0_31;
    dt1_l1_13 = -0.12205866724252701;
    dt1_l1_13 = dt1_l1_13 + (-0.25504162907600403)*dt1_g0_0;
    dt1_l1_13 = dt1_l1_13 + (-0.049930181354284286)*dt1_g0_1;
    dt1_l1_13 = dt1_l1_13 + (0.14232224225997925)*dt1_g0_2;
    dt1_l1_13 = dt1_l1_13 + (0.15969088673591614)*dt1_g0_3;
    dt1_l1_13 = dt1_l1_13 + (0.14399471879005432)*dt1_g0_4;
    dt1_l1_13 = dt1_l1_13 + (-0.058044787496328354)*dt1_g0_5;
    dt1_l1_13 = dt1_l1_13 + (0.11529924720525742)*dt1_g0_6;
    dt1_l1_13 = dt1_l1_13 + (0.039351854473352432)*dt1_g0_7;
    dt1_l1_13 = dt1_l1_13 + (0.12985527515411377)*dt1_g0_8;
    dt1_l1_13 = dt1_l1_13 + (-0.055830512195825577)*dt1_g0_9;
    dt1_l1_13 = dt1_l1_13 + (-0.11088638752698898)*dt1_g0_10;
    dt1_l1_13 = dt1_l1_13 + (-0.071301668882369995)*dt1_g0_11;
    dt1_l1_13 = dt1_l1_13 + (0.059834972023963928)*dt1_g0_12;
    dt1_l1_13 = dt1_l1_13 + (-0.026034511625766754)*dt1_g0_13;
    dt1_l1_13 = dt1_l1_13 + (0.18610493838787079)*dt1_g0_14;
    dt1_l1_13 = dt1_l1_13 + (-0.070099622011184692)*dt1_g0_15;
    dt1_l1_13 = dt1_l1_13 + (0.2838326096534729)*dt1_g0_16;
    dt1_l1_13 = dt1_l1_13 + (-0.037520397454500198)*dt1_g0_17;
    dt1_l1_13 = dt1_l1_13 + (0.13068065047264099)*dt1_g0_18;
    dt1_l1_13 = dt1_l1_13 + (0.066525585949420929)*dt1_g0_19;
    dt1_l1_13 = dt1_l1_13 + (-0.049645096063613892)*dt1_g0_20;
    dt1_l1_13 = dt1_l1_13 + (0.054189886897802353)*dt1_g0_21;
    dt1_l1_13 = dt1_l1_13 + (-0.17614948749542236)*dt1_g0_22;
    dt1_l1_13 = dt1_l1_13 + (0.0069473623298108578)*dt1_g0_23;
    dt1_l1_13 = dt1_l1_13 + (-0.071386918425559998)*dt1_g0_24;
    dt1_l1_13 = dt1_l1_13 + (-0.1061040461063385)*dt1_g0_25;
    dt1_l1_13 = dt1_l1_13 + (0.24330644309520721)*dt1_g0_26;
    dt1_l1_13 = dt1_l1_13 + (0.13288405537605286)*dt1_g0_27;
    dt1_l1_13 = dt1_l1_13 + (-0.095819815993309021)*dt1_g0_28;
    dt1_l1_13 = dt1_l1_13 + (0.1976703405380249)*dt1_g0_29;
    dt1_l1_13 = dt1_l1_13 + (-0.10413108766078949)*dt1_g0_30;
    dt1_l1_13 = dt1_l1_13 + (-0.066180601716041565)*dt1_g0_31;
    dt1_l1_14 = 0.10435187816619873;
    dt1_l1_14 = dt1_l1_14 + (0.066092170774936676)*dt1_g0_0;
    dt1_l1_14 = dt1_l1_14 + (-0.14066116511821747)*dt1_g0_1;
    dt1_l1_14 = dt1_l1_14 + (0.0070511805824935436)*dt1_g0_2;
    dt1_l1_14 = dt1_l1_14 + (0.016216622665524483)*dt1_g0_3;
    dt1_l1_14 = dt1_l1_14 + (-0.077155455946922302)*dt1_g0_4;
    dt1_l1_14 = dt1_l1_14 + (-0.0035024809185415506)*dt1_g0_5;
    dt1_l1_14 = dt1_l1_14 + (0.16614776849746704)*dt1_g0_6;
    dt1_l1_14 = dt1_l1_14 + (-0.097305327653884888)*dt1_g0_7;
    dt1_l1_14 = dt1_l1_14 + (0.049758661538362503)*dt1_g0_8;
    dt1_l1_14 = dt1_l1_14 + (-0.10961616039276123)*dt1_g0_9;
    dt1_l1_14 = dt1_l1_14 + (0.082717306911945343)*dt1_g0_10;
    dt1_l1_14 = dt1_l1_14 + (0.080690205097198486)*dt1_g0_11;
    dt1_l1_14 = dt1_l1_14 + (-0.019630759954452515)*dt1_g0_12;
    dt1_l1_14 = dt1_l1_14 + (-0.14077238738536835)*dt1_g0_13;
    dt1_l1_14 = dt1_l1_14 + (-0.14777269959449768)*dt1_g0_14;
    dt1_l1_14 = dt1_l1_14 + (0.1627192497253418)*dt1_g0_15;
    dt1_l1_14 = dt1_l1_14 + (-0.27055931091308594)*dt1_g0_16;
    dt1_l1_14 = dt1_l1_14 + (0.24675653874874115)*dt1_g0_17;
    dt1_l1_14 = dt1_l1_14 + (-0.13080167770385742)*dt1_g0_18;
    dt1_l1_14 = dt1_l1_14 + (-0.12526585161685944)*dt1_g0_19;
    dt1_l1_14 = dt1_l1_14 + (0.026029074564576149)*dt1_g0_20;
    dt1_l1_14 = dt1_l1_14 + (0.00069717544829472899)*dt1_g0_21;
    dt1_l1_14 = dt1_l1_14 + (-0.24566978216171265)*dt1_g0_22;
    dt1_l1_14 = dt1_l1_14 + (-0.03789505735039711)*dt1_g0_23;
    dt1_l1_14 = dt1_l1_14 + (0.031554587185382843)*dt1_g0_24;
    dt1_l1_14 = dt1_l1_14 + (-0.16307400166988373)*dt1_g0_25;
    dt1_l1_14 = dt1_l1_14 + (0.18186207115650177)*dt1_g0_26;
    dt1_l1_14 = dt1_l1_14 + (0.10117419809103012)*dt1_g0_27;
    dt1_l1_14 = dt1_l1_14 + (0.71069341897964478)*dt1_g0_28;
    dt1_l1_14 = dt1_l1_14 + (-0.094877868890762329)*dt1_g0_29;
    dt1_l1_14 = dt1_l1_14 + (-0.10863464325666428)*dt1_g0_30;
    dt1_l1_14 = dt1_l1_14 + (0.044603679329156876)*dt1_g0_31;
    dt1_l1_15 = 0.054931297898292542;
    dt1_l1_15 = dt1_l1_15 + (-0.12308650463819504)*dt1_g0_0;
    dt1_l1_15 = dt1_l1_15 + (0.10122453421354294)*dt1_g0_1;
    dt1_l1_15 = dt1_l1_15 + (-0.036758832633495331)*dt1_g0_2;
    dt1_l1_15 = dt1_l1_15 + (-0.055523984134197235)*dt1_g0_3;
    dt1_l1_15 = dt1_l1_15 + (0.024221815168857574)*dt1_g0_4;
    dt1_l1_15 = dt1_l1_15 + (0.36427092552185059)*dt1_g0_5;
    dt1_l1_15 = dt1_l1_15 + (0.013182561844587326)*dt1_g0_6;
    dt1_l1_15 = dt1_l1_15 + (-0.084676198661327362)*dt1_g0_7;
    dt1_l1_15 = dt1_l1_15 + (0.094983756542205811)*dt1_g0_8;
    dt1_l1_15 = dt1_l1_15 + (-0.044733546674251556)*dt1_g0_9;
    dt1_l1_15 = dt1_l1_15 + (-0.068374097347259521)*dt1_g0_10;
    dt1_l1_15 = dt1_l1_15 + (0.073864951729774475)*dt1_g0_11;
    dt1_l1_15 = dt1_l1_15 + (0.040122237056493759)*dt1_g0_12;
    dt1_l1_15 = dt1_l1_15 + (-0.11484098434448242)*dt1_g0_13;
    dt1_l1_15 = dt1_l1_15 + (0.029558604583144188)*dt1_g0_14;
    dt1_l1_15 = dt1_l1_15 + (-0.12961806356906891)*dt1_g0_15;
    dt1_l1_15 = dt1_l1_15 + (-0.68139654397964478)*dt1_g0_16;
    dt1_l1_15 = dt1_l1_15 + (-0.090533196926116943)*dt1_g0_17;
    dt1_l1_15 = dt1_l1_15 + (-0.055364329367876053)*dt1_g0_18;
    dt1_l1_15 = dt1_l1_15 + (-0.037381157279014587)*dt1_g0_19;
    dt1_l1_15 = dt1_l1_15 + (-0.013406396843492985)*dt1_g0_20;
    dt1_l1_15 = dt1_l1_15 + (0.067575834691524506)*dt1_g0_21;
    dt1_l1_15 = dt1_l1_15 + (-0.080908246338367462)*dt1_g0_22;
    dt1_l1_15 = dt1_l1_15 + (0.05767367035150528)*dt1_g0_23;
    dt1_l1_15 = dt1_l1_15 + (0.042280886322259903)*dt1_g0_24;
    dt1_l1_15 = dt1_l1_15 + (-0.18634659051895142)*dt1_g0_25;
    dt1_l1_15 = dt1_l1_15 + (0.31346985697746277)*dt1_g0_26;
    dt1_l1_15 = dt1_l1_15 + (0.038848195225000381)*dt1_g0_27;
    dt1_l1_15 = dt1_l1_15 + (0.23577156662940979)*dt1_g0_28;
    dt1_l1_15 = dt1_l1_15 + (-0.014047614298760891)*dt1_g0_29;
    dt1_l1_15 = dt1_l1_15 + (0.096515163779258728)*dt1_g0_30;
    dt1_l1_15 = dt1_l1_15 + (-0.062498938292264938)*dt1_g0_31;
    // Device tower token 2
    dt2_l0_0 = (-0.8181758287015638) + (0.34432113170623779)*eps_ox_scaled;
    dt2_l0_1 = (-1.3567823146691704) + (0.47822898626327515)*eps_ox_scaled;
    dt2_l0_2 = (0.64082301807314079) + (0.24066966772079468)*eps_ox_scaled;
    dt2_l0_3 = (-0.094063055245650229) + (0.048484642058610916)*eps_ox_scaled;
    dt2_l0_4 = (0.075286776760842611) + (0.13176910579204559)*eps_ox_scaled;
    dt2_l0_5 = (0.82553608470709439) + (-0.30407708883285522)*eps_ox_scaled;
    dt2_l0_6 = (-0.69419908266487607) + (-0.11684082448482513)*eps_ox_scaled;
    dt2_l0_7 = (-0.11441747271573643) + (0.040982868522405624)*eps_ox_scaled;
    dt2_l0_8 = (1.0907016593875112) + (0.61334097385406494)*eps_ox_scaled;
    dt2_l0_9 = (-0.027864230761230013) + (0.14561383426189423)*eps_ox_scaled;
    dt2_l0_10 = (-0.069608573220484415) + (0.45312285423278809)*eps_ox_scaled;
    dt2_l0_11 = (-0.058642057050594665) + (-0.057421129196882248)*eps_ox_scaled;
    dt2_l0_12 = (0.098381977517566555) + (0.076745271682739258)*eps_ox_scaled;
    dt2_l0_13 = (-0.29917125847641568) + (0.11903565376996994)*eps_ox_scaled;
    dt2_l0_14 = (-0.036962693565880111) + (0.049182634800672531)*eps_ox_scaled;
    dt2_l0_15 = (0.09861836178269745) + (0.39639326930046082)*eps_ox_scaled;
    dt2_l0_16 = (-0.5018105325969735) + (-0.5463671088218689)*eps_ox_scaled;
    dt2_l0_17 = (-0.93967326502383752) + (-0.34476840496063232)*eps_ox_scaled;
    dt2_l0_18 = (-0.17150610458067356) + (0.042969517409801483)*eps_ox_scaled;
    dt2_l0_19 = (-0.012876825642246514) + (-0.30303272604942322)*eps_ox_scaled;
    dt2_l0_20 = (-0.11691817108604963) + (0.073118828237056732)*eps_ox_scaled;
    dt2_l0_21 = (-0.21896841176435217) + (0.060475107282400131)*eps_ox_scaled;
    dt2_l0_22 = (-0.34935056688315413) + (0.23183275759220123)*eps_ox_scaled;
    dt2_l0_23 = (0.21868031655665507) + (0.0091169727966189384)*eps_ox_scaled;
    dt2_l0_24 = (-0.4573412277540933) + (-0.022656848654150963)*eps_ox_scaled;
    dt2_l0_25 = (-0.14664957055907646) + (0.13182426989078522)*eps_ox_scaled;
    dt2_l0_26 = (-1.1031609251126506) + (-0.41274189949035645)*eps_ox_scaled;
    dt2_l0_27 = (0.082457290925357252) + (0.14568156003952026)*eps_ox_scaled;
    dt2_l0_28 = (-0.43855505416200674) + (-0.67684346437454224)*eps_ox_scaled;
    dt2_l0_29 = (-0.012785314647849155) + (0.01818244531750679)*eps_ox_scaled;
    dt2_l0_30 = (-0.26965335573266225) + (0.22900021076202393)*eps_ox_scaled;
    dt2_l0_31 = (0.54947956548767629) + (-0.24716407060623169)*eps_ox_scaled;
    dt2_mean = (dt2_l0_0 + dt2_l0_1 + dt2_l0_2 + dt2_l0_3 + dt2_l0_4 + dt2_l0_5 + dt2_l0_6 + dt2_l0_7 + dt2_l0_8 + dt2_l0_9 + dt2_l0_10 + dt2_l0_11 + dt2_l0_12 + dt2_l0_13 + dt2_l0_14 + dt2_l0_15 + dt2_l0_16 + dt2_l0_17 + dt2_l0_18 + dt2_l0_19 + dt2_l0_20 + dt2_l0_21 + dt2_l0_22 + dt2_l0_23 + dt2_l0_24 + dt2_l0_25 + dt2_l0_26 + dt2_l0_27 + dt2_l0_28 + dt2_l0_29 + dt2_l0_30 + dt2_l0_31) / 32;
    dt2_var = (((dt2_l0_0) - dt2_mean)*((dt2_l0_0) - dt2_mean) + ((dt2_l0_1) - dt2_mean)*((dt2_l0_1) - dt2_mean) + ((dt2_l0_2) - dt2_mean)*((dt2_l0_2) - dt2_mean) + ((dt2_l0_3) - dt2_mean)*((dt2_l0_3) - dt2_mean) + ((dt2_l0_4) - dt2_mean)*((dt2_l0_4) - dt2_mean) + ((dt2_l0_5) - dt2_mean)*((dt2_l0_5) - dt2_mean) + ((dt2_l0_6) - dt2_mean)*((dt2_l0_6) - dt2_mean) + ((dt2_l0_7) - dt2_mean)*((dt2_l0_7) - dt2_mean) + ((dt2_l0_8) - dt2_mean)*((dt2_l0_8) - dt2_mean) + ((dt2_l0_9) - dt2_mean)*((dt2_l0_9) - dt2_mean) + ((dt2_l0_10) - dt2_mean)*((dt2_l0_10) - dt2_mean) + ((dt2_l0_11) - dt2_mean)*((dt2_l0_11) - dt2_mean) + ((dt2_l0_12) - dt2_mean)*((dt2_l0_12) - dt2_mean) + ((dt2_l0_13) - dt2_mean)*((dt2_l0_13) - dt2_mean) + ((dt2_l0_14) - dt2_mean)*((dt2_l0_14) - dt2_mean) + ((dt2_l0_15) - dt2_mean)*((dt2_l0_15) - dt2_mean) + ((dt2_l0_16) - dt2_mean)*((dt2_l0_16) - dt2_mean) + ((dt2_l0_17) - dt2_mean)*((dt2_l0_17) - dt2_mean) + ((dt2_l0_18) - dt2_mean)*((dt2_l0_18) - dt2_mean) + ((dt2_l0_19) - dt2_mean)*((dt2_l0_19) - dt2_mean) + ((dt2_l0_20) - dt2_mean)*((dt2_l0_20) - dt2_mean) + ((dt2_l0_21) - dt2_mean)*((dt2_l0_21) - dt2_mean) + ((dt2_l0_22) - dt2_mean)*((dt2_l0_22) - dt2_mean) + ((dt2_l0_23) - dt2_mean)*((dt2_l0_23) - dt2_mean) + ((dt2_l0_24) - dt2_mean)*((dt2_l0_24) - dt2_mean) + ((dt2_l0_25) - dt2_mean)*((dt2_l0_25) - dt2_mean) + ((dt2_l0_26) - dt2_mean)*((dt2_l0_26) - dt2_mean) + ((dt2_l0_27) - dt2_mean)*((dt2_l0_27) - dt2_mean) + ((dt2_l0_28) - dt2_mean)*((dt2_l0_28) - dt2_mean) + ((dt2_l0_29) - dt2_mean)*((dt2_l0_29) - dt2_mean) + ((dt2_l0_30) - dt2_mean)*((dt2_l0_30) - dt2_mean) + ((dt2_l0_31) - dt2_mean)*((dt2_l0_31) - dt2_mean)) / 32;
    dt2_n0_0 = (((dt2_l0_0) - dt2_mean) / sqrt(dt2_var + ln_eps)) * (1.1696591377258301) + (-0.11109431833028793);
    dt2_g0_0 = gelu_approx(dt2_n0_0);
    dt2_n0_1 = (((dt2_l0_1) - dt2_mean) / sqrt(dt2_var + ln_eps)) * (1.1050513982772827) + (-0.035068709403276443);
    dt2_g0_1 = gelu_approx(dt2_n0_1);
    dt2_n0_2 = (((dt2_l0_2) - dt2_mean) / sqrt(dt2_var + ln_eps)) * (1.04068922996521) + (-0.089032895863056183);
    dt2_g0_2 = gelu_approx(dt2_n0_2);
    dt2_n0_3 = (((dt2_l0_3) - dt2_mean) / sqrt(dt2_var + ln_eps)) * (0.67314571142196655) + (-0.25178694725036621);
    dt2_g0_3 = gelu_approx(dt2_n0_3);
    dt2_n0_4 = (((dt2_l0_4) - dt2_mean) / sqrt(dt2_var + ln_eps)) * (0.85388195514678955) + (-0.12780840694904327);
    dt2_g0_4 = gelu_approx(dt2_n0_4);
    dt2_n0_5 = (((dt2_l0_5) - dt2_mean) / sqrt(dt2_var + ln_eps)) * (1.2238403558731079) + (-0.017596408724784851);
    dt2_g0_5 = gelu_approx(dt2_n0_5);
    dt2_n0_6 = (((dt2_l0_6) - dt2_mean) / sqrt(dt2_var + ln_eps)) * (0.98674929141998291) + (-0.047802694141864777);
    dt2_g0_6 = gelu_approx(dt2_n0_6);
    dt2_n0_7 = (((dt2_l0_7) - dt2_mean) / sqrt(dt2_var + ln_eps)) * (0.73881924152374268) + (-0.26099607348442078);
    dt2_g0_7 = gelu_approx(dt2_n0_7);
    dt2_n0_8 = (((dt2_l0_8) - dt2_mean) / sqrt(dt2_var + ln_eps)) * (1.0608246326446533) + (-0.078888535499572754);
    dt2_g0_8 = gelu_approx(dt2_n0_8);
    dt2_n0_9 = (((dt2_l0_9) - dt2_mean) / sqrt(dt2_var + ln_eps)) * (0.785602867603302) + (-0.15794672071933746);
    dt2_g0_9 = gelu_approx(dt2_n0_9);
    dt2_n0_10 = (((dt2_l0_10) - dt2_mean) / sqrt(dt2_var + ln_eps)) * (1.020018458366394) + (-0.036895915865898132);
    dt2_g0_10 = gelu_approx(dt2_n0_10);
    dt2_n0_11 = (((dt2_l0_11) - dt2_mean) / sqrt(dt2_var + ln_eps)) * (0.85727518796920776) + (-0.12107124924659729);
    dt2_g0_11 = gelu_approx(dt2_n0_11);
    dt2_n0_12 = (((dt2_l0_12) - dt2_mean) / sqrt(dt2_var + ln_eps)) * (0.72308427095413208) + (-0.25479298830032349);
    dt2_g0_12 = gelu_approx(dt2_n0_12);
    dt2_n0_13 = (((dt2_l0_13) - dt2_mean) / sqrt(dt2_var + ln_eps)) * (0.86266148090362549) + (-0.14110274612903595);
    dt2_g0_13 = gelu_approx(dt2_n0_13);
    dt2_n0_14 = (((dt2_l0_14) - dt2_mean) / sqrt(dt2_var + ln_eps)) * (0.74258971214294434) + (-0.25694161653518677);
    dt2_g0_14 = gelu_approx(dt2_n0_14);
    dt2_n0_15 = (((dt2_l0_15) - dt2_mean) / sqrt(dt2_var + ln_eps)) * (1.0297513008117676) + (-0.048506777733564377);
    dt2_g0_15 = gelu_approx(dt2_n0_15);
    dt2_n0_16 = (((dt2_l0_16) - dt2_mean) / sqrt(dt2_var + ln_eps)) * (1.6998714208602905) + (0.031608574092388153);
    dt2_g0_16 = gelu_approx(dt2_n0_16);
    dt2_n0_17 = (((dt2_l0_17) - dt2_mean) / sqrt(dt2_var + ln_eps)) * (1.0622228384017944) + (-0.10873574018478394);
    dt2_g0_17 = gelu_approx(dt2_n0_17);
    dt2_n0_18 = (((dt2_l0_18) - dt2_mean) / sqrt(dt2_var + ln_eps)) * (0.84898489713668823) + (-0.16742095351219177);
    dt2_g0_18 = gelu_approx(dt2_n0_18);
    dt2_n0_19 = (((dt2_l0_19) - dt2_mean) / sqrt(dt2_var + ln_eps)) * (1.0004963874816895) + (-0.040494922548532486);
    dt2_g0_19 = gelu_approx(dt2_n0_19);
    dt2_n0_20 = (((dt2_l0_20) - dt2_mean) / sqrt(dt2_var + ln_eps)) * (0.81684249639511108) + (-0.19029967486858368);
    dt2_g0_20 = gelu_approx(dt2_n0_20);
    dt2_n0_21 = (((dt2_l0_21) - dt2_mean) / sqrt(dt2_var + ln_eps)) * (0.78132253885269165) + (-0.19372616708278656);
    dt2_g0_21 = gelu_approx(dt2_n0_21);
    dt2_n0_22 = (((dt2_l0_22) - dt2_mean) / sqrt(dt2_var + ln_eps)) * (1.074562668800354) + (-0.079838313162326813);
    dt2_g0_22 = gelu_approx(dt2_n0_22);
    dt2_n0_23 = (((dt2_l0_23) - dt2_mean) / sqrt(dt2_var + ln_eps)) * (0.83421492576599121) + (-0.17514687776565552);
    dt2_g0_23 = gelu_approx(dt2_n0_23);
    dt2_n0_24 = (((dt2_l0_24) - dt2_mean) / sqrt(dt2_var + ln_eps)) * (1.1784040927886963) + (-0.0051487316377460957);
    dt2_g0_24 = gelu_approx(dt2_n0_24);
    dt2_n0_25 = (((dt2_l0_25) - dt2_mean) / sqrt(dt2_var + ln_eps)) * (0.83455449342727661) + (-0.13809368014335632);
    dt2_g0_25 = gelu_approx(dt2_n0_25);
    dt2_n0_26 = (((dt2_l0_26) - dt2_mean) / sqrt(dt2_var + ln_eps)) * (1.1395912170410156) + (-0.027733271941542625);
    dt2_g0_26 = gelu_approx(dt2_n0_26);
    dt2_n0_27 = (((dt2_l0_27) - dt2_mean) / sqrt(dt2_var + ln_eps)) * (0.98487979173660278) + (-0.08256356418132782);
    dt2_g0_27 = gelu_approx(dt2_n0_27);
    dt2_n0_28 = (((dt2_l0_28) - dt2_mean) / sqrt(dt2_var + ln_eps)) * (1.519499659538269) + (-0.030904548242688179);
    dt2_g0_28 = gelu_approx(dt2_n0_28);
    dt2_n0_29 = (((dt2_l0_29) - dt2_mean) / sqrt(dt2_var + ln_eps)) * (0.75068819522857666) + (-0.20771928131580353);
    dt2_g0_29 = gelu_approx(dt2_n0_29);
    dt2_n0_30 = (((dt2_l0_30) - dt2_mean) / sqrt(dt2_var + ln_eps)) * (0.88442128896713257) + (-0.090217843651771545);
    dt2_g0_30 = gelu_approx(dt2_n0_30);
    dt2_n0_31 = (((dt2_l0_31) - dt2_mean) / sqrt(dt2_var + ln_eps)) * (0.94935429096221924) + (-0.040492460131645203);
    dt2_g0_31 = gelu_approx(dt2_n0_31);
    dt2_l1_0 = -0.046900030225515366;
    dt2_l1_0 = dt2_l1_0 + (-0.16293072700500488)*dt2_g0_0;
    dt2_l1_0 = dt2_l1_0 + (-0.16474521160125732)*dt2_g0_1;
    dt2_l1_0 = dt2_l1_0 + (0.26976498961448669)*dt2_g0_2;
    dt2_l1_0 = dt2_l1_0 + (-0.091086529195308685)*dt2_g0_3;
    dt2_l1_0 = dt2_l1_0 + (0.039857111871242523)*dt2_g0_4;
    dt2_l1_0 = dt2_l1_0 + (-0.36768817901611328)*dt2_g0_5;
    dt2_l1_0 = dt2_l1_0 + (0.029776940122246742)*dt2_g0_6;
    dt2_l1_0 = dt2_l1_0 + (0.0019191652536392212)*dt2_g0_7;
    dt2_l1_0 = dt2_l1_0 + (0.22635605931282043)*dt2_g0_8;
    dt2_l1_0 = dt2_l1_0 + (0.0014309659600257874)*dt2_g0_9;
    dt2_l1_0 = dt2_l1_0 + (-0.18940156698226929)*dt2_g0_10;
    dt2_l1_0 = dt2_l1_0 + (0.001589158084243536)*dt2_g0_11;
    dt2_l1_0 = dt2_l1_0 + (-0.079506546258926392)*dt2_g0_12;
    dt2_l1_0 = dt2_l1_0 + (-0.1057610958814621)*dt2_g0_13;
    dt2_l1_0 = dt2_l1_0 + (0.073466688394546509)*dt2_g0_14;
    dt2_l1_0 = dt2_l1_0 + (0.071385860443115234)*dt2_g0_15;
    dt2_l1_0 = dt2_l1_0 + (-0.085049651563167572)*dt2_g0_16;
    dt2_l1_0 = dt2_l1_0 + (0.048108115792274475)*dt2_g0_17;
    dt2_l1_0 = dt2_l1_0 + (0.037839200347661972)*dt2_g0_18;
    dt2_l1_0 = dt2_l1_0 + (0.008063427172601223)*dt2_g0_19;
    dt2_l1_0 = dt2_l1_0 + (-0.035607509315013885)*dt2_g0_20;
    dt2_l1_0 = dt2_l1_0 + (-0.0510379858314991)*dt2_g0_21;
    dt2_l1_0 = dt2_l1_0 + (0.048532266169786453)*dt2_g0_22;
    dt2_l1_0 = dt2_l1_0 + (0.096789225935935974)*dt2_g0_23;
    dt2_l1_0 = dt2_l1_0 + (0.2037883996963501)*dt2_g0_24;
    dt2_l1_0 = dt2_l1_0 + (0.13214650750160217)*dt2_g0_25;
    dt2_l1_0 = dt2_l1_0 + (0.1620766818523407)*dt2_g0_26;
    dt2_l1_0 = dt2_l1_0 + (0.10560188442468643)*dt2_g0_27;
    dt2_l1_0 = dt2_l1_0 + (-0.38243672251701355)*dt2_g0_28;
    dt2_l1_0 = dt2_l1_0 + (0.036945246160030365)*dt2_g0_29;
    dt2_l1_0 = dt2_l1_0 + (0.017235111445188522)*dt2_g0_30;
    dt2_l1_0 = dt2_l1_0 + (-0.0079529397189617157)*dt2_g0_31;
    dt2_l1_1 = -0.1650557667016983;
    dt2_l1_1 = dt2_l1_1 + (-0.28834861516952515)*dt2_g0_0;
    dt2_l1_1 = dt2_l1_1 + (-0.25788521766662598)*dt2_g0_1;
    dt2_l1_1 = dt2_l1_1 + (0.15913346409797668)*dt2_g0_2;
    dt2_l1_1 = dt2_l1_1 + (0.027718981727957726)*dt2_g0_3;
    dt2_l1_1 = dt2_l1_1 + (0.10900557786226273)*dt2_g0_4;
    dt2_l1_1 = dt2_l1_1 + (0.11376988142728806)*dt2_g0_5;
    dt2_l1_1 = dt2_l1_1 + (0.19892121851444244)*dt2_g0_6;
    dt2_l1_1 = dt2_l1_1 + (0.089453563094139099)*dt2_g0_7;
    dt2_l1_1 = dt2_l1_1 + (0.14389055967330933)*dt2_g0_8;
    dt2_l1_1 = dt2_l1_1 + (-0.030847437679767609)*dt2_g0_9;
    dt2_l1_1 = dt2_l1_1 + (-0.047776956111192703)*dt2_g0_10;
    dt2_l1_1 = dt2_l1_1 + (0.040948741137981415)*dt2_g0_11;
    dt2_l1_1 = dt2_l1_1 + (0.023026715964078903)*dt2_g0_12;
    dt2_l1_1 = dt2_l1_1 + (-0.019706688821315765)*dt2_g0_13;
    dt2_l1_1 = dt2_l1_1 + (-0.096261724829673767)*dt2_g0_14;
    dt2_l1_1 = dt2_l1_1 + (-0.20225909352302551)*dt2_g0_15;
    dt2_l1_1 = dt2_l1_1 + (-0.13004162907600403)*dt2_g0_16;
    dt2_l1_1 = dt2_l1_1 + (0.066044040024280548)*dt2_g0_17;
    dt2_l1_1 = dt2_l1_1 + (0.15169130265712738)*dt2_g0_18;
    dt2_l1_1 = dt2_l1_1 + (-0.079691514372825623)*dt2_g0_19;
    dt2_l1_1 = dt2_l1_1 + (-0.15136595070362091)*dt2_g0_20;
    dt2_l1_1 = dt2_l1_1 + (-0.11996348202228546)*dt2_g0_21;
    dt2_l1_1 = dt2_l1_1 + (0.096818938851356506)*dt2_g0_22;
    dt2_l1_1 = dt2_l1_1 + (0.017230300232768059)*dt2_g0_23;
    dt2_l1_1 = dt2_l1_1 + (-0.23509146273136139)*dt2_g0_24;
    dt2_l1_1 = dt2_l1_1 + (-0.053033959120512009)*dt2_g0_25;
    dt2_l1_1 = dt2_l1_1 + (0.35057505965232849)*dt2_g0_26;
    dt2_l1_1 = dt2_l1_1 + (-0.11318153887987137)*dt2_g0_27;
    dt2_l1_1 = dt2_l1_1 + (0.25067627429962158)*dt2_g0_28;
    dt2_l1_1 = dt2_l1_1 + (0.060550738126039505)*dt2_g0_29;
    dt2_l1_1 = dt2_l1_1 + (-0.11033059656620026)*dt2_g0_30;
    dt2_l1_1 = dt2_l1_1 + (0.10683048516511917)*dt2_g0_31;
    dt2_l1_2 = 0.040588255971670151;
    dt2_l1_2 = dt2_l1_2 + (0.01313297264277935)*dt2_g0_0;
    dt2_l1_2 = dt2_l1_2 + (0.21187171339988708)*dt2_g0_1;
    dt2_l1_2 = dt2_l1_2 + (0.055051211267709732)*dt2_g0_2;
    dt2_l1_2 = dt2_l1_2 + (0.081240192055702209)*dt2_g0_3;
    dt2_l1_2 = dt2_l1_2 + (0.11177189648151398)*dt2_g0_4;
    dt2_l1_2 = dt2_l1_2 + (-0.023280186578631401)*dt2_g0_5;
    dt2_l1_2 = dt2_l1_2 + (0.10673881322145462)*dt2_g0_6;
    dt2_l1_2 = dt2_l1_2 + (0.0054689659737050533)*dt2_g0_7;
    dt2_l1_2 = dt2_l1_2 + (-0.190908282995224)*dt2_g0_8;
    dt2_l1_2 = dt2_l1_2 + (-0.13047152757644653)*dt2_g0_9;
    dt2_l1_2 = dt2_l1_2 + (0.10141438245773315)*dt2_g0_10;
    dt2_l1_2 = dt2_l1_2 + (0.12788000702857971)*dt2_g0_11;
    dt2_l1_2 = dt2_l1_2 + (-0.078461281955242157)*dt2_g0_12;
    dt2_l1_2 = dt2_l1_2 + (0.05843580886721611)*dt2_g0_13;
    dt2_l1_2 = dt2_l1_2 + (0.055245514959096909)*dt2_g0_14;
    dt2_l1_2 = dt2_l1_2 + (0.026272119954228401)*dt2_g0_15;
    dt2_l1_2 = dt2_l1_2 + (-0.31216931343078613)*dt2_g0_16;
    dt2_l1_2 = dt2_l1_2 + (0.1585162878036499)*dt2_g0_17;
    dt2_l1_2 = dt2_l1_2 + (-0.047532562166452408)*dt2_g0_18;
    dt2_l1_2 = dt2_l1_2 + (0.0034459442831575871)*dt2_g0_19;
    dt2_l1_2 = dt2_l1_2 + (-0.073009148240089417)*dt2_g0_20;
    dt2_l1_2 = dt2_l1_2 + (0.063850387930870056)*dt2_g0_21;
    dt2_l1_2 = dt2_l1_2 + (0.20695371925830841)*dt2_g0_22;
    dt2_l1_2 = dt2_l1_2 + (0.084927849471569061)*dt2_g0_23;
    dt2_l1_2 = dt2_l1_2 + (-0.17805205285549164)*dt2_g0_24;
    dt2_l1_2 = dt2_l1_2 + (0.043571438640356064)*dt2_g0_25;
    dt2_l1_2 = dt2_l1_2 + (-0.28430473804473877)*dt2_g0_26;
    dt2_l1_2 = dt2_l1_2 + (0.046519283205270767)*dt2_g0_27;
    dt2_l1_2 = dt2_l1_2 + (0.13506217300891876)*dt2_g0_28;
    dt2_l1_2 = dt2_l1_2 + (0.080001845955848694)*dt2_g0_29;
    dt2_l1_2 = dt2_l1_2 + (0.094780534505844116)*dt2_g0_30;
    dt2_l1_2 = dt2_l1_2 + (-0.14838580787181854)*dt2_g0_31;
    dt2_l1_3 = 0.03006674163043499;
    dt2_l1_3 = dt2_l1_3 + (-0.35364684462547302)*dt2_g0_0;
    dt2_l1_3 = dt2_l1_3 + (-0.17629177868366241)*dt2_g0_1;
    dt2_l1_3 = dt2_l1_3 + (0.022153474390506744)*dt2_g0_2;
    dt2_l1_3 = dt2_l1_3 + (0.18007884919643402)*dt2_g0_3;
    dt2_l1_3 = dt2_l1_3 + (0.10401297360658646)*dt2_g0_4;
    dt2_l1_3 = dt2_l1_3 + (0.051684357225894928)*dt2_g0_5;
    dt2_l1_3 = dt2_l1_3 + (-0.075068175792694092)*dt2_g0_6;
    dt2_l1_3 = dt2_l1_3 + (-0.059393569827079773)*dt2_g0_7;
    dt2_l1_3 = dt2_l1_3 + (0.15978445112705231)*dt2_g0_8;
    dt2_l1_3 = dt2_l1_3 + (-0.12649829685688019)*dt2_g0_9;
    dt2_l1_3 = dt2_l1_3 + (-0.262550950050354)*dt2_g0_10;
    dt2_l1_3 = dt2_l1_3 + (0.061393164098262787)*dt2_g0_11;
    dt2_l1_3 = dt2_l1_3 + (0.065222702920436859)*dt2_g0_12;
    dt2_l1_3 = dt2_l1_3 + (-0.062185466289520264)*dt2_g0_13;
    dt2_l1_3 = dt2_l1_3 + (-0.067431561648845673)*dt2_g0_14;
    dt2_l1_3 = dt2_l1_3 + (-0.19861984252929688)*dt2_g0_15;
    dt2_l1_3 = dt2_l1_3 + (0.64975041151046753)*dt2_g0_16;
    dt2_l1_3 = dt2_l1_3 + (-0.10373525321483612)*dt2_g0_17;
    dt2_l1_3 = dt2_l1_3 + (-0.051274355500936508)*dt2_g0_18;
    dt2_l1_3 = dt2_l1_3 + (0.1738811731338501)*dt2_g0_19;
    dt2_l1_3 = dt2_l1_3 + (-0.064860448241233826)*dt2_g0_20;
    dt2_l1_3 = dt2_l1_3 + (0.13006292283535004)*dt2_g0_21;
    dt2_l1_3 = dt2_l1_3 + (0.039197433739900589)*dt2_g0_22;
    dt2_l1_3 = dt2_l1_3 + (0.11295291036367416)*dt2_g0_23;
    dt2_l1_3 = dt2_l1_3 + (0.039528913795948029)*dt2_g0_24;
    dt2_l1_3 = dt2_l1_3 + (0.13462246954441071)*dt2_g0_25;
    dt2_l1_3 = dt2_l1_3 + (0.074103392660617828)*dt2_g0_26;
    dt2_l1_3 = dt2_l1_3 + (-0.0064598540775477886)*dt2_g0_27;
    dt2_l1_3 = dt2_l1_3 + (-0.24211853742599487)*dt2_g0_28;
    dt2_l1_3 = dt2_l1_3 + (0.093256272375583649)*dt2_g0_29;
    dt2_l1_3 = dt2_l1_3 + (-0.17873191833496094)*dt2_g0_30;
    dt2_l1_3 = dt2_l1_3 + (0.13665640354156494)*dt2_g0_31;
    dt2_l1_4 = 0.12263526022434235;
    dt2_l1_4 = dt2_l1_4 + (0.17370125651359558)*dt2_g0_0;
    dt2_l1_4 = dt2_l1_4 + (-0.083672083914279938)*dt2_g0_1;
    dt2_l1_4 = dt2_l1_4 + (-0.058013491332530975)*dt2_g0_2;
    dt2_l1_4 = dt2_l1_4 + (0.030379418283700943)*dt2_g0_3;
    dt2_l1_4 = dt2_l1_4 + (-0.03496987372636795)*dt2_g0_4;
    dt2_l1_4 = dt2_l1_4 + (-0.34480535984039307)*dt2_g0_5;
    dt2_l1_4 = dt2_l1_4 + (0.18003655970096588)*dt2_g0_6;
    dt2_l1_4 = dt2_l1_4 + (-0.012501563876867294)*dt2_g0_7;
    dt2_l1_4 = dt2_l1_4 + (0.10306855291128159)*dt2_g0_8;
    dt2_l1_4 = dt2_l1_4 + (0.0010572918690741062)*dt2_g0_9;
    dt2_l1_4 = dt2_l1_4 + (0.22152738273143768)*dt2_g0_10;
    dt2_l1_4 = dt2_l1_4 + (-0.046255137771368027)*dt2_g0_11;
    dt2_l1_4 = dt2_l1_4 + (0.078009523451328278)*dt2_g0_12;
    dt2_l1_4 = dt2_l1_4 + (0.066000305116176605)*dt2_g0_13;
    dt2_l1_4 = dt2_l1_4 + (-0.13832651078701019)*dt2_g0_14;
    dt2_l1_4 = dt2_l1_4 + (0.15796451270580292)*dt2_g0_15;
    dt2_l1_4 = dt2_l1_4 + (0.050529871135950089)*dt2_g0_16;
    dt2_l1_4 = dt2_l1_4 + (0.21294906735420227)*dt2_g0_17;
    dt2_l1_4 = dt2_l1_4 + (-0.12090930342674255)*dt2_g0_18;
    dt2_l1_4 = dt2_l1_4 + (-0.068031854927539825)*dt2_g0_19;
    dt2_l1_4 = dt2_l1_4 + (-0.10580087453126907)*dt2_g0_20;
    dt2_l1_4 = dt2_l1_4 + (-0.0046419226564466953)*dt2_g0_21;
    dt2_l1_4 = dt2_l1_4 + (-0.082880429923534393)*dt2_g0_22;
    dt2_l1_4 = dt2_l1_4 + (-0.032585814595222473)*dt2_g0_23;
    dt2_l1_4 = dt2_l1_4 + (-0.10039889067411423)*dt2_g0_24;
    dt2_l1_4 = dt2_l1_4 + (0.11109044402837753)*dt2_g0_25;
    dt2_l1_4 = dt2_l1_4 + (-0.080455757677555084)*dt2_g0_26;
    dt2_l1_4 = dt2_l1_4 + (0.0014013194013386965)*dt2_g0_27;
    dt2_l1_4 = dt2_l1_4 + (-0.15381021797657013)*dt2_g0_28;
    dt2_l1_4 = dt2_l1_4 + (0.05111057311296463)*dt2_g0_29;
    dt2_l1_4 = dt2_l1_4 + (0.076669268310070038)*dt2_g0_30;
    dt2_l1_4 = dt2_l1_4 + (-0.17469201982021332)*dt2_g0_31;
    dt2_l1_5 = -0.051718160510063171;
    dt2_l1_5 = dt2_l1_5 + (0.12622646987438202)*dt2_g0_0;
    dt2_l1_5 = dt2_l1_5 + (0.15407618880271912)*dt2_g0_1;
    dt2_l1_5 = dt2_l1_5 + (0.1102263480424881)*dt2_g0_2;
    dt2_l1_5 = dt2_l1_5 + (0.081044577062129974)*dt2_g0_3;
    dt2_l1_5 = dt2_l1_5 + (0.15326599776744843)*dt2_g0_4;
    dt2_l1_5 = dt2_l1_5 + (0.064281925559043884)*dt2_g0_5;
    dt2_l1_5 = dt2_l1_5 + (-0.21500757336616516)*dt2_g0_6;
    dt2_l1_5 = dt2_l1_5 + (0.098096363246440887)*dt2_g0_7;
    dt2_l1_5 = dt2_l1_5 + (-0.035208825021982193)*dt2_g0_8;
    dt2_l1_5 = dt2_l1_5 + (-0.029627483338117599)*dt2_g0_9;
    dt2_l1_5 = dt2_l1_5 + (0.23539173603057861)*dt2_g0_10;
    dt2_l1_5 = dt2_l1_5 + (-0.059684157371520996)*dt2_g0_11;
    dt2_l1_5 = dt2_l1_5 + (0.18764948844909668)*dt2_g0_12;
    dt2_l1_5 = dt2_l1_5 + (-0.10946971923112869)*dt2_g0_13;
    dt2_l1_5 = dt2_l1_5 + (-0.058492869138717651)*dt2_g0_14;
    dt2_l1_5 = dt2_l1_5 + (0.29810228943824768)*dt2_g0_15;
    dt2_l1_5 = dt2_l1_5 + (-0.25540083646774292)*dt2_g0_16;
    dt2_l1_5 = dt2_l1_5 + (-0.25962957739830017)*dt2_g0_17;
    dt2_l1_5 = dt2_l1_5 + (0.07244226336479187)*dt2_g0_18;
    dt2_l1_5 = dt2_l1_5 + (-0.015826232731342316)*dt2_g0_19;
    dt2_l1_5 = dt2_l1_5 + (-0.13939377665519714)*dt2_g0_20;
    dt2_l1_5 = dt2_l1_5 + (-0.034775912761688232)*dt2_g0_21;
    dt2_l1_5 = dt2_l1_5 + (-0.21197742223739624)*dt2_g0_22;
    dt2_l1_5 = dt2_l1_5 + (-0.10610435903072357)*dt2_g0_23;
    dt2_l1_5 = dt2_l1_5 + (0.053570564836263657)*dt2_g0_24;
    dt2_l1_5 = dt2_l1_5 + (0.040605675429105759)*dt2_g0_25;
    dt2_l1_5 = dt2_l1_5 + (0.023010404780507088)*dt2_g0_26;
    dt2_l1_5 = dt2_l1_5 + (0.12137638777494431)*dt2_g0_27;
    dt2_l1_5 = dt2_l1_5 + (0.23015812039375305)*dt2_g0_28;
    dt2_l1_5 = dt2_l1_5 + (0.06396755576133728)*dt2_g0_29;
    dt2_l1_5 = dt2_l1_5 + (-0.11600128561258316)*dt2_g0_30;
    dt2_l1_5 = dt2_l1_5 + (0.0018161108018830419)*dt2_g0_31;
    dt2_l1_6 = -0.14502783119678497;
    dt2_l1_6 = dt2_l1_6 + (-0.21617880463600159)*dt2_g0_0;
    dt2_l1_6 = dt2_l1_6 + (0.024907056242227554)*dt2_g0_1;
    dt2_l1_6 = dt2_l1_6 + (0.28527197241783142)*dt2_g0_2;
    dt2_l1_6 = dt2_l1_6 + (-0.10465603321790695)*dt2_g0_3;
    dt2_l1_6 = dt2_l1_6 + (0.004011248704046011)*dt2_g0_4;
    dt2_l1_6 = dt2_l1_6 + (0.11178028583526611)*dt2_g0_5;
    dt2_l1_6 = dt2_l1_6 + (0.13247388601303101)*dt2_g0_6;
    dt2_l1_6 = dt2_l1_6 + (0.17205116152763367)*dt2_g0_7;
    dt2_l1_6 = dt2_l1_6 + (0.017789272591471672)*dt2_g0_8;
    dt2_l1_6 = dt2_l1_6 + (0.0079919397830963135)*dt2_g0_9;
    dt2_l1_6 = dt2_l1_6 + (-0.17143863439559937)*dt2_g0_10;
    dt2_l1_6 = dt2_l1_6 + (-0.090974859893321991)*dt2_g0_11;
    dt2_l1_6 = dt2_l1_6 + (0.00026911767781712115)*dt2_g0_12;
    dt2_l1_6 = dt2_l1_6 + (0.12699028849601746)*dt2_g0_13;
    dt2_l1_6 = dt2_l1_6 + (0.012657118029892445)*dt2_g0_14;
    dt2_l1_6 = dt2_l1_6 + (0.014249536208808422)*dt2_g0_15;
    dt2_l1_6 = dt2_l1_6 + (0.29837688803672791)*dt2_g0_16;
    dt2_l1_6 = dt2_l1_6 + (0.10275484621524811)*dt2_g0_17;
    dt2_l1_6 = dt2_l1_6 + (-0.052840493619441986)*dt2_g0_18;
    dt2_l1_6 = dt2_l1_6 + (-0.064061515033245087)*dt2_g0_19;
    dt2_l1_6 = dt2_l1_6 + (0.084928445518016815)*dt2_g0_20;
    dt2_l1_6 = dt2_l1_6 + (-0.10871539264917374)*dt2_g0_21;
    dt2_l1_6 = dt2_l1_6 + (0.17323924601078033)*dt2_g0_22;
    dt2_l1_6 = dt2_l1_6 + (0.063852109014987946)*dt2_g0_23;
    dt2_l1_6 = dt2_l1_6 + (-0.054064754396677017)*dt2_g0_24;
    dt2_l1_6 = dt2_l1_6 + (-0.096406780183315277)*dt2_g0_25;
    dt2_l1_6 = dt2_l1_6 + (0.034694094210863113)*dt2_g0_26;
    dt2_l1_6 = dt2_l1_6 + (-0.040985178202390671)*dt2_g0_27;
    dt2_l1_6 = dt2_l1_6 + (-0.1414448469877243)*dt2_g0_28;
    dt2_l1_6 = dt2_l1_6 + (-0.18324244022369385)*dt2_g0_29;
    dt2_l1_6 = dt2_l1_6 + (-0.0061641675420105457)*dt2_g0_30;
    dt2_l1_6 = dt2_l1_6 + (0.14373365044593811)*dt2_g0_31;
    dt2_l1_7 = 0.15039798617362976;
    dt2_l1_7 = dt2_l1_7 + (0.047673169523477554)*dt2_g0_0;
    dt2_l1_7 = dt2_l1_7 + (0.072389706969261169)*dt2_g0_1;
    dt2_l1_7 = dt2_l1_7 + (-0.065495222806930542)*dt2_g0_2;
    dt2_l1_7 = dt2_l1_7 + (-0.037528026849031448)*dt2_g0_3;
    dt2_l1_7 = dt2_l1_7 + (-0.10889255255460739)*dt2_g0_4;
    dt2_l1_7 = dt2_l1_7 + (0.11605526506900787)*dt2_g0_5;
    dt2_l1_7 = dt2_l1_7 + (-0.026777036488056183)*dt2_g0_6;
    dt2_l1_7 = dt2_l1_7 + (-0.028399230912327766)*dt2_g0_7;
    dt2_l1_7 = dt2_l1_7 + (0.047372490167617798)*dt2_g0_8;
    dt2_l1_7 = dt2_l1_7 + (-0.012069370597600937)*dt2_g0_9;
    dt2_l1_7 = dt2_l1_7 + (-0.083184346556663513)*dt2_g0_10;
    dt2_l1_7 = dt2_l1_7 + (0.02154984325170517)*dt2_g0_11;
    dt2_l1_7 = dt2_l1_7 + (-0.040346946567296982)*dt2_g0_12;
    dt2_l1_7 = dt2_l1_7 + (-0.16211129724979401)*dt2_g0_13;
    dt2_l1_7 = dt2_l1_7 + (0.13870799541473389)*dt2_g0_14;
    dt2_l1_7 = dt2_l1_7 + (-0.19581884145736694)*dt2_g0_15;
    dt2_l1_7 = dt2_l1_7 + (-0.1117430180311203)*dt2_g0_16;
    dt2_l1_7 = dt2_l1_7 + (0.17394495010375977)*dt2_g0_17;
    dt2_l1_7 = dt2_l1_7 + (-0.00035679028951562941)*dt2_g0_18;
    dt2_l1_7 = dt2_l1_7 + (-0.048673704266548157)*dt2_g0_19;
    dt2_l1_7 = dt2_l1_7 + (0.15421126782894135)*dt2_g0_20;
    dt2_l1_7 = dt2_l1_7 + (0.13505768775939941)*dt2_g0_21;
    dt2_l1_7 = dt2_l1_7 + (0.036396581679582596)*dt2_g0_22;
    dt2_l1_7 = dt2_l1_7 + (0.0034029996022582054)*dt2_g0_23;
    dt2_l1_7 = dt2_l1_7 + (-0.24609997868537903)*dt2_g0_24;
    dt2_l1_7 = dt2_l1_7 + (0.15485222637653351)*dt2_g0_25;
    dt2_l1_7 = dt2_l1_7 + (-0.073318503797054291)*dt2_g0_26;
    dt2_l1_7 = dt2_l1_7 + (0.050975963473320007)*dt2_g0_27;
    dt2_l1_7 = dt2_l1_7 + (0.016177339479327202)*dt2_g0_28;
    dt2_l1_7 = dt2_l1_7 + (0.069688819348812103)*dt2_g0_29;
    dt2_l1_7 = dt2_l1_7 + (0.070944041013717651)*dt2_g0_30;
    dt2_l1_7 = dt2_l1_7 + (0.11156594753265381)*dt2_g0_31;
    dt2_l1_8 = 0.17791567742824554;
    dt2_l1_8 = dt2_l1_8 + (-0.071427121758460999)*dt2_g0_0;
    dt2_l1_8 = dt2_l1_8 + (-0.014428609050810337)*dt2_g0_1;
    dt2_l1_8 = dt2_l1_8 + (-0.1958298534154892)*dt2_g0_2;
    dt2_l1_8 = dt2_l1_8 + (-0.16039794683456421)*dt2_g0_3;
    dt2_l1_8 = dt2_l1_8 + (-0.13343974947929382)*dt2_g0_4;
    dt2_l1_8 = dt2_l1_8 + (0.26373711228370667)*dt2_g0_5;
    dt2_l1_8 = dt2_l1_8 + (0.017795341089367867)*dt2_g0_6;
    dt2_l1_8 = dt2_l1_8 + (-0.021144472062587738)*dt2_g0_7;
    dt2_l1_8 = dt2_l1_8 + (-0.23094122111797333)*dt2_g0_8;
    dt2_l1_8 = dt2_l1_8 + (0.073461614549160004)*dt2_g0_9;
    dt2_l1_8 = dt2_l1_8 + (0.11966696381568909)*dt2_g0_10;
    dt2_l1_8 = dt2_l1_8 + (0.17676906287670135)*dt2_g0_11;
    dt2_l1_8 = dt2_l1_8 + (-0.048930056393146515)*dt2_g0_12;
    dt2_l1_8 = dt2_l1_8 + (-0.14716175198554993)*dt2_g0_13;
    dt2_l1_8 = dt2_l1_8 + (0.11388258635997772)*dt2_g0_14;
    dt2_l1_8 = dt2_l1_8 + (0.082485564053058624)*dt2_g0_15;
    dt2_l1_8 = dt2_l1_8 + (0.46304497122764587)*dt2_g0_16;
    dt2_l1_8 = dt2_l1_8 + (0.00068784336326643825)*dt2_g0_17;
    dt2_l1_8 = dt2_l1_8 + (0.10457544773817062)*dt2_g0_18;
    dt2_l1_8 = dt2_l1_8 + (-0.0063994922675192356)*dt2_g0_19;
    dt2_l1_8 = dt2_l1_8 + (-0.14240989089012146)*dt2_g0_20;
    dt2_l1_8 = dt2_l1_8 + (-0.048434056341648102)*dt2_g0_21;
    dt2_l1_8 = dt2_l1_8 + (0.16329094767570496)*dt2_g0_22;
    dt2_l1_8 = dt2_l1_8 + (-0.080508217215538025)*dt2_g0_23;
    dt2_l1_8 = dt2_l1_8 + (0.18204766511917114)*dt2_g0_24;
    dt2_l1_8 = dt2_l1_8 + (-0.094055630266666412)*dt2_g0_25;
    dt2_l1_8 = dt2_l1_8 + (-0.12780973315238953)*dt2_g0_26;
    dt2_l1_8 = dt2_l1_8 + (-0.11680302768945694)*dt2_g0_27;
    dt2_l1_8 = dt2_l1_8 + (0.25664985179901123)*dt2_g0_28;
    dt2_l1_8 = dt2_l1_8 + (0.050704926252365112)*dt2_g0_29;
    dt2_l1_8 = dt2_l1_8 + (0.1178852841258049)*dt2_g0_30;
    dt2_l1_8 = dt2_l1_8 + (0.23110063374042511)*dt2_g0_31;
    dt2_l1_9 = -0.13868293166160583;
    dt2_l1_9 = dt2_l1_9 + (0.023834094405174255)*dt2_g0_0;
    dt2_l1_9 = dt2_l1_9 + (0.13403761386871338)*dt2_g0_1;
    dt2_l1_9 = dt2_l1_9 + (0.15153506398200989)*dt2_g0_2;
    dt2_l1_9 = dt2_l1_9 + (0.017937421798706055)*dt2_g0_3;
    dt2_l1_9 = dt2_l1_9 + (0.156947061419487)*dt2_g0_4;
    dt2_l1_9 = dt2_l1_9 + (-0.23003552854061127)*dt2_g0_5;
    dt2_l1_9 = dt2_l1_9 + (-0.11289767175912857)*dt2_g0_6;
    dt2_l1_9 = dt2_l1_9 + (0.049387767910957336)*dt2_g0_7;
    dt2_l1_9 = dt2_l1_9 + (0.21174226701259613)*dt2_g0_8;
    dt2_l1_9 = dt2_l1_9 + (0.18910692632198334)*dt2_g0_9;
    dt2_l1_9 = dt2_l1_9 + (0.10178250819444656)*dt2_g0_10;
    dt2_l1_9 = dt2_l1_9 + (-0.13315603137016296)*dt2_g0_11;
    dt2_l1_9 = dt2_l1_9 + (0.10240495204925537)*dt2_g0_12;
    dt2_l1_9 = dt2_l1_9 + (0.045188978314399719)*dt2_g0_13;
    dt2_l1_9 = dt2_l1_9 + (0.12674446403980255)*dt2_g0_14;
    dt2_l1_9 = dt2_l1_9 + (-0.018667533993721008)*dt2_g0_15;
    dt2_l1_9 = dt2_l1_9 + (0.054173573851585388)*dt2_g0_16;
    dt2_l1_9 = dt2_l1_9 + (-0.050129134207963943)*dt2_g0_17;
    dt2_l1_9 = dt2_l1_9 + (0.10595974326133728)*dt2_g0_18;
    dt2_l1_9 = dt2_l1_9 + (-0.029256910085678101)*dt2_g0_19;
    dt2_l1_9 = dt2_l1_9 + (-0.0041289492510259151)*dt2_g0_20;
    dt2_l1_9 = dt2_l1_9 + (0.067040741443634033)*dt2_g0_21;
    dt2_l1_9 = dt2_l1_9 + (0.28273269534111023)*dt2_g0_22;
    dt2_l1_9 = dt2_l1_9 + (-0.08960222452878952)*dt2_g0_23;
    dt2_l1_9 = dt2_l1_9 + (0.23507948219776154)*dt2_g0_24;
    dt2_l1_9 = dt2_l1_9 + (0.11662031710147858)*dt2_g0_25;
    dt2_l1_9 = dt2_l1_9 + (-0.1481965184211731)*dt2_g0_26;
    dt2_l1_9 = dt2_l1_9 + (0.068826325237751007)*dt2_g0_27;
    dt2_l1_9 = dt2_l1_9 + (-0.41048020124435425)*dt2_g0_28;
    dt2_l1_9 = dt2_l1_9 + (0.028586402535438538)*dt2_g0_29;
    dt2_l1_9 = dt2_l1_9 + (0.093711540102958679)*dt2_g0_30;
    dt2_l1_9 = dt2_l1_9 + (-0.16042201220989227)*dt2_g0_31;
    dt2_l1_10 = -0.078292421996593475;
    dt2_l1_10 = dt2_l1_10 + (0.38613796234130859)*dt2_g0_0;
    dt2_l1_10 = dt2_l1_10 + (0.16861145198345184)*dt2_g0_1;
    dt2_l1_10 = dt2_l1_10 + (-0.034250523895025253)*dt2_g0_2;
    dt2_l1_10 = dt2_l1_10 + (0.12220780551433563)*dt2_g0_3;
    dt2_l1_10 = dt2_l1_10 + (0.076330028474330902)*dt2_g0_4;
    dt2_l1_10 = dt2_l1_10 + (0.45561903715133667)*dt2_g0_5;
    dt2_l1_10 = dt2_l1_10 + (0.09523686021566391)*dt2_g0_6;
    dt2_l1_10 = dt2_l1_10 + (-0.031291704624891281)*dt2_g0_7;
    dt2_l1_10 = dt2_l1_10 + (-0.16195787489414215)*dt2_g0_8;
    dt2_l1_10 = dt2_l1_10 + (-0.12284358590841293)*dt2_g0_9;
    dt2_l1_10 = dt2_l1_10 + (0.19868870079517365)*dt2_g0_10;
    dt2_l1_10 = dt2_l1_10 + (-0.059839930385351181)*dt2_g0_11;
    dt2_l1_10 = dt2_l1_10 + (0.016507105901837349)*dt2_g0_12;
    dt2_l1_10 = dt2_l1_10 + (0.089055366814136505)*dt2_g0_13;
    dt2_l1_10 = dt2_l1_10 + (-0.073398031294345856)*dt2_g0_14;
    dt2_l1_10 = dt2_l1_10 + (0.12010634690523148)*dt2_g0_15;
    dt2_l1_10 = dt2_l1_10 + (-0.56620091199874878)*dt2_g0_16;
    dt2_l1_10 = dt2_l1_10 + (0.032096225768327713)*dt2_g0_17;
    dt2_l1_10 = dt2_l1_10 + (0.060803625732660294)*dt2_g0_18;
    dt2_l1_10 = dt2_l1_10 + (-0.1705658882856369)*dt2_g0_19;
    dt2_l1_10 = dt2_l1_10 + (-0.13755302131175995)*dt2_g0_20;
    dt2_l1_10 = dt2_l1_10 + (-0.087579868733882904)*dt2_g0_21;
    dt2_l1_10 = dt2_l1_10 + (-0.1278015673160553)*dt2_g0_22;
    dt2_l1_10 = dt2_l1_10 + (0.18843105435371399)*dt2_g0_23;
    dt2_l1_10 = dt2_l1_10 + (0.1520625501871109)*dt2_g0_24;
    dt2_l1_10 = dt2_l1_10 + (0.079296454787254333)*dt2_g0_25;
    dt2_l1_10 = dt2_l1_10 + (-0.24782979488372803)*dt2_g0_26;
    dt2_l1_10 = dt2_l1_10 + (-0.039584934711456299)*dt2_g0_27;
    dt2_l1_10 = dt2_l1_10 + (0.37787425518035889)*dt2_g0_28;
    dt2_l1_10 = dt2_l1_10 + (0.11145026236772537)*dt2_g0_29;
    dt2_l1_10 = dt2_l1_10 + (-0.16598974168300629)*dt2_g0_30;
    dt2_l1_10 = dt2_l1_10 + (0.0084111606702208519)*dt2_g0_31;
    dt2_l1_11 = -0.062137391418218613;
    dt2_l1_11 = dt2_l1_11 + (-0.17376498878002167)*dt2_g0_0;
    dt2_l1_11 = dt2_l1_11 + (0.096284717321395874)*dt2_g0_1;
    dt2_l1_11 = dt2_l1_11 + (-0.091086395084857941)*dt2_g0_2;
    dt2_l1_11 = dt2_l1_11 + (-0.098921611905097961)*dt2_g0_3;
    dt2_l1_11 = dt2_l1_11 + (-0.13950799405574799)*dt2_g0_4;
    dt2_l1_11 = dt2_l1_11 + (-0.21119497716426849)*dt2_g0_5;
    dt2_l1_11 = dt2_l1_11 + (-0.29174453020095825)*dt2_g0_6;
    dt2_l1_11 = dt2_l1_11 + (-0.041246883571147919)*dt2_g0_7;
    dt2_l1_11 = dt2_l1_11 + (-0.19079685211181641)*dt2_g0_8;
    dt2_l1_11 = dt2_l1_11 + (-0.063988305628299713)*dt2_g0_9;
    dt2_l1_11 = dt2_l1_11 + (0.19126258790493011)*dt2_g0_10;
    dt2_l1_11 = dt2_l1_11 + (-0.17825838923454285)*dt2_g0_11;
    dt2_l1_11 = dt2_l1_11 + (-0.15225179493427277)*dt2_g0_12;
    dt2_l1_11 = dt2_l1_11 + (-0.16363492608070374)*dt2_g0_13;
    dt2_l1_11 = dt2_l1_11 + (-0.10237506777048111)*dt2_g0_14;
    dt2_l1_11 = dt2_l1_11 + (0.18985816836357117)*dt2_g0_15;
    dt2_l1_11 = dt2_l1_11 + (0.11689111590385437)*dt2_g0_16;
    dt2_l1_11 = dt2_l1_11 + (-0.27802398800849915)*dt2_g0_17;
    dt2_l1_11 = dt2_l1_11 + (0.030934391543269157)*dt2_g0_18;
    dt2_l1_11 = dt2_l1_11 + (0.1008097305893898)*dt2_g0_19;
    dt2_l1_11 = dt2_l1_11 + (0.098364770412445068)*dt2_g0_20;
    dt2_l1_11 = dt2_l1_11 + (-0.010569779202342033)*dt2_g0_21;
    dt2_l1_11 = dt2_l1_11 + (0.0079128220677375793)*dt2_g0_22;
    dt2_l1_11 = dt2_l1_11 + (-0.079806827008724213)*dt2_g0_23;
    dt2_l1_11 = dt2_l1_11 + (0.27011299133300781)*dt2_g0_24;
    dt2_l1_11 = dt2_l1_11 + (0.070469021797180176)*dt2_g0_25;
    dt2_l1_11 = dt2_l1_11 + (-0.38286259770393372)*dt2_g0_26;
    dt2_l1_11 = dt2_l1_11 + (-0.14456358551979065)*dt2_g0_27;
    dt2_l1_11 = dt2_l1_11 + (-0.52179837226867676)*dt2_g0_28;
    dt2_l1_11 = dt2_l1_11 + (-0.073391132056713104)*dt2_g0_29;
    dt2_l1_11 = dt2_l1_11 + (0.10099390894174576)*dt2_g0_30;
    dt2_l1_11 = dt2_l1_11 + (-0.2381131649017334)*dt2_g0_31;
    dt2_l1_12 = -0.077903278172016144;
    dt2_l1_12 = dt2_l1_12 + (-0.024478539824485779)*dt2_g0_0;
    dt2_l1_12 = dt2_l1_12 + (0.15509465336799622)*dt2_g0_1;
    dt2_l1_12 = dt2_l1_12 + (0.021082784980535507)*dt2_g0_2;
    dt2_l1_12 = dt2_l1_12 + (-0.089185543358325958)*dt2_g0_3;
    dt2_l1_12 = dt2_l1_12 + (0.0031038988381624222)*dt2_g0_4;
    dt2_l1_12 = dt2_l1_12 + (0.10395709425210953)*dt2_g0_5;
    dt2_l1_12 = dt2_l1_12 + (-0.26505029201507568)*dt2_g0_6;
    dt2_l1_12 = dt2_l1_12 + (-0.10546328872442245)*dt2_g0_7;
    dt2_l1_12 = dt2_l1_12 + (-0.12884120643138885)*dt2_g0_8;
    dt2_l1_12 = dt2_l1_12 + (0.11630596220493317)*dt2_g0_9;
    dt2_l1_12 = dt2_l1_12 + (0.0063452315516769886)*dt2_g0_10;
    dt2_l1_12 = dt2_l1_12 + (-0.0063953367061913013)*dt2_g0_11;
    dt2_l1_12 = dt2_l1_12 + (-0.021227281540632248)*dt2_g0_12;
    dt2_l1_12 = dt2_l1_12 + (-0.10694406181573868)*dt2_g0_13;
    dt2_l1_12 = dt2_l1_12 + (-0.051671974360942841)*dt2_g0_14;
    dt2_l1_12 = dt2_l1_12 + (0.014918405562639236)*dt2_g0_15;
    dt2_l1_12 = dt2_l1_12 + (-0.33986765146255493)*dt2_g0_16;
    dt2_l1_12 = dt2_l1_12 + (0.024092648178339005)*dt2_g0_17;
    dt2_l1_12 = dt2_l1_12 + (0.090858824551105499)*dt2_g0_18;
    dt2_l1_12 = dt2_l1_12 + (0.19264908134937286)*dt2_g0_19;
    dt2_l1_12 = dt2_l1_12 + (-0.082039140164852142)*dt2_g0_20;
    dt2_l1_12 = dt2_l1_12 + (0.0058428267948329449)*dt2_g0_21;
    dt2_l1_12 = dt2_l1_12 + (0.25755473971366882)*dt2_g0_22;
    dt2_l1_12 = dt2_l1_12 + (0.048122107982635498)*dt2_g0_23;
    dt2_l1_12 = dt2_l1_12 + (-0.25055438280105591)*dt2_g0_24;
    dt2_l1_12 = dt2_l1_12 + (0.016316866502165794)*dt2_g0_25;
    dt2_l1_12 = dt2_l1_12 + (-0.081792674958705902)*dt2_g0_26;
    dt2_l1_12 = dt2_l1_12 + (-0.063519790768623352)*dt2_g0_27;
    dt2_l1_12 = dt2_l1_12 + (0.50614690780639648)*dt2_g0_28;
    dt2_l1_12 = dt2_l1_12 + (-0.066375598311424255)*dt2_g0_29;
    dt2_l1_12 = dt2_l1_12 + (0.090680874884128571)*dt2_g0_30;
    dt2_l1_12 = dt2_l1_12 + (-0.073922984302043915)*dt2_g0_31;
    dt2_l1_13 = -0.12205866724252701;
    dt2_l1_13 = dt2_l1_13 + (-0.25504162907600403)*dt2_g0_0;
    dt2_l1_13 = dt2_l1_13 + (-0.049930181354284286)*dt2_g0_1;
    dt2_l1_13 = dt2_l1_13 + (0.14232224225997925)*dt2_g0_2;
    dt2_l1_13 = dt2_l1_13 + (0.15969088673591614)*dt2_g0_3;
    dt2_l1_13 = dt2_l1_13 + (0.14399471879005432)*dt2_g0_4;
    dt2_l1_13 = dt2_l1_13 + (-0.058044787496328354)*dt2_g0_5;
    dt2_l1_13 = dt2_l1_13 + (0.11529924720525742)*dt2_g0_6;
    dt2_l1_13 = dt2_l1_13 + (0.039351854473352432)*dt2_g0_7;
    dt2_l1_13 = dt2_l1_13 + (0.12985527515411377)*dt2_g0_8;
    dt2_l1_13 = dt2_l1_13 + (-0.055830512195825577)*dt2_g0_9;
    dt2_l1_13 = dt2_l1_13 + (-0.11088638752698898)*dt2_g0_10;
    dt2_l1_13 = dt2_l1_13 + (-0.071301668882369995)*dt2_g0_11;
    dt2_l1_13 = dt2_l1_13 + (0.059834972023963928)*dt2_g0_12;
    dt2_l1_13 = dt2_l1_13 + (-0.026034511625766754)*dt2_g0_13;
    dt2_l1_13 = dt2_l1_13 + (0.18610493838787079)*dt2_g0_14;
    dt2_l1_13 = dt2_l1_13 + (-0.070099622011184692)*dt2_g0_15;
    dt2_l1_13 = dt2_l1_13 + (0.2838326096534729)*dt2_g0_16;
    dt2_l1_13 = dt2_l1_13 + (-0.037520397454500198)*dt2_g0_17;
    dt2_l1_13 = dt2_l1_13 + (0.13068065047264099)*dt2_g0_18;
    dt2_l1_13 = dt2_l1_13 + (0.066525585949420929)*dt2_g0_19;
    dt2_l1_13 = dt2_l1_13 + (-0.049645096063613892)*dt2_g0_20;
    dt2_l1_13 = dt2_l1_13 + (0.054189886897802353)*dt2_g0_21;
    dt2_l1_13 = dt2_l1_13 + (-0.17614948749542236)*dt2_g0_22;
    dt2_l1_13 = dt2_l1_13 + (0.0069473623298108578)*dt2_g0_23;
    dt2_l1_13 = dt2_l1_13 + (-0.071386918425559998)*dt2_g0_24;
    dt2_l1_13 = dt2_l1_13 + (-0.1061040461063385)*dt2_g0_25;
    dt2_l1_13 = dt2_l1_13 + (0.24330644309520721)*dt2_g0_26;
    dt2_l1_13 = dt2_l1_13 + (0.13288405537605286)*dt2_g0_27;
    dt2_l1_13 = dt2_l1_13 + (-0.095819815993309021)*dt2_g0_28;
    dt2_l1_13 = dt2_l1_13 + (0.1976703405380249)*dt2_g0_29;
    dt2_l1_13 = dt2_l1_13 + (-0.10413108766078949)*dt2_g0_30;
    dt2_l1_13 = dt2_l1_13 + (-0.066180601716041565)*dt2_g0_31;
    dt2_l1_14 = 0.10435187816619873;
    dt2_l1_14 = dt2_l1_14 + (0.066092170774936676)*dt2_g0_0;
    dt2_l1_14 = dt2_l1_14 + (-0.14066116511821747)*dt2_g0_1;
    dt2_l1_14 = dt2_l1_14 + (0.0070511805824935436)*dt2_g0_2;
    dt2_l1_14 = dt2_l1_14 + (0.016216622665524483)*dt2_g0_3;
    dt2_l1_14 = dt2_l1_14 + (-0.077155455946922302)*dt2_g0_4;
    dt2_l1_14 = dt2_l1_14 + (-0.0035024809185415506)*dt2_g0_5;
    dt2_l1_14 = dt2_l1_14 + (0.16614776849746704)*dt2_g0_6;
    dt2_l1_14 = dt2_l1_14 + (-0.097305327653884888)*dt2_g0_7;
    dt2_l1_14 = dt2_l1_14 + (0.049758661538362503)*dt2_g0_8;
    dt2_l1_14 = dt2_l1_14 + (-0.10961616039276123)*dt2_g0_9;
    dt2_l1_14 = dt2_l1_14 + (0.082717306911945343)*dt2_g0_10;
    dt2_l1_14 = dt2_l1_14 + (0.080690205097198486)*dt2_g0_11;
    dt2_l1_14 = dt2_l1_14 + (-0.019630759954452515)*dt2_g0_12;
    dt2_l1_14 = dt2_l1_14 + (-0.14077238738536835)*dt2_g0_13;
    dt2_l1_14 = dt2_l1_14 + (-0.14777269959449768)*dt2_g0_14;
    dt2_l1_14 = dt2_l1_14 + (0.1627192497253418)*dt2_g0_15;
    dt2_l1_14 = dt2_l1_14 + (-0.27055931091308594)*dt2_g0_16;
    dt2_l1_14 = dt2_l1_14 + (0.24675653874874115)*dt2_g0_17;
    dt2_l1_14 = dt2_l1_14 + (-0.13080167770385742)*dt2_g0_18;
    dt2_l1_14 = dt2_l1_14 + (-0.12526585161685944)*dt2_g0_19;
    dt2_l1_14 = dt2_l1_14 + (0.026029074564576149)*dt2_g0_20;
    dt2_l1_14 = dt2_l1_14 + (0.00069717544829472899)*dt2_g0_21;
    dt2_l1_14 = dt2_l1_14 + (-0.24566978216171265)*dt2_g0_22;
    dt2_l1_14 = dt2_l1_14 + (-0.03789505735039711)*dt2_g0_23;
    dt2_l1_14 = dt2_l1_14 + (0.031554587185382843)*dt2_g0_24;
    dt2_l1_14 = dt2_l1_14 + (-0.16307400166988373)*dt2_g0_25;
    dt2_l1_14 = dt2_l1_14 + (0.18186207115650177)*dt2_g0_26;
    dt2_l1_14 = dt2_l1_14 + (0.10117419809103012)*dt2_g0_27;
    dt2_l1_14 = dt2_l1_14 + (0.71069341897964478)*dt2_g0_28;
    dt2_l1_14 = dt2_l1_14 + (-0.094877868890762329)*dt2_g0_29;
    dt2_l1_14 = dt2_l1_14 + (-0.10863464325666428)*dt2_g0_30;
    dt2_l1_14 = dt2_l1_14 + (0.044603679329156876)*dt2_g0_31;
    dt2_l1_15 = 0.054931297898292542;
    dt2_l1_15 = dt2_l1_15 + (-0.12308650463819504)*dt2_g0_0;
    dt2_l1_15 = dt2_l1_15 + (0.10122453421354294)*dt2_g0_1;
    dt2_l1_15 = dt2_l1_15 + (-0.036758832633495331)*dt2_g0_2;
    dt2_l1_15 = dt2_l1_15 + (-0.055523984134197235)*dt2_g0_3;
    dt2_l1_15 = dt2_l1_15 + (0.024221815168857574)*dt2_g0_4;
    dt2_l1_15 = dt2_l1_15 + (0.36427092552185059)*dt2_g0_5;
    dt2_l1_15 = dt2_l1_15 + (0.013182561844587326)*dt2_g0_6;
    dt2_l1_15 = dt2_l1_15 + (-0.084676198661327362)*dt2_g0_7;
    dt2_l1_15 = dt2_l1_15 + (0.094983756542205811)*dt2_g0_8;
    dt2_l1_15 = dt2_l1_15 + (-0.044733546674251556)*dt2_g0_9;
    dt2_l1_15 = dt2_l1_15 + (-0.068374097347259521)*dt2_g0_10;
    dt2_l1_15 = dt2_l1_15 + (0.073864951729774475)*dt2_g0_11;
    dt2_l1_15 = dt2_l1_15 + (0.040122237056493759)*dt2_g0_12;
    dt2_l1_15 = dt2_l1_15 + (-0.11484098434448242)*dt2_g0_13;
    dt2_l1_15 = dt2_l1_15 + (0.029558604583144188)*dt2_g0_14;
    dt2_l1_15 = dt2_l1_15 + (-0.12961806356906891)*dt2_g0_15;
    dt2_l1_15 = dt2_l1_15 + (-0.68139654397964478)*dt2_g0_16;
    dt2_l1_15 = dt2_l1_15 + (-0.090533196926116943)*dt2_g0_17;
    dt2_l1_15 = dt2_l1_15 + (-0.055364329367876053)*dt2_g0_18;
    dt2_l1_15 = dt2_l1_15 + (-0.037381157279014587)*dt2_g0_19;
    dt2_l1_15 = dt2_l1_15 + (-0.013406396843492985)*dt2_g0_20;
    dt2_l1_15 = dt2_l1_15 + (0.067575834691524506)*dt2_g0_21;
    dt2_l1_15 = dt2_l1_15 + (-0.080908246338367462)*dt2_g0_22;
    dt2_l1_15 = dt2_l1_15 + (0.05767367035150528)*dt2_g0_23;
    dt2_l1_15 = dt2_l1_15 + (0.042280886322259903)*dt2_g0_24;
    dt2_l1_15 = dt2_l1_15 + (-0.18634659051895142)*dt2_g0_25;
    dt2_l1_15 = dt2_l1_15 + (0.31346985697746277)*dt2_g0_26;
    dt2_l1_15 = dt2_l1_15 + (0.038848195225000381)*dt2_g0_27;
    dt2_l1_15 = dt2_l1_15 + (0.23577156662940979)*dt2_g0_28;
    dt2_l1_15 = dt2_l1_15 + (-0.014047614298760891)*dt2_g0_29;
    dt2_l1_15 = dt2_l1_15 + (0.096515163779258728)*dt2_g0_30;
    dt2_l1_15 = dt2_l1_15 + (-0.062498938292264938)*dt2_g0_31;
    // Device tower token 3
    dt3_l0_0 = (-0.061654173989431904) + (0.34432113170623779)*meff_scaled;
    dt3_l0_1 = (0.020702285551950528) + (0.47822898626327515)*meff_scaled;
    dt3_l0_2 = (-0.21026292055868567) + (0.24066966772079468)*meff_scaled;
    dt3_l0_3 = (0.97251600280961714) + (0.048484642058610916)*meff_scaled;
    dt3_l0_4 = (0.23854195141496648) + (0.13176910579204559)*meff_scaled;
    dt3_l0_5 = (-0.32797947458782373) + (-0.30407708883285522)*meff_scaled;
    dt3_l0_6 = (-0.50486251993556763) + (-0.11684082448482513)*meff_scaled;
    dt3_l0_7 = (0.64567813549152075) + (0.040982868522405624)*meff_scaled;
    dt3_l0_8 = (-0.091917923665936541) + (0.61334097385406494)*meff_scaled;
    dt3_l0_9 = (-1.2110904198916346) + (0.14561383426189423)*meff_scaled;
    dt3_l0_10 = (-0.97592718207131657) + (0.45312285423278809)*meff_scaled;
    dt3_l0_11 = (-0.11050254428775186) + (-0.057421129196882248)*meff_scaled;
    dt3_l0_12 = (0.9910957180000215) + (0.076745271682739258)*meff_scaled;
    dt3_l0_13 = (1.2123826164835898) + (0.11903565376996994)*meff_scaled;
    dt3_l0_14 = (1.6326540312202247) + (0.049182634800672531)*meff_scaled;
    dt3_l0_15 = (-2.5861388604395872) + (0.39639326930046082)*meff_scaled;
    dt3_l0_16 = (0.012037686202450326) + (-0.5463671088218689)*meff_scaled;
    dt3_l0_17 = (0.35470078365188451) + (-0.34476840496063232)*meff_scaled;
    dt3_l0_18 = (1.6138125762967372) + (0.042969517409801483)*meff_scaled;
    dt3_l0_19 = (0.1226716232199993) + (-0.30303272604942322)*meff_scaled;
    dt3_l0_20 = (0.65275857242211188) + (0.073118828237056732)*meff_scaled;
    dt3_l0_21 = (1.0127001457631024) + (0.060475107282400131)*meff_scaled;
    dt3_l0_22 = (-0.27022060373560031) + (0.23183275759220123)*meff_scaled;
    dt3_l0_23 = (0.62280627547580825) + (0.0091169727966189384)*meff_scaled;
    dt3_l0_24 = (-0.25747194289427144) + (-0.022656848654150963)*meff_scaled;
    dt3_l0_25 = (0.38493311608245162) + (0.13182426989078522)*meff_scaled;
    dt3_l0_26 = (0.13753589106613712) + (-0.41274189949035645)*meff_scaled;
    dt3_l0_27 = (0.35358184472884358) + (0.14568156003952026)*meff_scaled;
    dt3_l0_28 = (-0.14388540254933879) + (-0.67684346437454224)*meff_scaled;
    dt3_l0_29 = (0.89530721258903578) + (0.01818244531750679)*meff_scaled;
    dt3_l0_30 = (0.012597157051310925) + (0.22900021076202393)*meff_scaled;
    dt3_l0_31 = (-0.5371486635816044) + (-0.24716407060623169)*meff_scaled;
    dt3_mean = (dt3_l0_0 + dt3_l0_1 + dt3_l0_2 + dt3_l0_3 + dt3_l0_4 + dt3_l0_5 + dt3_l0_6 + dt3_l0_7 + dt3_l0_8 + dt3_l0_9 + dt3_l0_10 + dt3_l0_11 + dt3_l0_12 + dt3_l0_13 + dt3_l0_14 + dt3_l0_15 + dt3_l0_16 + dt3_l0_17 + dt3_l0_18 + dt3_l0_19 + dt3_l0_20 + dt3_l0_21 + dt3_l0_22 + dt3_l0_23 + dt3_l0_24 + dt3_l0_25 + dt3_l0_26 + dt3_l0_27 + dt3_l0_28 + dt3_l0_29 + dt3_l0_30 + dt3_l0_31) / 32;
    dt3_var = (((dt3_l0_0) - dt3_mean)*((dt3_l0_0) - dt3_mean) + ((dt3_l0_1) - dt3_mean)*((dt3_l0_1) - dt3_mean) + ((dt3_l0_2) - dt3_mean)*((dt3_l0_2) - dt3_mean) + ((dt3_l0_3) - dt3_mean)*((dt3_l0_3) - dt3_mean) + ((dt3_l0_4) - dt3_mean)*((dt3_l0_4) - dt3_mean) + ((dt3_l0_5) - dt3_mean)*((dt3_l0_5) - dt3_mean) + ((dt3_l0_6) - dt3_mean)*((dt3_l0_6) - dt3_mean) + ((dt3_l0_7) - dt3_mean)*((dt3_l0_7) - dt3_mean) + ((dt3_l0_8) - dt3_mean)*((dt3_l0_8) - dt3_mean) + ((dt3_l0_9) - dt3_mean)*((dt3_l0_9) - dt3_mean) + ((dt3_l0_10) - dt3_mean)*((dt3_l0_10) - dt3_mean) + ((dt3_l0_11) - dt3_mean)*((dt3_l0_11) - dt3_mean) + ((dt3_l0_12) - dt3_mean)*((dt3_l0_12) - dt3_mean) + ((dt3_l0_13) - dt3_mean)*((dt3_l0_13) - dt3_mean) + ((dt3_l0_14) - dt3_mean)*((dt3_l0_14) - dt3_mean) + ((dt3_l0_15) - dt3_mean)*((dt3_l0_15) - dt3_mean) + ((dt3_l0_16) - dt3_mean)*((dt3_l0_16) - dt3_mean) + ((dt3_l0_17) - dt3_mean)*((dt3_l0_17) - dt3_mean) + ((dt3_l0_18) - dt3_mean)*((dt3_l0_18) - dt3_mean) + ((dt3_l0_19) - dt3_mean)*((dt3_l0_19) - dt3_mean) + ((dt3_l0_20) - dt3_mean)*((dt3_l0_20) - dt3_mean) + ((dt3_l0_21) - dt3_mean)*((dt3_l0_21) - dt3_mean) + ((dt3_l0_22) - dt3_mean)*((dt3_l0_22) - dt3_mean) + ((dt3_l0_23) - dt3_mean)*((dt3_l0_23) - dt3_mean) + ((dt3_l0_24) - dt3_mean)*((dt3_l0_24) - dt3_mean) + ((dt3_l0_25) - dt3_mean)*((dt3_l0_25) - dt3_mean) + ((dt3_l0_26) - dt3_mean)*((dt3_l0_26) - dt3_mean) + ((dt3_l0_27) - dt3_mean)*((dt3_l0_27) - dt3_mean) + ((dt3_l0_28) - dt3_mean)*((dt3_l0_28) - dt3_mean) + ((dt3_l0_29) - dt3_mean)*((dt3_l0_29) - dt3_mean) + ((dt3_l0_30) - dt3_mean)*((dt3_l0_30) - dt3_mean) + ((dt3_l0_31) - dt3_mean)*((dt3_l0_31) - dt3_mean)) / 32;
    dt3_n0_0 = (((dt3_l0_0) - dt3_mean) / sqrt(dt3_var + ln_eps)) * (1.1696591377258301) + (-0.11109431833028793);
    dt3_g0_0 = gelu_approx(dt3_n0_0);
    dt3_n0_1 = (((dt3_l0_1) - dt3_mean) / sqrt(dt3_var + ln_eps)) * (1.1050513982772827) + (-0.035068709403276443);
    dt3_g0_1 = gelu_approx(dt3_n0_1);
    dt3_n0_2 = (((dt3_l0_2) - dt3_mean) / sqrt(dt3_var + ln_eps)) * (1.04068922996521) + (-0.089032895863056183);
    dt3_g0_2 = gelu_approx(dt3_n0_2);
    dt3_n0_3 = (((dt3_l0_3) - dt3_mean) / sqrt(dt3_var + ln_eps)) * (0.67314571142196655) + (-0.25178694725036621);
    dt3_g0_3 = gelu_approx(dt3_n0_3);
    dt3_n0_4 = (((dt3_l0_4) - dt3_mean) / sqrt(dt3_var + ln_eps)) * (0.85388195514678955) + (-0.12780840694904327);
    dt3_g0_4 = gelu_approx(dt3_n0_4);
    dt3_n0_5 = (((dt3_l0_5) - dt3_mean) / sqrt(dt3_var + ln_eps)) * (1.2238403558731079) + (-0.017596408724784851);
    dt3_g0_5 = gelu_approx(dt3_n0_5);
    dt3_n0_6 = (((dt3_l0_6) - dt3_mean) / sqrt(dt3_var + ln_eps)) * (0.98674929141998291) + (-0.047802694141864777);
    dt3_g0_6 = gelu_approx(dt3_n0_6);
    dt3_n0_7 = (((dt3_l0_7) - dt3_mean) / sqrt(dt3_var + ln_eps)) * (0.73881924152374268) + (-0.26099607348442078);
    dt3_g0_7 = gelu_approx(dt3_n0_7);
    dt3_n0_8 = (((dt3_l0_8) - dt3_mean) / sqrt(dt3_var + ln_eps)) * (1.0608246326446533) + (-0.078888535499572754);
    dt3_g0_8 = gelu_approx(dt3_n0_8);
    dt3_n0_9 = (((dt3_l0_9) - dt3_mean) / sqrt(dt3_var + ln_eps)) * (0.785602867603302) + (-0.15794672071933746);
    dt3_g0_9 = gelu_approx(dt3_n0_9);
    dt3_n0_10 = (((dt3_l0_10) - dt3_mean) / sqrt(dt3_var + ln_eps)) * (1.020018458366394) + (-0.036895915865898132);
    dt3_g0_10 = gelu_approx(dt3_n0_10);
    dt3_n0_11 = (((dt3_l0_11) - dt3_mean) / sqrt(dt3_var + ln_eps)) * (0.85727518796920776) + (-0.12107124924659729);
    dt3_g0_11 = gelu_approx(dt3_n0_11);
    dt3_n0_12 = (((dt3_l0_12) - dt3_mean) / sqrt(dt3_var + ln_eps)) * (0.72308427095413208) + (-0.25479298830032349);
    dt3_g0_12 = gelu_approx(dt3_n0_12);
    dt3_n0_13 = (((dt3_l0_13) - dt3_mean) / sqrt(dt3_var + ln_eps)) * (0.86266148090362549) + (-0.14110274612903595);
    dt3_g0_13 = gelu_approx(dt3_n0_13);
    dt3_n0_14 = (((dt3_l0_14) - dt3_mean) / sqrt(dt3_var + ln_eps)) * (0.74258971214294434) + (-0.25694161653518677);
    dt3_g0_14 = gelu_approx(dt3_n0_14);
    dt3_n0_15 = (((dt3_l0_15) - dt3_mean) / sqrt(dt3_var + ln_eps)) * (1.0297513008117676) + (-0.048506777733564377);
    dt3_g0_15 = gelu_approx(dt3_n0_15);
    dt3_n0_16 = (((dt3_l0_16) - dt3_mean) / sqrt(dt3_var + ln_eps)) * (1.6998714208602905) + (0.031608574092388153);
    dt3_g0_16 = gelu_approx(dt3_n0_16);
    dt3_n0_17 = (((dt3_l0_17) - dt3_mean) / sqrt(dt3_var + ln_eps)) * (1.0622228384017944) + (-0.10873574018478394);
    dt3_g0_17 = gelu_approx(dt3_n0_17);
    dt3_n0_18 = (((dt3_l0_18) - dt3_mean) / sqrt(dt3_var + ln_eps)) * (0.84898489713668823) + (-0.16742095351219177);
    dt3_g0_18 = gelu_approx(dt3_n0_18);
    dt3_n0_19 = (((dt3_l0_19) - dt3_mean) / sqrt(dt3_var + ln_eps)) * (1.0004963874816895) + (-0.040494922548532486);
    dt3_g0_19 = gelu_approx(dt3_n0_19);
    dt3_n0_20 = (((dt3_l0_20) - dt3_mean) / sqrt(dt3_var + ln_eps)) * (0.81684249639511108) + (-0.19029967486858368);
    dt3_g0_20 = gelu_approx(dt3_n0_20);
    dt3_n0_21 = (((dt3_l0_21) - dt3_mean) / sqrt(dt3_var + ln_eps)) * (0.78132253885269165) + (-0.19372616708278656);
    dt3_g0_21 = gelu_approx(dt3_n0_21);
    dt3_n0_22 = (((dt3_l0_22) - dt3_mean) / sqrt(dt3_var + ln_eps)) * (1.074562668800354) + (-0.079838313162326813);
    dt3_g0_22 = gelu_approx(dt3_n0_22);
    dt3_n0_23 = (((dt3_l0_23) - dt3_mean) / sqrt(dt3_var + ln_eps)) * (0.83421492576599121) + (-0.17514687776565552);
    dt3_g0_23 = gelu_approx(dt3_n0_23);
    dt3_n0_24 = (((dt3_l0_24) - dt3_mean) / sqrt(dt3_var + ln_eps)) * (1.1784040927886963) + (-0.0051487316377460957);
    dt3_g0_24 = gelu_approx(dt3_n0_24);
    dt3_n0_25 = (((dt3_l0_25) - dt3_mean) / sqrt(dt3_var + ln_eps)) * (0.83455449342727661) + (-0.13809368014335632);
    dt3_g0_25 = gelu_approx(dt3_n0_25);
    dt3_n0_26 = (((dt3_l0_26) - dt3_mean) / sqrt(dt3_var + ln_eps)) * (1.1395912170410156) + (-0.027733271941542625);
    dt3_g0_26 = gelu_approx(dt3_n0_26);
    dt3_n0_27 = (((dt3_l0_27) - dt3_mean) / sqrt(dt3_var + ln_eps)) * (0.98487979173660278) + (-0.08256356418132782);
    dt3_g0_27 = gelu_approx(dt3_n0_27);
    dt3_n0_28 = (((dt3_l0_28) - dt3_mean) / sqrt(dt3_var + ln_eps)) * (1.519499659538269) + (-0.030904548242688179);
    dt3_g0_28 = gelu_approx(dt3_n0_28);
    dt3_n0_29 = (((dt3_l0_29) - dt3_mean) / sqrt(dt3_var + ln_eps)) * (0.75068819522857666) + (-0.20771928131580353);
    dt3_g0_29 = gelu_approx(dt3_n0_29);
    dt3_n0_30 = (((dt3_l0_30) - dt3_mean) / sqrt(dt3_var + ln_eps)) * (0.88442128896713257) + (-0.090217843651771545);
    dt3_g0_30 = gelu_approx(dt3_n0_30);
    dt3_n0_31 = (((dt3_l0_31) - dt3_mean) / sqrt(dt3_var + ln_eps)) * (0.94935429096221924) + (-0.040492460131645203);
    dt3_g0_31 = gelu_approx(dt3_n0_31);
    dt3_l1_0 = -0.046900030225515366;
    dt3_l1_0 = dt3_l1_0 + (-0.16293072700500488)*dt3_g0_0;
    dt3_l1_0 = dt3_l1_0 + (-0.16474521160125732)*dt3_g0_1;
    dt3_l1_0 = dt3_l1_0 + (0.26976498961448669)*dt3_g0_2;
    dt3_l1_0 = dt3_l1_0 + (-0.091086529195308685)*dt3_g0_3;
    dt3_l1_0 = dt3_l1_0 + (0.039857111871242523)*dt3_g0_4;
    dt3_l1_0 = dt3_l1_0 + (-0.36768817901611328)*dt3_g0_5;
    dt3_l1_0 = dt3_l1_0 + (0.029776940122246742)*dt3_g0_6;
    dt3_l1_0 = dt3_l1_0 + (0.0019191652536392212)*dt3_g0_7;
    dt3_l1_0 = dt3_l1_0 + (0.22635605931282043)*dt3_g0_8;
    dt3_l1_0 = dt3_l1_0 + (0.0014309659600257874)*dt3_g0_9;
    dt3_l1_0 = dt3_l1_0 + (-0.18940156698226929)*dt3_g0_10;
    dt3_l1_0 = dt3_l1_0 + (0.001589158084243536)*dt3_g0_11;
    dt3_l1_0 = dt3_l1_0 + (-0.079506546258926392)*dt3_g0_12;
    dt3_l1_0 = dt3_l1_0 + (-0.1057610958814621)*dt3_g0_13;
    dt3_l1_0 = dt3_l1_0 + (0.073466688394546509)*dt3_g0_14;
    dt3_l1_0 = dt3_l1_0 + (0.071385860443115234)*dt3_g0_15;
    dt3_l1_0 = dt3_l1_0 + (-0.085049651563167572)*dt3_g0_16;
    dt3_l1_0 = dt3_l1_0 + (0.048108115792274475)*dt3_g0_17;
    dt3_l1_0 = dt3_l1_0 + (0.037839200347661972)*dt3_g0_18;
    dt3_l1_0 = dt3_l1_0 + (0.008063427172601223)*dt3_g0_19;
    dt3_l1_0 = dt3_l1_0 + (-0.035607509315013885)*dt3_g0_20;
    dt3_l1_0 = dt3_l1_0 + (-0.0510379858314991)*dt3_g0_21;
    dt3_l1_0 = dt3_l1_0 + (0.048532266169786453)*dt3_g0_22;
    dt3_l1_0 = dt3_l1_0 + (0.096789225935935974)*dt3_g0_23;
    dt3_l1_0 = dt3_l1_0 + (0.2037883996963501)*dt3_g0_24;
    dt3_l1_0 = dt3_l1_0 + (0.13214650750160217)*dt3_g0_25;
    dt3_l1_0 = dt3_l1_0 + (0.1620766818523407)*dt3_g0_26;
    dt3_l1_0 = dt3_l1_0 + (0.10560188442468643)*dt3_g0_27;
    dt3_l1_0 = dt3_l1_0 + (-0.38243672251701355)*dt3_g0_28;
    dt3_l1_0 = dt3_l1_0 + (0.036945246160030365)*dt3_g0_29;
    dt3_l1_0 = dt3_l1_0 + (0.017235111445188522)*dt3_g0_30;
    dt3_l1_0 = dt3_l1_0 + (-0.0079529397189617157)*dt3_g0_31;
    dt3_l1_1 = -0.1650557667016983;
    dt3_l1_1 = dt3_l1_1 + (-0.28834861516952515)*dt3_g0_0;
    dt3_l1_1 = dt3_l1_1 + (-0.25788521766662598)*dt3_g0_1;
    dt3_l1_1 = dt3_l1_1 + (0.15913346409797668)*dt3_g0_2;
    dt3_l1_1 = dt3_l1_1 + (0.027718981727957726)*dt3_g0_3;
    dt3_l1_1 = dt3_l1_1 + (0.10900557786226273)*dt3_g0_4;
    dt3_l1_1 = dt3_l1_1 + (0.11376988142728806)*dt3_g0_5;
    dt3_l1_1 = dt3_l1_1 + (0.19892121851444244)*dt3_g0_6;
    dt3_l1_1 = dt3_l1_1 + (0.089453563094139099)*dt3_g0_7;
    dt3_l1_1 = dt3_l1_1 + (0.14389055967330933)*dt3_g0_8;
    dt3_l1_1 = dt3_l1_1 + (-0.030847437679767609)*dt3_g0_9;
    dt3_l1_1 = dt3_l1_1 + (-0.047776956111192703)*dt3_g0_10;
    dt3_l1_1 = dt3_l1_1 + (0.040948741137981415)*dt3_g0_11;
    dt3_l1_1 = dt3_l1_1 + (0.023026715964078903)*dt3_g0_12;
    dt3_l1_1 = dt3_l1_1 + (-0.019706688821315765)*dt3_g0_13;
    dt3_l1_1 = dt3_l1_1 + (-0.096261724829673767)*dt3_g0_14;
    dt3_l1_1 = dt3_l1_1 + (-0.20225909352302551)*dt3_g0_15;
    dt3_l1_1 = dt3_l1_1 + (-0.13004162907600403)*dt3_g0_16;
    dt3_l1_1 = dt3_l1_1 + (0.066044040024280548)*dt3_g0_17;
    dt3_l1_1 = dt3_l1_1 + (0.15169130265712738)*dt3_g0_18;
    dt3_l1_1 = dt3_l1_1 + (-0.079691514372825623)*dt3_g0_19;
    dt3_l1_1 = dt3_l1_1 + (-0.15136595070362091)*dt3_g0_20;
    dt3_l1_1 = dt3_l1_1 + (-0.11996348202228546)*dt3_g0_21;
    dt3_l1_1 = dt3_l1_1 + (0.096818938851356506)*dt3_g0_22;
    dt3_l1_1 = dt3_l1_1 + (0.017230300232768059)*dt3_g0_23;
    dt3_l1_1 = dt3_l1_1 + (-0.23509146273136139)*dt3_g0_24;
    dt3_l1_1 = dt3_l1_1 + (-0.053033959120512009)*dt3_g0_25;
    dt3_l1_1 = dt3_l1_1 + (0.35057505965232849)*dt3_g0_26;
    dt3_l1_1 = dt3_l1_1 + (-0.11318153887987137)*dt3_g0_27;
    dt3_l1_1 = dt3_l1_1 + (0.25067627429962158)*dt3_g0_28;
    dt3_l1_1 = dt3_l1_1 + (0.060550738126039505)*dt3_g0_29;
    dt3_l1_1 = dt3_l1_1 + (-0.11033059656620026)*dt3_g0_30;
    dt3_l1_1 = dt3_l1_1 + (0.10683048516511917)*dt3_g0_31;
    dt3_l1_2 = 0.040588255971670151;
    dt3_l1_2 = dt3_l1_2 + (0.01313297264277935)*dt3_g0_0;
    dt3_l1_2 = dt3_l1_2 + (0.21187171339988708)*dt3_g0_1;
    dt3_l1_2 = dt3_l1_2 + (0.055051211267709732)*dt3_g0_2;
    dt3_l1_2 = dt3_l1_2 + (0.081240192055702209)*dt3_g0_3;
    dt3_l1_2 = dt3_l1_2 + (0.11177189648151398)*dt3_g0_4;
    dt3_l1_2 = dt3_l1_2 + (-0.023280186578631401)*dt3_g0_5;
    dt3_l1_2 = dt3_l1_2 + (0.10673881322145462)*dt3_g0_6;
    dt3_l1_2 = dt3_l1_2 + (0.0054689659737050533)*dt3_g0_7;
    dt3_l1_2 = dt3_l1_2 + (-0.190908282995224)*dt3_g0_8;
    dt3_l1_2 = dt3_l1_2 + (-0.13047152757644653)*dt3_g0_9;
    dt3_l1_2 = dt3_l1_2 + (0.10141438245773315)*dt3_g0_10;
    dt3_l1_2 = dt3_l1_2 + (0.12788000702857971)*dt3_g0_11;
    dt3_l1_2 = dt3_l1_2 + (-0.078461281955242157)*dt3_g0_12;
    dt3_l1_2 = dt3_l1_2 + (0.05843580886721611)*dt3_g0_13;
    dt3_l1_2 = dt3_l1_2 + (0.055245514959096909)*dt3_g0_14;
    dt3_l1_2 = dt3_l1_2 + (0.026272119954228401)*dt3_g0_15;
    dt3_l1_2 = dt3_l1_2 + (-0.31216931343078613)*dt3_g0_16;
    dt3_l1_2 = dt3_l1_2 + (0.1585162878036499)*dt3_g0_17;
    dt3_l1_2 = dt3_l1_2 + (-0.047532562166452408)*dt3_g0_18;
    dt3_l1_2 = dt3_l1_2 + (0.0034459442831575871)*dt3_g0_19;
    dt3_l1_2 = dt3_l1_2 + (-0.073009148240089417)*dt3_g0_20;
    dt3_l1_2 = dt3_l1_2 + (0.063850387930870056)*dt3_g0_21;
    dt3_l1_2 = dt3_l1_2 + (0.20695371925830841)*dt3_g0_22;
    dt3_l1_2 = dt3_l1_2 + (0.084927849471569061)*dt3_g0_23;
    dt3_l1_2 = dt3_l1_2 + (-0.17805205285549164)*dt3_g0_24;
    dt3_l1_2 = dt3_l1_2 + (0.043571438640356064)*dt3_g0_25;
    dt3_l1_2 = dt3_l1_2 + (-0.28430473804473877)*dt3_g0_26;
    dt3_l1_2 = dt3_l1_2 + (0.046519283205270767)*dt3_g0_27;
    dt3_l1_2 = dt3_l1_2 + (0.13506217300891876)*dt3_g0_28;
    dt3_l1_2 = dt3_l1_2 + (0.080001845955848694)*dt3_g0_29;
    dt3_l1_2 = dt3_l1_2 + (0.094780534505844116)*dt3_g0_30;
    dt3_l1_2 = dt3_l1_2 + (-0.14838580787181854)*dt3_g0_31;
    dt3_l1_3 = 0.03006674163043499;
    dt3_l1_3 = dt3_l1_3 + (-0.35364684462547302)*dt3_g0_0;
    dt3_l1_3 = dt3_l1_3 + (-0.17629177868366241)*dt3_g0_1;
    dt3_l1_3 = dt3_l1_3 + (0.022153474390506744)*dt3_g0_2;
    dt3_l1_3 = dt3_l1_3 + (0.18007884919643402)*dt3_g0_3;
    dt3_l1_3 = dt3_l1_3 + (0.10401297360658646)*dt3_g0_4;
    dt3_l1_3 = dt3_l1_3 + (0.051684357225894928)*dt3_g0_5;
    dt3_l1_3 = dt3_l1_3 + (-0.075068175792694092)*dt3_g0_6;
    dt3_l1_3 = dt3_l1_3 + (-0.059393569827079773)*dt3_g0_7;
    dt3_l1_3 = dt3_l1_3 + (0.15978445112705231)*dt3_g0_8;
    dt3_l1_3 = dt3_l1_3 + (-0.12649829685688019)*dt3_g0_9;
    dt3_l1_3 = dt3_l1_3 + (-0.262550950050354)*dt3_g0_10;
    dt3_l1_3 = dt3_l1_3 + (0.061393164098262787)*dt3_g0_11;
    dt3_l1_3 = dt3_l1_3 + (0.065222702920436859)*dt3_g0_12;
    dt3_l1_3 = dt3_l1_3 + (-0.062185466289520264)*dt3_g0_13;
    dt3_l1_3 = dt3_l1_3 + (-0.067431561648845673)*dt3_g0_14;
    dt3_l1_3 = dt3_l1_3 + (-0.19861984252929688)*dt3_g0_15;
    dt3_l1_3 = dt3_l1_3 + (0.64975041151046753)*dt3_g0_16;
    dt3_l1_3 = dt3_l1_3 + (-0.10373525321483612)*dt3_g0_17;
    dt3_l1_3 = dt3_l1_3 + (-0.051274355500936508)*dt3_g0_18;
    dt3_l1_3 = dt3_l1_3 + (0.1738811731338501)*dt3_g0_19;
    dt3_l1_3 = dt3_l1_3 + (-0.064860448241233826)*dt3_g0_20;
    dt3_l1_3 = dt3_l1_3 + (0.13006292283535004)*dt3_g0_21;
    dt3_l1_3 = dt3_l1_3 + (0.039197433739900589)*dt3_g0_22;
    dt3_l1_3 = dt3_l1_3 + (0.11295291036367416)*dt3_g0_23;
    dt3_l1_3 = dt3_l1_3 + (0.039528913795948029)*dt3_g0_24;
    dt3_l1_3 = dt3_l1_3 + (0.13462246954441071)*dt3_g0_25;
    dt3_l1_3 = dt3_l1_3 + (0.074103392660617828)*dt3_g0_26;
    dt3_l1_3 = dt3_l1_3 + (-0.0064598540775477886)*dt3_g0_27;
    dt3_l1_3 = dt3_l1_3 + (-0.24211853742599487)*dt3_g0_28;
    dt3_l1_3 = dt3_l1_3 + (0.093256272375583649)*dt3_g0_29;
    dt3_l1_3 = dt3_l1_3 + (-0.17873191833496094)*dt3_g0_30;
    dt3_l1_3 = dt3_l1_3 + (0.13665640354156494)*dt3_g0_31;
    dt3_l1_4 = 0.12263526022434235;
    dt3_l1_4 = dt3_l1_4 + (0.17370125651359558)*dt3_g0_0;
    dt3_l1_4 = dt3_l1_4 + (-0.083672083914279938)*dt3_g0_1;
    dt3_l1_4 = dt3_l1_4 + (-0.058013491332530975)*dt3_g0_2;
    dt3_l1_4 = dt3_l1_4 + (0.030379418283700943)*dt3_g0_3;
    dt3_l1_4 = dt3_l1_4 + (-0.03496987372636795)*dt3_g0_4;
    dt3_l1_4 = dt3_l1_4 + (-0.34480535984039307)*dt3_g0_5;
    dt3_l1_4 = dt3_l1_4 + (0.18003655970096588)*dt3_g0_6;
    dt3_l1_4 = dt3_l1_4 + (-0.012501563876867294)*dt3_g0_7;
    dt3_l1_4 = dt3_l1_4 + (0.10306855291128159)*dt3_g0_8;
    dt3_l1_4 = dt3_l1_4 + (0.0010572918690741062)*dt3_g0_9;
    dt3_l1_4 = dt3_l1_4 + (0.22152738273143768)*dt3_g0_10;
    dt3_l1_4 = dt3_l1_4 + (-0.046255137771368027)*dt3_g0_11;
    dt3_l1_4 = dt3_l1_4 + (0.078009523451328278)*dt3_g0_12;
    dt3_l1_4 = dt3_l1_4 + (0.066000305116176605)*dt3_g0_13;
    dt3_l1_4 = dt3_l1_4 + (-0.13832651078701019)*dt3_g0_14;
    dt3_l1_4 = dt3_l1_4 + (0.15796451270580292)*dt3_g0_15;
    dt3_l1_4 = dt3_l1_4 + (0.050529871135950089)*dt3_g0_16;
    dt3_l1_4 = dt3_l1_4 + (0.21294906735420227)*dt3_g0_17;
    dt3_l1_4 = dt3_l1_4 + (-0.12090930342674255)*dt3_g0_18;
    dt3_l1_4 = dt3_l1_4 + (-0.068031854927539825)*dt3_g0_19;
    dt3_l1_4 = dt3_l1_4 + (-0.10580087453126907)*dt3_g0_20;
    dt3_l1_4 = dt3_l1_4 + (-0.0046419226564466953)*dt3_g0_21;
    dt3_l1_4 = dt3_l1_4 + (-0.082880429923534393)*dt3_g0_22;
    dt3_l1_4 = dt3_l1_4 + (-0.032585814595222473)*dt3_g0_23;
    dt3_l1_4 = dt3_l1_4 + (-0.10039889067411423)*dt3_g0_24;
    dt3_l1_4 = dt3_l1_4 + (0.11109044402837753)*dt3_g0_25;
    dt3_l1_4 = dt3_l1_4 + (-0.080455757677555084)*dt3_g0_26;
    dt3_l1_4 = dt3_l1_4 + (0.0014013194013386965)*dt3_g0_27;
    dt3_l1_4 = dt3_l1_4 + (-0.15381021797657013)*dt3_g0_28;
    dt3_l1_4 = dt3_l1_4 + (0.05111057311296463)*dt3_g0_29;
    dt3_l1_4 = dt3_l1_4 + (0.076669268310070038)*dt3_g0_30;
    dt3_l1_4 = dt3_l1_4 + (-0.17469201982021332)*dt3_g0_31;
    dt3_l1_5 = -0.051718160510063171;
    dt3_l1_5 = dt3_l1_5 + (0.12622646987438202)*dt3_g0_0;
    dt3_l1_5 = dt3_l1_5 + (0.15407618880271912)*dt3_g0_1;
    dt3_l1_5 = dt3_l1_5 + (0.1102263480424881)*dt3_g0_2;
    dt3_l1_5 = dt3_l1_5 + (0.081044577062129974)*dt3_g0_3;
    dt3_l1_5 = dt3_l1_5 + (0.15326599776744843)*dt3_g0_4;
    dt3_l1_5 = dt3_l1_5 + (0.064281925559043884)*dt3_g0_5;
    dt3_l1_5 = dt3_l1_5 + (-0.21500757336616516)*dt3_g0_6;
    dt3_l1_5 = dt3_l1_5 + (0.098096363246440887)*dt3_g0_7;
    dt3_l1_5 = dt3_l1_5 + (-0.035208825021982193)*dt3_g0_8;
    dt3_l1_5 = dt3_l1_5 + (-0.029627483338117599)*dt3_g0_9;
    dt3_l1_5 = dt3_l1_5 + (0.23539173603057861)*dt3_g0_10;
    dt3_l1_5 = dt3_l1_5 + (-0.059684157371520996)*dt3_g0_11;
    dt3_l1_5 = dt3_l1_5 + (0.18764948844909668)*dt3_g0_12;
    dt3_l1_5 = dt3_l1_5 + (-0.10946971923112869)*dt3_g0_13;
    dt3_l1_5 = dt3_l1_5 + (-0.058492869138717651)*dt3_g0_14;
    dt3_l1_5 = dt3_l1_5 + (0.29810228943824768)*dt3_g0_15;
    dt3_l1_5 = dt3_l1_5 + (-0.25540083646774292)*dt3_g0_16;
    dt3_l1_5 = dt3_l1_5 + (-0.25962957739830017)*dt3_g0_17;
    dt3_l1_5 = dt3_l1_5 + (0.07244226336479187)*dt3_g0_18;
    dt3_l1_5 = dt3_l1_5 + (-0.015826232731342316)*dt3_g0_19;
    dt3_l1_5 = dt3_l1_5 + (-0.13939377665519714)*dt3_g0_20;
    dt3_l1_5 = dt3_l1_5 + (-0.034775912761688232)*dt3_g0_21;
    dt3_l1_5 = dt3_l1_5 + (-0.21197742223739624)*dt3_g0_22;
    dt3_l1_5 = dt3_l1_5 + (-0.10610435903072357)*dt3_g0_23;
    dt3_l1_5 = dt3_l1_5 + (0.053570564836263657)*dt3_g0_24;
    dt3_l1_5 = dt3_l1_5 + (0.040605675429105759)*dt3_g0_25;
    dt3_l1_5 = dt3_l1_5 + (0.023010404780507088)*dt3_g0_26;
    dt3_l1_5 = dt3_l1_5 + (0.12137638777494431)*dt3_g0_27;
    dt3_l1_5 = dt3_l1_5 + (0.23015812039375305)*dt3_g0_28;
    dt3_l1_5 = dt3_l1_5 + (0.06396755576133728)*dt3_g0_29;
    dt3_l1_5 = dt3_l1_5 + (-0.11600128561258316)*dt3_g0_30;
    dt3_l1_5 = dt3_l1_5 + (0.0018161108018830419)*dt3_g0_31;
    dt3_l1_6 = -0.14502783119678497;
    dt3_l1_6 = dt3_l1_6 + (-0.21617880463600159)*dt3_g0_0;
    dt3_l1_6 = dt3_l1_6 + (0.024907056242227554)*dt3_g0_1;
    dt3_l1_6 = dt3_l1_6 + (0.28527197241783142)*dt3_g0_2;
    dt3_l1_6 = dt3_l1_6 + (-0.10465603321790695)*dt3_g0_3;
    dt3_l1_6 = dt3_l1_6 + (0.004011248704046011)*dt3_g0_4;
    dt3_l1_6 = dt3_l1_6 + (0.11178028583526611)*dt3_g0_5;
    dt3_l1_6 = dt3_l1_6 + (0.13247388601303101)*dt3_g0_6;
    dt3_l1_6 = dt3_l1_6 + (0.17205116152763367)*dt3_g0_7;
    dt3_l1_6 = dt3_l1_6 + (0.017789272591471672)*dt3_g0_8;
    dt3_l1_6 = dt3_l1_6 + (0.0079919397830963135)*dt3_g0_9;
    dt3_l1_6 = dt3_l1_6 + (-0.17143863439559937)*dt3_g0_10;
    dt3_l1_6 = dt3_l1_6 + (-0.090974859893321991)*dt3_g0_11;
    dt3_l1_6 = dt3_l1_6 + (0.00026911767781712115)*dt3_g0_12;
    dt3_l1_6 = dt3_l1_6 + (0.12699028849601746)*dt3_g0_13;
    dt3_l1_6 = dt3_l1_6 + (0.012657118029892445)*dt3_g0_14;
    dt3_l1_6 = dt3_l1_6 + (0.014249536208808422)*dt3_g0_15;
    dt3_l1_6 = dt3_l1_6 + (0.29837688803672791)*dt3_g0_16;
    dt3_l1_6 = dt3_l1_6 + (0.10275484621524811)*dt3_g0_17;
    dt3_l1_6 = dt3_l1_6 + (-0.052840493619441986)*dt3_g0_18;
    dt3_l1_6 = dt3_l1_6 + (-0.064061515033245087)*dt3_g0_19;
    dt3_l1_6 = dt3_l1_6 + (0.084928445518016815)*dt3_g0_20;
    dt3_l1_6 = dt3_l1_6 + (-0.10871539264917374)*dt3_g0_21;
    dt3_l1_6 = dt3_l1_6 + (0.17323924601078033)*dt3_g0_22;
    dt3_l1_6 = dt3_l1_6 + (0.063852109014987946)*dt3_g0_23;
    dt3_l1_6 = dt3_l1_6 + (-0.054064754396677017)*dt3_g0_24;
    dt3_l1_6 = dt3_l1_6 + (-0.096406780183315277)*dt3_g0_25;
    dt3_l1_6 = dt3_l1_6 + (0.034694094210863113)*dt3_g0_26;
    dt3_l1_6 = dt3_l1_6 + (-0.040985178202390671)*dt3_g0_27;
    dt3_l1_6 = dt3_l1_6 + (-0.1414448469877243)*dt3_g0_28;
    dt3_l1_6 = dt3_l1_6 + (-0.18324244022369385)*dt3_g0_29;
    dt3_l1_6 = dt3_l1_6 + (-0.0061641675420105457)*dt3_g0_30;
    dt3_l1_6 = dt3_l1_6 + (0.14373365044593811)*dt3_g0_31;
    dt3_l1_7 = 0.15039798617362976;
    dt3_l1_7 = dt3_l1_7 + (0.047673169523477554)*dt3_g0_0;
    dt3_l1_7 = dt3_l1_7 + (0.072389706969261169)*dt3_g0_1;
    dt3_l1_7 = dt3_l1_7 + (-0.065495222806930542)*dt3_g0_2;
    dt3_l1_7 = dt3_l1_7 + (-0.037528026849031448)*dt3_g0_3;
    dt3_l1_7 = dt3_l1_7 + (-0.10889255255460739)*dt3_g0_4;
    dt3_l1_7 = dt3_l1_7 + (0.11605526506900787)*dt3_g0_5;
    dt3_l1_7 = dt3_l1_7 + (-0.026777036488056183)*dt3_g0_6;
    dt3_l1_7 = dt3_l1_7 + (-0.028399230912327766)*dt3_g0_7;
    dt3_l1_7 = dt3_l1_7 + (0.047372490167617798)*dt3_g0_8;
    dt3_l1_7 = dt3_l1_7 + (-0.012069370597600937)*dt3_g0_9;
    dt3_l1_7 = dt3_l1_7 + (-0.083184346556663513)*dt3_g0_10;
    dt3_l1_7 = dt3_l1_7 + (0.02154984325170517)*dt3_g0_11;
    dt3_l1_7 = dt3_l1_7 + (-0.040346946567296982)*dt3_g0_12;
    dt3_l1_7 = dt3_l1_7 + (-0.16211129724979401)*dt3_g0_13;
    dt3_l1_7 = dt3_l1_7 + (0.13870799541473389)*dt3_g0_14;
    dt3_l1_7 = dt3_l1_7 + (-0.19581884145736694)*dt3_g0_15;
    dt3_l1_7 = dt3_l1_7 + (-0.1117430180311203)*dt3_g0_16;
    dt3_l1_7 = dt3_l1_7 + (0.17394495010375977)*dt3_g0_17;
    dt3_l1_7 = dt3_l1_7 + (-0.00035679028951562941)*dt3_g0_18;
    dt3_l1_7 = dt3_l1_7 + (-0.048673704266548157)*dt3_g0_19;
    dt3_l1_7 = dt3_l1_7 + (0.15421126782894135)*dt3_g0_20;
    dt3_l1_7 = dt3_l1_7 + (0.13505768775939941)*dt3_g0_21;
    dt3_l1_7 = dt3_l1_7 + (0.036396581679582596)*dt3_g0_22;
    dt3_l1_7 = dt3_l1_7 + (0.0034029996022582054)*dt3_g0_23;
    dt3_l1_7 = dt3_l1_7 + (-0.24609997868537903)*dt3_g0_24;
    dt3_l1_7 = dt3_l1_7 + (0.15485222637653351)*dt3_g0_25;
    dt3_l1_7 = dt3_l1_7 + (-0.073318503797054291)*dt3_g0_26;
    dt3_l1_7 = dt3_l1_7 + (0.050975963473320007)*dt3_g0_27;
    dt3_l1_7 = dt3_l1_7 + (0.016177339479327202)*dt3_g0_28;
    dt3_l1_7 = dt3_l1_7 + (0.069688819348812103)*dt3_g0_29;
    dt3_l1_7 = dt3_l1_7 + (0.070944041013717651)*dt3_g0_30;
    dt3_l1_7 = dt3_l1_7 + (0.11156594753265381)*dt3_g0_31;
    dt3_l1_8 = 0.17791567742824554;
    dt3_l1_8 = dt3_l1_8 + (-0.071427121758460999)*dt3_g0_0;
    dt3_l1_8 = dt3_l1_8 + (-0.014428609050810337)*dt3_g0_1;
    dt3_l1_8 = dt3_l1_8 + (-0.1958298534154892)*dt3_g0_2;
    dt3_l1_8 = dt3_l1_8 + (-0.16039794683456421)*dt3_g0_3;
    dt3_l1_8 = dt3_l1_8 + (-0.13343974947929382)*dt3_g0_4;
    dt3_l1_8 = dt3_l1_8 + (0.26373711228370667)*dt3_g0_5;
    dt3_l1_8 = dt3_l1_8 + (0.017795341089367867)*dt3_g0_6;
    dt3_l1_8 = dt3_l1_8 + (-0.021144472062587738)*dt3_g0_7;
    dt3_l1_8 = dt3_l1_8 + (-0.23094122111797333)*dt3_g0_8;
    dt3_l1_8 = dt3_l1_8 + (0.073461614549160004)*dt3_g0_9;
    dt3_l1_8 = dt3_l1_8 + (0.11966696381568909)*dt3_g0_10;
    dt3_l1_8 = dt3_l1_8 + (0.17676906287670135)*dt3_g0_11;
    dt3_l1_8 = dt3_l1_8 + (-0.048930056393146515)*dt3_g0_12;
    dt3_l1_8 = dt3_l1_8 + (-0.14716175198554993)*dt3_g0_13;
    dt3_l1_8 = dt3_l1_8 + (0.11388258635997772)*dt3_g0_14;
    dt3_l1_8 = dt3_l1_8 + (0.082485564053058624)*dt3_g0_15;
    dt3_l1_8 = dt3_l1_8 + (0.46304497122764587)*dt3_g0_16;
    dt3_l1_8 = dt3_l1_8 + (0.00068784336326643825)*dt3_g0_17;
    dt3_l1_8 = dt3_l1_8 + (0.10457544773817062)*dt3_g0_18;
    dt3_l1_8 = dt3_l1_8 + (-0.0063994922675192356)*dt3_g0_19;
    dt3_l1_8 = dt3_l1_8 + (-0.14240989089012146)*dt3_g0_20;
    dt3_l1_8 = dt3_l1_8 + (-0.048434056341648102)*dt3_g0_21;
    dt3_l1_8 = dt3_l1_8 + (0.16329094767570496)*dt3_g0_22;
    dt3_l1_8 = dt3_l1_8 + (-0.080508217215538025)*dt3_g0_23;
    dt3_l1_8 = dt3_l1_8 + (0.18204766511917114)*dt3_g0_24;
    dt3_l1_8 = dt3_l1_8 + (-0.094055630266666412)*dt3_g0_25;
    dt3_l1_8 = dt3_l1_8 + (-0.12780973315238953)*dt3_g0_26;
    dt3_l1_8 = dt3_l1_8 + (-0.11680302768945694)*dt3_g0_27;
    dt3_l1_8 = dt3_l1_8 + (0.25664985179901123)*dt3_g0_28;
    dt3_l1_8 = dt3_l1_8 + (0.050704926252365112)*dt3_g0_29;
    dt3_l1_8 = dt3_l1_8 + (0.1178852841258049)*dt3_g0_30;
    dt3_l1_8 = dt3_l1_8 + (0.23110063374042511)*dt3_g0_31;
    dt3_l1_9 = -0.13868293166160583;
    dt3_l1_9 = dt3_l1_9 + (0.023834094405174255)*dt3_g0_0;
    dt3_l1_9 = dt3_l1_9 + (0.13403761386871338)*dt3_g0_1;
    dt3_l1_9 = dt3_l1_9 + (0.15153506398200989)*dt3_g0_2;
    dt3_l1_9 = dt3_l1_9 + (0.017937421798706055)*dt3_g0_3;
    dt3_l1_9 = dt3_l1_9 + (0.156947061419487)*dt3_g0_4;
    dt3_l1_9 = dt3_l1_9 + (-0.23003552854061127)*dt3_g0_5;
    dt3_l1_9 = dt3_l1_9 + (-0.11289767175912857)*dt3_g0_6;
    dt3_l1_9 = dt3_l1_9 + (0.049387767910957336)*dt3_g0_7;
    dt3_l1_9 = dt3_l1_9 + (0.21174226701259613)*dt3_g0_8;
    dt3_l1_9 = dt3_l1_9 + (0.18910692632198334)*dt3_g0_9;
    dt3_l1_9 = dt3_l1_9 + (0.10178250819444656)*dt3_g0_10;
    dt3_l1_9 = dt3_l1_9 + (-0.13315603137016296)*dt3_g0_11;
    dt3_l1_9 = dt3_l1_9 + (0.10240495204925537)*dt3_g0_12;
    dt3_l1_9 = dt3_l1_9 + (0.045188978314399719)*dt3_g0_13;
    dt3_l1_9 = dt3_l1_9 + (0.12674446403980255)*dt3_g0_14;
    dt3_l1_9 = dt3_l1_9 + (-0.018667533993721008)*dt3_g0_15;
    dt3_l1_9 = dt3_l1_9 + (0.054173573851585388)*dt3_g0_16;
    dt3_l1_9 = dt3_l1_9 + (-0.050129134207963943)*dt3_g0_17;
    dt3_l1_9 = dt3_l1_9 + (0.10595974326133728)*dt3_g0_18;
    dt3_l1_9 = dt3_l1_9 + (-0.029256910085678101)*dt3_g0_19;
    dt3_l1_9 = dt3_l1_9 + (-0.0041289492510259151)*dt3_g0_20;
    dt3_l1_9 = dt3_l1_9 + (0.067040741443634033)*dt3_g0_21;
    dt3_l1_9 = dt3_l1_9 + (0.28273269534111023)*dt3_g0_22;
    dt3_l1_9 = dt3_l1_9 + (-0.08960222452878952)*dt3_g0_23;
    dt3_l1_9 = dt3_l1_9 + (0.23507948219776154)*dt3_g0_24;
    dt3_l1_9 = dt3_l1_9 + (0.11662031710147858)*dt3_g0_25;
    dt3_l1_9 = dt3_l1_9 + (-0.1481965184211731)*dt3_g0_26;
    dt3_l1_9 = dt3_l1_9 + (0.068826325237751007)*dt3_g0_27;
    dt3_l1_9 = dt3_l1_9 + (-0.41048020124435425)*dt3_g0_28;
    dt3_l1_9 = dt3_l1_9 + (0.028586402535438538)*dt3_g0_29;
    dt3_l1_9 = dt3_l1_9 + (0.093711540102958679)*dt3_g0_30;
    dt3_l1_9 = dt3_l1_9 + (-0.16042201220989227)*dt3_g0_31;
    dt3_l1_10 = -0.078292421996593475;
    dt3_l1_10 = dt3_l1_10 + (0.38613796234130859)*dt3_g0_0;
    dt3_l1_10 = dt3_l1_10 + (0.16861145198345184)*dt3_g0_1;
    dt3_l1_10 = dt3_l1_10 + (-0.034250523895025253)*dt3_g0_2;
    dt3_l1_10 = dt3_l1_10 + (0.12220780551433563)*dt3_g0_3;
    dt3_l1_10 = dt3_l1_10 + (0.076330028474330902)*dt3_g0_4;
    dt3_l1_10 = dt3_l1_10 + (0.45561903715133667)*dt3_g0_5;
    dt3_l1_10 = dt3_l1_10 + (0.09523686021566391)*dt3_g0_6;
    dt3_l1_10 = dt3_l1_10 + (-0.031291704624891281)*dt3_g0_7;
    dt3_l1_10 = dt3_l1_10 + (-0.16195787489414215)*dt3_g0_8;
    dt3_l1_10 = dt3_l1_10 + (-0.12284358590841293)*dt3_g0_9;
    dt3_l1_10 = dt3_l1_10 + (0.19868870079517365)*dt3_g0_10;
    dt3_l1_10 = dt3_l1_10 + (-0.059839930385351181)*dt3_g0_11;
    dt3_l1_10 = dt3_l1_10 + (0.016507105901837349)*dt3_g0_12;
    dt3_l1_10 = dt3_l1_10 + (0.089055366814136505)*dt3_g0_13;
    dt3_l1_10 = dt3_l1_10 + (-0.073398031294345856)*dt3_g0_14;
    dt3_l1_10 = dt3_l1_10 + (0.12010634690523148)*dt3_g0_15;
    dt3_l1_10 = dt3_l1_10 + (-0.56620091199874878)*dt3_g0_16;
    dt3_l1_10 = dt3_l1_10 + (0.032096225768327713)*dt3_g0_17;
    dt3_l1_10 = dt3_l1_10 + (0.060803625732660294)*dt3_g0_18;
    dt3_l1_10 = dt3_l1_10 + (-0.1705658882856369)*dt3_g0_19;
    dt3_l1_10 = dt3_l1_10 + (-0.13755302131175995)*dt3_g0_20;
    dt3_l1_10 = dt3_l1_10 + (-0.087579868733882904)*dt3_g0_21;
    dt3_l1_10 = dt3_l1_10 + (-0.1278015673160553)*dt3_g0_22;
    dt3_l1_10 = dt3_l1_10 + (0.18843105435371399)*dt3_g0_23;
    dt3_l1_10 = dt3_l1_10 + (0.1520625501871109)*dt3_g0_24;
    dt3_l1_10 = dt3_l1_10 + (0.079296454787254333)*dt3_g0_25;
    dt3_l1_10 = dt3_l1_10 + (-0.24782979488372803)*dt3_g0_26;
    dt3_l1_10 = dt3_l1_10 + (-0.039584934711456299)*dt3_g0_27;
    dt3_l1_10 = dt3_l1_10 + (0.37787425518035889)*dt3_g0_28;
    dt3_l1_10 = dt3_l1_10 + (0.11145026236772537)*dt3_g0_29;
    dt3_l1_10 = dt3_l1_10 + (-0.16598974168300629)*dt3_g0_30;
    dt3_l1_10 = dt3_l1_10 + (0.0084111606702208519)*dt3_g0_31;
    dt3_l1_11 = -0.062137391418218613;
    dt3_l1_11 = dt3_l1_11 + (-0.17376498878002167)*dt3_g0_0;
    dt3_l1_11 = dt3_l1_11 + (0.096284717321395874)*dt3_g0_1;
    dt3_l1_11 = dt3_l1_11 + (-0.091086395084857941)*dt3_g0_2;
    dt3_l1_11 = dt3_l1_11 + (-0.098921611905097961)*dt3_g0_3;
    dt3_l1_11 = dt3_l1_11 + (-0.13950799405574799)*dt3_g0_4;
    dt3_l1_11 = dt3_l1_11 + (-0.21119497716426849)*dt3_g0_5;
    dt3_l1_11 = dt3_l1_11 + (-0.29174453020095825)*dt3_g0_6;
    dt3_l1_11 = dt3_l1_11 + (-0.041246883571147919)*dt3_g0_7;
    dt3_l1_11 = dt3_l1_11 + (-0.19079685211181641)*dt3_g0_8;
    dt3_l1_11 = dt3_l1_11 + (-0.063988305628299713)*dt3_g0_9;
    dt3_l1_11 = dt3_l1_11 + (0.19126258790493011)*dt3_g0_10;
    dt3_l1_11 = dt3_l1_11 + (-0.17825838923454285)*dt3_g0_11;
    dt3_l1_11 = dt3_l1_11 + (-0.15225179493427277)*dt3_g0_12;
    dt3_l1_11 = dt3_l1_11 + (-0.16363492608070374)*dt3_g0_13;
    dt3_l1_11 = dt3_l1_11 + (-0.10237506777048111)*dt3_g0_14;
    dt3_l1_11 = dt3_l1_11 + (0.18985816836357117)*dt3_g0_15;
    dt3_l1_11 = dt3_l1_11 + (0.11689111590385437)*dt3_g0_16;
    dt3_l1_11 = dt3_l1_11 + (-0.27802398800849915)*dt3_g0_17;
    dt3_l1_11 = dt3_l1_11 + (0.030934391543269157)*dt3_g0_18;
    dt3_l1_11 = dt3_l1_11 + (0.1008097305893898)*dt3_g0_19;
    dt3_l1_11 = dt3_l1_11 + (0.098364770412445068)*dt3_g0_20;
    dt3_l1_11 = dt3_l1_11 + (-0.010569779202342033)*dt3_g0_21;
    dt3_l1_11 = dt3_l1_11 + (0.0079128220677375793)*dt3_g0_22;
    dt3_l1_11 = dt3_l1_11 + (-0.079806827008724213)*dt3_g0_23;
    dt3_l1_11 = dt3_l1_11 + (0.27011299133300781)*dt3_g0_24;
    dt3_l1_11 = dt3_l1_11 + (0.070469021797180176)*dt3_g0_25;
    dt3_l1_11 = dt3_l1_11 + (-0.38286259770393372)*dt3_g0_26;
    dt3_l1_11 = dt3_l1_11 + (-0.14456358551979065)*dt3_g0_27;
    dt3_l1_11 = dt3_l1_11 + (-0.52179837226867676)*dt3_g0_28;
    dt3_l1_11 = dt3_l1_11 + (-0.073391132056713104)*dt3_g0_29;
    dt3_l1_11 = dt3_l1_11 + (0.10099390894174576)*dt3_g0_30;
    dt3_l1_11 = dt3_l1_11 + (-0.2381131649017334)*dt3_g0_31;
    dt3_l1_12 = -0.077903278172016144;
    dt3_l1_12 = dt3_l1_12 + (-0.024478539824485779)*dt3_g0_0;
    dt3_l1_12 = dt3_l1_12 + (0.15509465336799622)*dt3_g0_1;
    dt3_l1_12 = dt3_l1_12 + (0.021082784980535507)*dt3_g0_2;
    dt3_l1_12 = dt3_l1_12 + (-0.089185543358325958)*dt3_g0_3;
    dt3_l1_12 = dt3_l1_12 + (0.0031038988381624222)*dt3_g0_4;
    dt3_l1_12 = dt3_l1_12 + (0.10395709425210953)*dt3_g0_5;
    dt3_l1_12 = dt3_l1_12 + (-0.26505029201507568)*dt3_g0_6;
    dt3_l1_12 = dt3_l1_12 + (-0.10546328872442245)*dt3_g0_7;
    dt3_l1_12 = dt3_l1_12 + (-0.12884120643138885)*dt3_g0_8;
    dt3_l1_12 = dt3_l1_12 + (0.11630596220493317)*dt3_g0_9;
    dt3_l1_12 = dt3_l1_12 + (0.0063452315516769886)*dt3_g0_10;
    dt3_l1_12 = dt3_l1_12 + (-0.0063953367061913013)*dt3_g0_11;
    dt3_l1_12 = dt3_l1_12 + (-0.021227281540632248)*dt3_g0_12;
    dt3_l1_12 = dt3_l1_12 + (-0.10694406181573868)*dt3_g0_13;
    dt3_l1_12 = dt3_l1_12 + (-0.051671974360942841)*dt3_g0_14;
    dt3_l1_12 = dt3_l1_12 + (0.014918405562639236)*dt3_g0_15;
    dt3_l1_12 = dt3_l1_12 + (-0.33986765146255493)*dt3_g0_16;
    dt3_l1_12 = dt3_l1_12 + (0.024092648178339005)*dt3_g0_17;
    dt3_l1_12 = dt3_l1_12 + (0.090858824551105499)*dt3_g0_18;
    dt3_l1_12 = dt3_l1_12 + (0.19264908134937286)*dt3_g0_19;
    dt3_l1_12 = dt3_l1_12 + (-0.082039140164852142)*dt3_g0_20;
    dt3_l1_12 = dt3_l1_12 + (0.0058428267948329449)*dt3_g0_21;
    dt3_l1_12 = dt3_l1_12 + (0.25755473971366882)*dt3_g0_22;
    dt3_l1_12 = dt3_l1_12 + (0.048122107982635498)*dt3_g0_23;
    dt3_l1_12 = dt3_l1_12 + (-0.25055438280105591)*dt3_g0_24;
    dt3_l1_12 = dt3_l1_12 + (0.016316866502165794)*dt3_g0_25;
    dt3_l1_12 = dt3_l1_12 + (-0.081792674958705902)*dt3_g0_26;
    dt3_l1_12 = dt3_l1_12 + (-0.063519790768623352)*dt3_g0_27;
    dt3_l1_12 = dt3_l1_12 + (0.50614690780639648)*dt3_g0_28;
    dt3_l1_12 = dt3_l1_12 + (-0.066375598311424255)*dt3_g0_29;
    dt3_l1_12 = dt3_l1_12 + (0.090680874884128571)*dt3_g0_30;
    dt3_l1_12 = dt3_l1_12 + (-0.073922984302043915)*dt3_g0_31;
    dt3_l1_13 = -0.12205866724252701;
    dt3_l1_13 = dt3_l1_13 + (-0.25504162907600403)*dt3_g0_0;
    dt3_l1_13 = dt3_l1_13 + (-0.049930181354284286)*dt3_g0_1;
    dt3_l1_13 = dt3_l1_13 + (0.14232224225997925)*dt3_g0_2;
    dt3_l1_13 = dt3_l1_13 + (0.15969088673591614)*dt3_g0_3;
    dt3_l1_13 = dt3_l1_13 + (0.14399471879005432)*dt3_g0_4;
    dt3_l1_13 = dt3_l1_13 + (-0.058044787496328354)*dt3_g0_5;
    dt3_l1_13 = dt3_l1_13 + (0.11529924720525742)*dt3_g0_6;
    dt3_l1_13 = dt3_l1_13 + (0.039351854473352432)*dt3_g0_7;
    dt3_l1_13 = dt3_l1_13 + (0.12985527515411377)*dt3_g0_8;
    dt3_l1_13 = dt3_l1_13 + (-0.055830512195825577)*dt3_g0_9;
    dt3_l1_13 = dt3_l1_13 + (-0.11088638752698898)*dt3_g0_10;
    dt3_l1_13 = dt3_l1_13 + (-0.071301668882369995)*dt3_g0_11;
    dt3_l1_13 = dt3_l1_13 + (0.059834972023963928)*dt3_g0_12;
    dt3_l1_13 = dt3_l1_13 + (-0.026034511625766754)*dt3_g0_13;
    dt3_l1_13 = dt3_l1_13 + (0.18610493838787079)*dt3_g0_14;
    dt3_l1_13 = dt3_l1_13 + (-0.070099622011184692)*dt3_g0_15;
    dt3_l1_13 = dt3_l1_13 + (0.2838326096534729)*dt3_g0_16;
    dt3_l1_13 = dt3_l1_13 + (-0.037520397454500198)*dt3_g0_17;
    dt3_l1_13 = dt3_l1_13 + (0.13068065047264099)*dt3_g0_18;
    dt3_l1_13 = dt3_l1_13 + (0.066525585949420929)*dt3_g0_19;
    dt3_l1_13 = dt3_l1_13 + (-0.049645096063613892)*dt3_g0_20;
    dt3_l1_13 = dt3_l1_13 + (0.054189886897802353)*dt3_g0_21;
    dt3_l1_13 = dt3_l1_13 + (-0.17614948749542236)*dt3_g0_22;
    dt3_l1_13 = dt3_l1_13 + (0.0069473623298108578)*dt3_g0_23;
    dt3_l1_13 = dt3_l1_13 + (-0.071386918425559998)*dt3_g0_24;
    dt3_l1_13 = dt3_l1_13 + (-0.1061040461063385)*dt3_g0_25;
    dt3_l1_13 = dt3_l1_13 + (0.24330644309520721)*dt3_g0_26;
    dt3_l1_13 = dt3_l1_13 + (0.13288405537605286)*dt3_g0_27;
    dt3_l1_13 = dt3_l1_13 + (-0.095819815993309021)*dt3_g0_28;
    dt3_l1_13 = dt3_l1_13 + (0.1976703405380249)*dt3_g0_29;
    dt3_l1_13 = dt3_l1_13 + (-0.10413108766078949)*dt3_g0_30;
    dt3_l1_13 = dt3_l1_13 + (-0.066180601716041565)*dt3_g0_31;
    dt3_l1_14 = 0.10435187816619873;
    dt3_l1_14 = dt3_l1_14 + (0.066092170774936676)*dt3_g0_0;
    dt3_l1_14 = dt3_l1_14 + (-0.14066116511821747)*dt3_g0_1;
    dt3_l1_14 = dt3_l1_14 + (0.0070511805824935436)*dt3_g0_2;
    dt3_l1_14 = dt3_l1_14 + (0.016216622665524483)*dt3_g0_3;
    dt3_l1_14 = dt3_l1_14 + (-0.077155455946922302)*dt3_g0_4;
    dt3_l1_14 = dt3_l1_14 + (-0.0035024809185415506)*dt3_g0_5;
    dt3_l1_14 = dt3_l1_14 + (0.16614776849746704)*dt3_g0_6;
    dt3_l1_14 = dt3_l1_14 + (-0.097305327653884888)*dt3_g0_7;
    dt3_l1_14 = dt3_l1_14 + (0.049758661538362503)*dt3_g0_8;
    dt3_l1_14 = dt3_l1_14 + (-0.10961616039276123)*dt3_g0_9;
    dt3_l1_14 = dt3_l1_14 + (0.082717306911945343)*dt3_g0_10;
    dt3_l1_14 = dt3_l1_14 + (0.080690205097198486)*dt3_g0_11;
    dt3_l1_14 = dt3_l1_14 + (-0.019630759954452515)*dt3_g0_12;
    dt3_l1_14 = dt3_l1_14 + (-0.14077238738536835)*dt3_g0_13;
    dt3_l1_14 = dt3_l1_14 + (-0.14777269959449768)*dt3_g0_14;
    dt3_l1_14 = dt3_l1_14 + (0.1627192497253418)*dt3_g0_15;
    dt3_l1_14 = dt3_l1_14 + (-0.27055931091308594)*dt3_g0_16;
    dt3_l1_14 = dt3_l1_14 + (0.24675653874874115)*dt3_g0_17;
    dt3_l1_14 = dt3_l1_14 + (-0.13080167770385742)*dt3_g0_18;
    dt3_l1_14 = dt3_l1_14 + (-0.12526585161685944)*dt3_g0_19;
    dt3_l1_14 = dt3_l1_14 + (0.026029074564576149)*dt3_g0_20;
    dt3_l1_14 = dt3_l1_14 + (0.00069717544829472899)*dt3_g0_21;
    dt3_l1_14 = dt3_l1_14 + (-0.24566978216171265)*dt3_g0_22;
    dt3_l1_14 = dt3_l1_14 + (-0.03789505735039711)*dt3_g0_23;
    dt3_l1_14 = dt3_l1_14 + (0.031554587185382843)*dt3_g0_24;
    dt3_l1_14 = dt3_l1_14 + (-0.16307400166988373)*dt3_g0_25;
    dt3_l1_14 = dt3_l1_14 + (0.18186207115650177)*dt3_g0_26;
    dt3_l1_14 = dt3_l1_14 + (0.10117419809103012)*dt3_g0_27;
    dt3_l1_14 = dt3_l1_14 + (0.71069341897964478)*dt3_g0_28;
    dt3_l1_14 = dt3_l1_14 + (-0.094877868890762329)*dt3_g0_29;
    dt3_l1_14 = dt3_l1_14 + (-0.10863464325666428)*dt3_g0_30;
    dt3_l1_14 = dt3_l1_14 + (0.044603679329156876)*dt3_g0_31;
    dt3_l1_15 = 0.054931297898292542;
    dt3_l1_15 = dt3_l1_15 + (-0.12308650463819504)*dt3_g0_0;
    dt3_l1_15 = dt3_l1_15 + (0.10122453421354294)*dt3_g0_1;
    dt3_l1_15 = dt3_l1_15 + (-0.036758832633495331)*dt3_g0_2;
    dt3_l1_15 = dt3_l1_15 + (-0.055523984134197235)*dt3_g0_3;
    dt3_l1_15 = dt3_l1_15 + (0.024221815168857574)*dt3_g0_4;
    dt3_l1_15 = dt3_l1_15 + (0.36427092552185059)*dt3_g0_5;
    dt3_l1_15 = dt3_l1_15 + (0.013182561844587326)*dt3_g0_6;
    dt3_l1_15 = dt3_l1_15 + (-0.084676198661327362)*dt3_g0_7;
    dt3_l1_15 = dt3_l1_15 + (0.094983756542205811)*dt3_g0_8;
    dt3_l1_15 = dt3_l1_15 + (-0.044733546674251556)*dt3_g0_9;
    dt3_l1_15 = dt3_l1_15 + (-0.068374097347259521)*dt3_g0_10;
    dt3_l1_15 = dt3_l1_15 + (0.073864951729774475)*dt3_g0_11;
    dt3_l1_15 = dt3_l1_15 + (0.040122237056493759)*dt3_g0_12;
    dt3_l1_15 = dt3_l1_15 + (-0.11484098434448242)*dt3_g0_13;
    dt3_l1_15 = dt3_l1_15 + (0.029558604583144188)*dt3_g0_14;
    dt3_l1_15 = dt3_l1_15 + (-0.12961806356906891)*dt3_g0_15;
    dt3_l1_15 = dt3_l1_15 + (-0.68139654397964478)*dt3_g0_16;
    dt3_l1_15 = dt3_l1_15 + (-0.090533196926116943)*dt3_g0_17;
    dt3_l1_15 = dt3_l1_15 + (-0.055364329367876053)*dt3_g0_18;
    dt3_l1_15 = dt3_l1_15 + (-0.037381157279014587)*dt3_g0_19;
    dt3_l1_15 = dt3_l1_15 + (-0.013406396843492985)*dt3_g0_20;
    dt3_l1_15 = dt3_l1_15 + (0.067575834691524506)*dt3_g0_21;
    dt3_l1_15 = dt3_l1_15 + (-0.080908246338367462)*dt3_g0_22;
    dt3_l1_15 = dt3_l1_15 + (0.05767367035150528)*dt3_g0_23;
    dt3_l1_15 = dt3_l1_15 + (0.042280886322259903)*dt3_g0_24;
    dt3_l1_15 = dt3_l1_15 + (-0.18634659051895142)*dt3_g0_25;
    dt3_l1_15 = dt3_l1_15 + (0.31346985697746277)*dt3_g0_26;
    dt3_l1_15 = dt3_l1_15 + (0.038848195225000381)*dt3_g0_27;
    dt3_l1_15 = dt3_l1_15 + (0.23577156662940979)*dt3_g0_28;
    dt3_l1_15 = dt3_l1_15 + (-0.014047614298760891)*dt3_g0_29;
    dt3_l1_15 = dt3_l1_15 + (0.096515163779258728)*dt3_g0_30;
    dt3_l1_15 = dt3_l1_15 + (-0.062498938292264938)*dt3_g0_31;
    // Device tower token 4
    dt4_l0_0 = (-0.24873463535667367) + (0.34432113170623779)*d_scaled;
    dt4_l0_1 = (-0.21331571292041906) + (0.47822898626327515)*d_scaled;
    dt4_l0_2 = (-0.21976859611243799) + (0.24066966772079468)*d_scaled;
    dt4_l0_3 = (0.42381765659129123) + (0.048484642058610916)*d_scaled;
    dt4_l0_4 = (0.74053086076337615) + (0.13176910579204559)*d_scaled;
    dt4_l0_5 = (-0.38299381160017609) + (-0.30407708883285522)*d_scaled;
    dt4_l0_6 = (-1.2772189396723381) + (-0.11684082448482513)*d_scaled;
    dt4_l0_7 = (0.77588608467776166) + (0.040982868522405624)*d_scaled;
    dt4_l0_8 = (0.7522523506793577) + (0.61334097385406494)*d_scaled;
    dt4_l0_9 = (0.2579478302305247) + (0.14561383426189423)*d_scaled;
    dt4_l0_10 = (-0.40403994056374298) + (0.45312285423278809)*d_scaled;
    dt4_l0_11 = (0.2797443018315362) + (-0.057421129196882248)*d_scaled;
    dt4_l0_12 = (0.31890106006099928) + (0.076745271682739258)*d_scaled;
    dt4_l0_13 = (0.54260345557680523) + (0.11903565376996994)*d_scaled;
    dt4_l0_14 = (1.6077713234927895) + (0.049182634800672531)*d_scaled;
    dt4_l0_15 = (-0.59713845057642412) + (0.39639326930046082)*d_scaled;
    dt4_l0_16 = (-0.33631869617771643) + (-0.5463671088218689)*d_scaled;
    dt4_l0_17 = (-0.93765964701410587) + (-0.34476840496063232)*d_scaled;
    dt4_l0_18 = (-0.060071978249083835) + (0.042969517409801483)*d_scaled;
    dt4_l0_19 = (0.78980722460921393) + (-0.30303272604942322)*d_scaled;
    dt4_l0_20 = (-0.14060048445958262) + (0.073118828237056732)*d_scaled;
    dt4_l0_21 = (0.14994671758925848) + (0.060475107282400131)*d_scaled;
    dt4_l0_22 = (-1.4307988737301764) + (0.23183275759220123)*d_scaled;
    dt4_l0_23 = (-0.20707401956042915) + (0.0091169727966189384)*d_scaled;
    dt4_l0_24 = (-0.41785811007943169) + (-0.022656848654150963)*d_scaled;
    dt4_l0_25 = (0.82856888025079023) + (0.13182426989078522)*d_scaled;
    dt4_l0_26 = (-0.7880096479185873) + (-0.41274189949035645)*d_scaled;
    dt4_l0_27 = (-0.21026343318667085) + (0.14568156003952026)*d_scaled;
    dt4_l0_28 = (-0.44914498133974151) + (-0.67684346437454224)*d_scaled;
    dt4_l0_29 = (0.14874548287528244) + (0.01818244531750679)*d_scaled;
    dt4_l0_30 = (-1.1376853568583769) + (0.22900021076202393)*d_scaled;
    dt4_l0_31 = (-0.43200306931951094) + (-0.24716407060623169)*d_scaled;
    dt4_mean = (dt4_l0_0 + dt4_l0_1 + dt4_l0_2 + dt4_l0_3 + dt4_l0_4 + dt4_l0_5 + dt4_l0_6 + dt4_l0_7 + dt4_l0_8 + dt4_l0_9 + dt4_l0_10 + dt4_l0_11 + dt4_l0_12 + dt4_l0_13 + dt4_l0_14 + dt4_l0_15 + dt4_l0_16 + dt4_l0_17 + dt4_l0_18 + dt4_l0_19 + dt4_l0_20 + dt4_l0_21 + dt4_l0_22 + dt4_l0_23 + dt4_l0_24 + dt4_l0_25 + dt4_l0_26 + dt4_l0_27 + dt4_l0_28 + dt4_l0_29 + dt4_l0_30 + dt4_l0_31) / 32;
    dt4_var = (((dt4_l0_0) - dt4_mean)*((dt4_l0_0) - dt4_mean) + ((dt4_l0_1) - dt4_mean)*((dt4_l0_1) - dt4_mean) + ((dt4_l0_2) - dt4_mean)*((dt4_l0_2) - dt4_mean) + ((dt4_l0_3) - dt4_mean)*((dt4_l0_3) - dt4_mean) + ((dt4_l0_4) - dt4_mean)*((dt4_l0_4) - dt4_mean) + ((dt4_l0_5) - dt4_mean)*((dt4_l0_5) - dt4_mean) + ((dt4_l0_6) - dt4_mean)*((dt4_l0_6) - dt4_mean) + ((dt4_l0_7) - dt4_mean)*((dt4_l0_7) - dt4_mean) + ((dt4_l0_8) - dt4_mean)*((dt4_l0_8) - dt4_mean) + ((dt4_l0_9) - dt4_mean)*((dt4_l0_9) - dt4_mean) + ((dt4_l0_10) - dt4_mean)*((dt4_l0_10) - dt4_mean) + ((dt4_l0_11) - dt4_mean)*((dt4_l0_11) - dt4_mean) + ((dt4_l0_12) - dt4_mean)*((dt4_l0_12) - dt4_mean) + ((dt4_l0_13) - dt4_mean)*((dt4_l0_13) - dt4_mean) + ((dt4_l0_14) - dt4_mean)*((dt4_l0_14) - dt4_mean) + ((dt4_l0_15) - dt4_mean)*((dt4_l0_15) - dt4_mean) + ((dt4_l0_16) - dt4_mean)*((dt4_l0_16) - dt4_mean) + ((dt4_l0_17) - dt4_mean)*((dt4_l0_17) - dt4_mean) + ((dt4_l0_18) - dt4_mean)*((dt4_l0_18) - dt4_mean) + ((dt4_l0_19) - dt4_mean)*((dt4_l0_19) - dt4_mean) + ((dt4_l0_20) - dt4_mean)*((dt4_l0_20) - dt4_mean) + ((dt4_l0_21) - dt4_mean)*((dt4_l0_21) - dt4_mean) + ((dt4_l0_22) - dt4_mean)*((dt4_l0_22) - dt4_mean) + ((dt4_l0_23) - dt4_mean)*((dt4_l0_23) - dt4_mean) + ((dt4_l0_24) - dt4_mean)*((dt4_l0_24) - dt4_mean) + ((dt4_l0_25) - dt4_mean)*((dt4_l0_25) - dt4_mean) + ((dt4_l0_26) - dt4_mean)*((dt4_l0_26) - dt4_mean) + ((dt4_l0_27) - dt4_mean)*((dt4_l0_27) - dt4_mean) + ((dt4_l0_28) - dt4_mean)*((dt4_l0_28) - dt4_mean) + ((dt4_l0_29) - dt4_mean)*((dt4_l0_29) - dt4_mean) + ((dt4_l0_30) - dt4_mean)*((dt4_l0_30) - dt4_mean) + ((dt4_l0_31) - dt4_mean)*((dt4_l0_31) - dt4_mean)) / 32;
    dt4_n0_0 = (((dt4_l0_0) - dt4_mean) / sqrt(dt4_var + ln_eps)) * (1.1696591377258301) + (-0.11109431833028793);
    dt4_g0_0 = gelu_approx(dt4_n0_0);
    dt4_n0_1 = (((dt4_l0_1) - dt4_mean) / sqrt(dt4_var + ln_eps)) * (1.1050513982772827) + (-0.035068709403276443);
    dt4_g0_1 = gelu_approx(dt4_n0_1);
    dt4_n0_2 = (((dt4_l0_2) - dt4_mean) / sqrt(dt4_var + ln_eps)) * (1.04068922996521) + (-0.089032895863056183);
    dt4_g0_2 = gelu_approx(dt4_n0_2);
    dt4_n0_3 = (((dt4_l0_3) - dt4_mean) / sqrt(dt4_var + ln_eps)) * (0.67314571142196655) + (-0.25178694725036621);
    dt4_g0_3 = gelu_approx(dt4_n0_3);
    dt4_n0_4 = (((dt4_l0_4) - dt4_mean) / sqrt(dt4_var + ln_eps)) * (0.85388195514678955) + (-0.12780840694904327);
    dt4_g0_4 = gelu_approx(dt4_n0_4);
    dt4_n0_5 = (((dt4_l0_5) - dt4_mean) / sqrt(dt4_var + ln_eps)) * (1.2238403558731079) + (-0.017596408724784851);
    dt4_g0_5 = gelu_approx(dt4_n0_5);
    dt4_n0_6 = (((dt4_l0_6) - dt4_mean) / sqrt(dt4_var + ln_eps)) * (0.98674929141998291) + (-0.047802694141864777);
    dt4_g0_6 = gelu_approx(dt4_n0_6);
    dt4_n0_7 = (((dt4_l0_7) - dt4_mean) / sqrt(dt4_var + ln_eps)) * (0.73881924152374268) + (-0.26099607348442078);
    dt4_g0_7 = gelu_approx(dt4_n0_7);
    dt4_n0_8 = (((dt4_l0_8) - dt4_mean) / sqrt(dt4_var + ln_eps)) * (1.0608246326446533) + (-0.078888535499572754);
    dt4_g0_8 = gelu_approx(dt4_n0_8);
    dt4_n0_9 = (((dt4_l0_9) - dt4_mean) / sqrt(dt4_var + ln_eps)) * (0.785602867603302) + (-0.15794672071933746);
    dt4_g0_9 = gelu_approx(dt4_n0_9);
    dt4_n0_10 = (((dt4_l0_10) - dt4_mean) / sqrt(dt4_var + ln_eps)) * (1.020018458366394) + (-0.036895915865898132);
    dt4_g0_10 = gelu_approx(dt4_n0_10);
    dt4_n0_11 = (((dt4_l0_11) - dt4_mean) / sqrt(dt4_var + ln_eps)) * (0.85727518796920776) + (-0.12107124924659729);
    dt4_g0_11 = gelu_approx(dt4_n0_11);
    dt4_n0_12 = (((dt4_l0_12) - dt4_mean) / sqrt(dt4_var + ln_eps)) * (0.72308427095413208) + (-0.25479298830032349);
    dt4_g0_12 = gelu_approx(dt4_n0_12);
    dt4_n0_13 = (((dt4_l0_13) - dt4_mean) / sqrt(dt4_var + ln_eps)) * (0.86266148090362549) + (-0.14110274612903595);
    dt4_g0_13 = gelu_approx(dt4_n0_13);
    dt4_n0_14 = (((dt4_l0_14) - dt4_mean) / sqrt(dt4_var + ln_eps)) * (0.74258971214294434) + (-0.25694161653518677);
    dt4_g0_14 = gelu_approx(dt4_n0_14);
    dt4_n0_15 = (((dt4_l0_15) - dt4_mean) / sqrt(dt4_var + ln_eps)) * (1.0297513008117676) + (-0.048506777733564377);
    dt4_g0_15 = gelu_approx(dt4_n0_15);
    dt4_n0_16 = (((dt4_l0_16) - dt4_mean) / sqrt(dt4_var + ln_eps)) * (1.6998714208602905) + (0.031608574092388153);
    dt4_g0_16 = gelu_approx(dt4_n0_16);
    dt4_n0_17 = (((dt4_l0_17) - dt4_mean) / sqrt(dt4_var + ln_eps)) * (1.0622228384017944) + (-0.10873574018478394);
    dt4_g0_17 = gelu_approx(dt4_n0_17);
    dt4_n0_18 = (((dt4_l0_18) - dt4_mean) / sqrt(dt4_var + ln_eps)) * (0.84898489713668823) + (-0.16742095351219177);
    dt4_g0_18 = gelu_approx(dt4_n0_18);
    dt4_n0_19 = (((dt4_l0_19) - dt4_mean) / sqrt(dt4_var + ln_eps)) * (1.0004963874816895) + (-0.040494922548532486);
    dt4_g0_19 = gelu_approx(dt4_n0_19);
    dt4_n0_20 = (((dt4_l0_20) - dt4_mean) / sqrt(dt4_var + ln_eps)) * (0.81684249639511108) + (-0.19029967486858368);
    dt4_g0_20 = gelu_approx(dt4_n0_20);
    dt4_n0_21 = (((dt4_l0_21) - dt4_mean) / sqrt(dt4_var + ln_eps)) * (0.78132253885269165) + (-0.19372616708278656);
    dt4_g0_21 = gelu_approx(dt4_n0_21);
    dt4_n0_22 = (((dt4_l0_22) - dt4_mean) / sqrt(dt4_var + ln_eps)) * (1.074562668800354) + (-0.079838313162326813);
    dt4_g0_22 = gelu_approx(dt4_n0_22);
    dt4_n0_23 = (((dt4_l0_23) - dt4_mean) / sqrt(dt4_var + ln_eps)) * (0.83421492576599121) + (-0.17514687776565552);
    dt4_g0_23 = gelu_approx(dt4_n0_23);
    dt4_n0_24 = (((dt4_l0_24) - dt4_mean) / sqrt(dt4_var + ln_eps)) * (1.1784040927886963) + (-0.0051487316377460957);
    dt4_g0_24 = gelu_approx(dt4_n0_24);
    dt4_n0_25 = (((dt4_l0_25) - dt4_mean) / sqrt(dt4_var + ln_eps)) * (0.83455449342727661) + (-0.13809368014335632);
    dt4_g0_25 = gelu_approx(dt4_n0_25);
    dt4_n0_26 = (((dt4_l0_26) - dt4_mean) / sqrt(dt4_var + ln_eps)) * (1.1395912170410156) + (-0.027733271941542625);
    dt4_g0_26 = gelu_approx(dt4_n0_26);
    dt4_n0_27 = (((dt4_l0_27) - dt4_mean) / sqrt(dt4_var + ln_eps)) * (0.98487979173660278) + (-0.08256356418132782);
    dt4_g0_27 = gelu_approx(dt4_n0_27);
    dt4_n0_28 = (((dt4_l0_28) - dt4_mean) / sqrt(dt4_var + ln_eps)) * (1.519499659538269) + (-0.030904548242688179);
    dt4_g0_28 = gelu_approx(dt4_n0_28);
    dt4_n0_29 = (((dt4_l0_29) - dt4_mean) / sqrt(dt4_var + ln_eps)) * (0.75068819522857666) + (-0.20771928131580353);
    dt4_g0_29 = gelu_approx(dt4_n0_29);
    dt4_n0_30 = (((dt4_l0_30) - dt4_mean) / sqrt(dt4_var + ln_eps)) * (0.88442128896713257) + (-0.090217843651771545);
    dt4_g0_30 = gelu_approx(dt4_n0_30);
    dt4_n0_31 = (((dt4_l0_31) - dt4_mean) / sqrt(dt4_var + ln_eps)) * (0.94935429096221924) + (-0.040492460131645203);
    dt4_g0_31 = gelu_approx(dt4_n0_31);
    dt4_l1_0 = -0.046900030225515366;
    dt4_l1_0 = dt4_l1_0 + (-0.16293072700500488)*dt4_g0_0;
    dt4_l1_0 = dt4_l1_0 + (-0.16474521160125732)*dt4_g0_1;
    dt4_l1_0 = dt4_l1_0 + (0.26976498961448669)*dt4_g0_2;
    dt4_l1_0 = dt4_l1_0 + (-0.091086529195308685)*dt4_g0_3;
    dt4_l1_0 = dt4_l1_0 + (0.039857111871242523)*dt4_g0_4;
    dt4_l1_0 = dt4_l1_0 + (-0.36768817901611328)*dt4_g0_5;
    dt4_l1_0 = dt4_l1_0 + (0.029776940122246742)*dt4_g0_6;
    dt4_l1_0 = dt4_l1_0 + (0.0019191652536392212)*dt4_g0_7;
    dt4_l1_0 = dt4_l1_0 + (0.22635605931282043)*dt4_g0_8;
    dt4_l1_0 = dt4_l1_0 + (0.0014309659600257874)*dt4_g0_9;
    dt4_l1_0 = dt4_l1_0 + (-0.18940156698226929)*dt4_g0_10;
    dt4_l1_0 = dt4_l1_0 + (0.001589158084243536)*dt4_g0_11;
    dt4_l1_0 = dt4_l1_0 + (-0.079506546258926392)*dt4_g0_12;
    dt4_l1_0 = dt4_l1_0 + (-0.1057610958814621)*dt4_g0_13;
    dt4_l1_0 = dt4_l1_0 + (0.073466688394546509)*dt4_g0_14;
    dt4_l1_0 = dt4_l1_0 + (0.071385860443115234)*dt4_g0_15;
    dt4_l1_0 = dt4_l1_0 + (-0.085049651563167572)*dt4_g0_16;
    dt4_l1_0 = dt4_l1_0 + (0.048108115792274475)*dt4_g0_17;
    dt4_l1_0 = dt4_l1_0 + (0.037839200347661972)*dt4_g0_18;
    dt4_l1_0 = dt4_l1_0 + (0.008063427172601223)*dt4_g0_19;
    dt4_l1_0 = dt4_l1_0 + (-0.035607509315013885)*dt4_g0_20;
    dt4_l1_0 = dt4_l1_0 + (-0.0510379858314991)*dt4_g0_21;
    dt4_l1_0 = dt4_l1_0 + (0.048532266169786453)*dt4_g0_22;
    dt4_l1_0 = dt4_l1_0 + (0.096789225935935974)*dt4_g0_23;
    dt4_l1_0 = dt4_l1_0 + (0.2037883996963501)*dt4_g0_24;
    dt4_l1_0 = dt4_l1_0 + (0.13214650750160217)*dt4_g0_25;
    dt4_l1_0 = dt4_l1_0 + (0.1620766818523407)*dt4_g0_26;
    dt4_l1_0 = dt4_l1_0 + (0.10560188442468643)*dt4_g0_27;
    dt4_l1_0 = dt4_l1_0 + (-0.38243672251701355)*dt4_g0_28;
    dt4_l1_0 = dt4_l1_0 + (0.036945246160030365)*dt4_g0_29;
    dt4_l1_0 = dt4_l1_0 + (0.017235111445188522)*dt4_g0_30;
    dt4_l1_0 = dt4_l1_0 + (-0.0079529397189617157)*dt4_g0_31;
    dt4_l1_1 = -0.1650557667016983;
    dt4_l1_1 = dt4_l1_1 + (-0.28834861516952515)*dt4_g0_0;
    dt4_l1_1 = dt4_l1_1 + (-0.25788521766662598)*dt4_g0_1;
    dt4_l1_1 = dt4_l1_1 + (0.15913346409797668)*dt4_g0_2;
    dt4_l1_1 = dt4_l1_1 + (0.027718981727957726)*dt4_g0_3;
    dt4_l1_1 = dt4_l1_1 + (0.10900557786226273)*dt4_g0_4;
    dt4_l1_1 = dt4_l1_1 + (0.11376988142728806)*dt4_g0_5;
    dt4_l1_1 = dt4_l1_1 + (0.19892121851444244)*dt4_g0_6;
    dt4_l1_1 = dt4_l1_1 + (0.089453563094139099)*dt4_g0_7;
    dt4_l1_1 = dt4_l1_1 + (0.14389055967330933)*dt4_g0_8;
    dt4_l1_1 = dt4_l1_1 + (-0.030847437679767609)*dt4_g0_9;
    dt4_l1_1 = dt4_l1_1 + (-0.047776956111192703)*dt4_g0_10;
    dt4_l1_1 = dt4_l1_1 + (0.040948741137981415)*dt4_g0_11;
    dt4_l1_1 = dt4_l1_1 + (0.023026715964078903)*dt4_g0_12;
    dt4_l1_1 = dt4_l1_1 + (-0.019706688821315765)*dt4_g0_13;
    dt4_l1_1 = dt4_l1_1 + (-0.096261724829673767)*dt4_g0_14;
    dt4_l1_1 = dt4_l1_1 + (-0.20225909352302551)*dt4_g0_15;
    dt4_l1_1 = dt4_l1_1 + (-0.13004162907600403)*dt4_g0_16;
    dt4_l1_1 = dt4_l1_1 + (0.066044040024280548)*dt4_g0_17;
    dt4_l1_1 = dt4_l1_1 + (0.15169130265712738)*dt4_g0_18;
    dt4_l1_1 = dt4_l1_1 + (-0.079691514372825623)*dt4_g0_19;
    dt4_l1_1 = dt4_l1_1 + (-0.15136595070362091)*dt4_g0_20;
    dt4_l1_1 = dt4_l1_1 + (-0.11996348202228546)*dt4_g0_21;
    dt4_l1_1 = dt4_l1_1 + (0.096818938851356506)*dt4_g0_22;
    dt4_l1_1 = dt4_l1_1 + (0.017230300232768059)*dt4_g0_23;
    dt4_l1_1 = dt4_l1_1 + (-0.23509146273136139)*dt4_g0_24;
    dt4_l1_1 = dt4_l1_1 + (-0.053033959120512009)*dt4_g0_25;
    dt4_l1_1 = dt4_l1_1 + (0.35057505965232849)*dt4_g0_26;
    dt4_l1_1 = dt4_l1_1 + (-0.11318153887987137)*dt4_g0_27;
    dt4_l1_1 = dt4_l1_1 + (0.25067627429962158)*dt4_g0_28;
    dt4_l1_1 = dt4_l1_1 + (0.060550738126039505)*dt4_g0_29;
    dt4_l1_1 = dt4_l1_1 + (-0.11033059656620026)*dt4_g0_30;
    dt4_l1_1 = dt4_l1_1 + (0.10683048516511917)*dt4_g0_31;
    dt4_l1_2 = 0.040588255971670151;
    dt4_l1_2 = dt4_l1_2 + (0.01313297264277935)*dt4_g0_0;
    dt4_l1_2 = dt4_l1_2 + (0.21187171339988708)*dt4_g0_1;
    dt4_l1_2 = dt4_l1_2 + (0.055051211267709732)*dt4_g0_2;
    dt4_l1_2 = dt4_l1_2 + (0.081240192055702209)*dt4_g0_3;
    dt4_l1_2 = dt4_l1_2 + (0.11177189648151398)*dt4_g0_4;
    dt4_l1_2 = dt4_l1_2 + (-0.023280186578631401)*dt4_g0_5;
    dt4_l1_2 = dt4_l1_2 + (0.10673881322145462)*dt4_g0_6;
    dt4_l1_2 = dt4_l1_2 + (0.0054689659737050533)*dt4_g0_7;
    dt4_l1_2 = dt4_l1_2 + (-0.190908282995224)*dt4_g0_8;
    dt4_l1_2 = dt4_l1_2 + (-0.13047152757644653)*dt4_g0_9;
    dt4_l1_2 = dt4_l1_2 + (0.10141438245773315)*dt4_g0_10;
    dt4_l1_2 = dt4_l1_2 + (0.12788000702857971)*dt4_g0_11;
    dt4_l1_2 = dt4_l1_2 + (-0.078461281955242157)*dt4_g0_12;
    dt4_l1_2 = dt4_l1_2 + (0.05843580886721611)*dt4_g0_13;
    dt4_l1_2 = dt4_l1_2 + (0.055245514959096909)*dt4_g0_14;
    dt4_l1_2 = dt4_l1_2 + (0.026272119954228401)*dt4_g0_15;
    dt4_l1_2 = dt4_l1_2 + (-0.31216931343078613)*dt4_g0_16;
    dt4_l1_2 = dt4_l1_2 + (0.1585162878036499)*dt4_g0_17;
    dt4_l1_2 = dt4_l1_2 + (-0.047532562166452408)*dt4_g0_18;
    dt4_l1_2 = dt4_l1_2 + (0.0034459442831575871)*dt4_g0_19;
    dt4_l1_2 = dt4_l1_2 + (-0.073009148240089417)*dt4_g0_20;
    dt4_l1_2 = dt4_l1_2 + (0.063850387930870056)*dt4_g0_21;
    dt4_l1_2 = dt4_l1_2 + (0.20695371925830841)*dt4_g0_22;
    dt4_l1_2 = dt4_l1_2 + (0.084927849471569061)*dt4_g0_23;
    dt4_l1_2 = dt4_l1_2 + (-0.17805205285549164)*dt4_g0_24;
    dt4_l1_2 = dt4_l1_2 + (0.043571438640356064)*dt4_g0_25;
    dt4_l1_2 = dt4_l1_2 + (-0.28430473804473877)*dt4_g0_26;
    dt4_l1_2 = dt4_l1_2 + (0.046519283205270767)*dt4_g0_27;
    dt4_l1_2 = dt4_l1_2 + (0.13506217300891876)*dt4_g0_28;
    dt4_l1_2 = dt4_l1_2 + (0.080001845955848694)*dt4_g0_29;
    dt4_l1_2 = dt4_l1_2 + (0.094780534505844116)*dt4_g0_30;
    dt4_l1_2 = dt4_l1_2 + (-0.14838580787181854)*dt4_g0_31;
    dt4_l1_3 = 0.03006674163043499;
    dt4_l1_3 = dt4_l1_3 + (-0.35364684462547302)*dt4_g0_0;
    dt4_l1_3 = dt4_l1_3 + (-0.17629177868366241)*dt4_g0_1;
    dt4_l1_3 = dt4_l1_3 + (0.022153474390506744)*dt4_g0_2;
    dt4_l1_3 = dt4_l1_3 + (0.18007884919643402)*dt4_g0_3;
    dt4_l1_3 = dt4_l1_3 + (0.10401297360658646)*dt4_g0_4;
    dt4_l1_3 = dt4_l1_3 + (0.051684357225894928)*dt4_g0_5;
    dt4_l1_3 = dt4_l1_3 + (-0.075068175792694092)*dt4_g0_6;
    dt4_l1_3 = dt4_l1_3 + (-0.059393569827079773)*dt4_g0_7;
    dt4_l1_3 = dt4_l1_3 + (0.15978445112705231)*dt4_g0_8;
    dt4_l1_3 = dt4_l1_3 + (-0.12649829685688019)*dt4_g0_9;
    dt4_l1_3 = dt4_l1_3 + (-0.262550950050354)*dt4_g0_10;
    dt4_l1_3 = dt4_l1_3 + (0.061393164098262787)*dt4_g0_11;
    dt4_l1_3 = dt4_l1_3 + (0.065222702920436859)*dt4_g0_12;
    dt4_l1_3 = dt4_l1_3 + (-0.062185466289520264)*dt4_g0_13;
    dt4_l1_3 = dt4_l1_3 + (-0.067431561648845673)*dt4_g0_14;
    dt4_l1_3 = dt4_l1_3 + (-0.19861984252929688)*dt4_g0_15;
    dt4_l1_3 = dt4_l1_3 + (0.64975041151046753)*dt4_g0_16;
    dt4_l1_3 = dt4_l1_3 + (-0.10373525321483612)*dt4_g0_17;
    dt4_l1_3 = dt4_l1_3 + (-0.051274355500936508)*dt4_g0_18;
    dt4_l1_3 = dt4_l1_3 + (0.1738811731338501)*dt4_g0_19;
    dt4_l1_3 = dt4_l1_3 + (-0.064860448241233826)*dt4_g0_20;
    dt4_l1_3 = dt4_l1_3 + (0.13006292283535004)*dt4_g0_21;
    dt4_l1_3 = dt4_l1_3 + (0.039197433739900589)*dt4_g0_22;
    dt4_l1_3 = dt4_l1_3 + (0.11295291036367416)*dt4_g0_23;
    dt4_l1_3 = dt4_l1_3 + (0.039528913795948029)*dt4_g0_24;
    dt4_l1_3 = dt4_l1_3 + (0.13462246954441071)*dt4_g0_25;
    dt4_l1_3 = dt4_l1_3 + (0.074103392660617828)*dt4_g0_26;
    dt4_l1_3 = dt4_l1_3 + (-0.0064598540775477886)*dt4_g0_27;
    dt4_l1_3 = dt4_l1_3 + (-0.24211853742599487)*dt4_g0_28;
    dt4_l1_3 = dt4_l1_3 + (0.093256272375583649)*dt4_g0_29;
    dt4_l1_3 = dt4_l1_3 + (-0.17873191833496094)*dt4_g0_30;
    dt4_l1_3 = dt4_l1_3 + (0.13665640354156494)*dt4_g0_31;
    dt4_l1_4 = 0.12263526022434235;
    dt4_l1_4 = dt4_l1_4 + (0.17370125651359558)*dt4_g0_0;
    dt4_l1_4 = dt4_l1_4 + (-0.083672083914279938)*dt4_g0_1;
    dt4_l1_4 = dt4_l1_4 + (-0.058013491332530975)*dt4_g0_2;
    dt4_l1_4 = dt4_l1_4 + (0.030379418283700943)*dt4_g0_3;
    dt4_l1_4 = dt4_l1_4 + (-0.03496987372636795)*dt4_g0_4;
    dt4_l1_4 = dt4_l1_4 + (-0.34480535984039307)*dt4_g0_5;
    dt4_l1_4 = dt4_l1_4 + (0.18003655970096588)*dt4_g0_6;
    dt4_l1_4 = dt4_l1_4 + (-0.012501563876867294)*dt4_g0_7;
    dt4_l1_4 = dt4_l1_4 + (0.10306855291128159)*dt4_g0_8;
    dt4_l1_4 = dt4_l1_4 + (0.0010572918690741062)*dt4_g0_9;
    dt4_l1_4 = dt4_l1_4 + (0.22152738273143768)*dt4_g0_10;
    dt4_l1_4 = dt4_l1_4 + (-0.046255137771368027)*dt4_g0_11;
    dt4_l1_4 = dt4_l1_4 + (0.078009523451328278)*dt4_g0_12;
    dt4_l1_4 = dt4_l1_4 + (0.066000305116176605)*dt4_g0_13;
    dt4_l1_4 = dt4_l1_4 + (-0.13832651078701019)*dt4_g0_14;
    dt4_l1_4 = dt4_l1_4 + (0.15796451270580292)*dt4_g0_15;
    dt4_l1_4 = dt4_l1_4 + (0.050529871135950089)*dt4_g0_16;
    dt4_l1_4 = dt4_l1_4 + (0.21294906735420227)*dt4_g0_17;
    dt4_l1_4 = dt4_l1_4 + (-0.12090930342674255)*dt4_g0_18;
    dt4_l1_4 = dt4_l1_4 + (-0.068031854927539825)*dt4_g0_19;
    dt4_l1_4 = dt4_l1_4 + (-0.10580087453126907)*dt4_g0_20;
    dt4_l1_4 = dt4_l1_4 + (-0.0046419226564466953)*dt4_g0_21;
    dt4_l1_4 = dt4_l1_4 + (-0.082880429923534393)*dt4_g0_22;
    dt4_l1_4 = dt4_l1_4 + (-0.032585814595222473)*dt4_g0_23;
    dt4_l1_4 = dt4_l1_4 + (-0.10039889067411423)*dt4_g0_24;
    dt4_l1_4 = dt4_l1_4 + (0.11109044402837753)*dt4_g0_25;
    dt4_l1_4 = dt4_l1_4 + (-0.080455757677555084)*dt4_g0_26;
    dt4_l1_4 = dt4_l1_4 + (0.0014013194013386965)*dt4_g0_27;
    dt4_l1_4 = dt4_l1_4 + (-0.15381021797657013)*dt4_g0_28;
    dt4_l1_4 = dt4_l1_4 + (0.05111057311296463)*dt4_g0_29;
    dt4_l1_4 = dt4_l1_4 + (0.076669268310070038)*dt4_g0_30;
    dt4_l1_4 = dt4_l1_4 + (-0.17469201982021332)*dt4_g0_31;
    dt4_l1_5 = -0.051718160510063171;
    dt4_l1_5 = dt4_l1_5 + (0.12622646987438202)*dt4_g0_0;
    dt4_l1_5 = dt4_l1_5 + (0.15407618880271912)*dt4_g0_1;
    dt4_l1_5 = dt4_l1_5 + (0.1102263480424881)*dt4_g0_2;
    dt4_l1_5 = dt4_l1_5 + (0.081044577062129974)*dt4_g0_3;
    dt4_l1_5 = dt4_l1_5 + (0.15326599776744843)*dt4_g0_4;
    dt4_l1_5 = dt4_l1_5 + (0.064281925559043884)*dt4_g0_5;
    dt4_l1_5 = dt4_l1_5 + (-0.21500757336616516)*dt4_g0_6;
    dt4_l1_5 = dt4_l1_5 + (0.098096363246440887)*dt4_g0_7;
    dt4_l1_5 = dt4_l1_5 + (-0.035208825021982193)*dt4_g0_8;
    dt4_l1_5 = dt4_l1_5 + (-0.029627483338117599)*dt4_g0_9;
    dt4_l1_5 = dt4_l1_5 + (0.23539173603057861)*dt4_g0_10;
    dt4_l1_5 = dt4_l1_5 + (-0.059684157371520996)*dt4_g0_11;
    dt4_l1_5 = dt4_l1_5 + (0.18764948844909668)*dt4_g0_12;
    dt4_l1_5 = dt4_l1_5 + (-0.10946971923112869)*dt4_g0_13;
    dt4_l1_5 = dt4_l1_5 + (-0.058492869138717651)*dt4_g0_14;
    dt4_l1_5 = dt4_l1_5 + (0.29810228943824768)*dt4_g0_15;
    dt4_l1_5 = dt4_l1_5 + (-0.25540083646774292)*dt4_g0_16;
    dt4_l1_5 = dt4_l1_5 + (-0.25962957739830017)*dt4_g0_17;
    dt4_l1_5 = dt4_l1_5 + (0.07244226336479187)*dt4_g0_18;
    dt4_l1_5 = dt4_l1_5 + (-0.015826232731342316)*dt4_g0_19;
    dt4_l1_5 = dt4_l1_5 + (-0.13939377665519714)*dt4_g0_20;
    dt4_l1_5 = dt4_l1_5 + (-0.034775912761688232)*dt4_g0_21;
    dt4_l1_5 = dt4_l1_5 + (-0.21197742223739624)*dt4_g0_22;
    dt4_l1_5 = dt4_l1_5 + (-0.10610435903072357)*dt4_g0_23;
    dt4_l1_5 = dt4_l1_5 + (0.053570564836263657)*dt4_g0_24;
    dt4_l1_5 = dt4_l1_5 + (0.040605675429105759)*dt4_g0_25;
    dt4_l1_5 = dt4_l1_5 + (0.023010404780507088)*dt4_g0_26;
    dt4_l1_5 = dt4_l1_5 + (0.12137638777494431)*dt4_g0_27;
    dt4_l1_5 = dt4_l1_5 + (0.23015812039375305)*dt4_g0_28;
    dt4_l1_5 = dt4_l1_5 + (0.06396755576133728)*dt4_g0_29;
    dt4_l1_5 = dt4_l1_5 + (-0.11600128561258316)*dt4_g0_30;
    dt4_l1_5 = dt4_l1_5 + (0.0018161108018830419)*dt4_g0_31;
    dt4_l1_6 = -0.14502783119678497;
    dt4_l1_6 = dt4_l1_6 + (-0.21617880463600159)*dt4_g0_0;
    dt4_l1_6 = dt4_l1_6 + (0.024907056242227554)*dt4_g0_1;
    dt4_l1_6 = dt4_l1_6 + (0.28527197241783142)*dt4_g0_2;
    dt4_l1_6 = dt4_l1_6 + (-0.10465603321790695)*dt4_g0_3;
    dt4_l1_6 = dt4_l1_6 + (0.004011248704046011)*dt4_g0_4;
    dt4_l1_6 = dt4_l1_6 + (0.11178028583526611)*dt4_g0_5;
    dt4_l1_6 = dt4_l1_6 + (0.13247388601303101)*dt4_g0_6;
    dt4_l1_6 = dt4_l1_6 + (0.17205116152763367)*dt4_g0_7;
    dt4_l1_6 = dt4_l1_6 + (0.017789272591471672)*dt4_g0_8;
    dt4_l1_6 = dt4_l1_6 + (0.0079919397830963135)*dt4_g0_9;
    dt4_l1_6 = dt4_l1_6 + (-0.17143863439559937)*dt4_g0_10;
    dt4_l1_6 = dt4_l1_6 + (-0.090974859893321991)*dt4_g0_11;
    dt4_l1_6 = dt4_l1_6 + (0.00026911767781712115)*dt4_g0_12;
    dt4_l1_6 = dt4_l1_6 + (0.12699028849601746)*dt4_g0_13;
    dt4_l1_6 = dt4_l1_6 + (0.012657118029892445)*dt4_g0_14;
    dt4_l1_6 = dt4_l1_6 + (0.014249536208808422)*dt4_g0_15;
    dt4_l1_6 = dt4_l1_6 + (0.29837688803672791)*dt4_g0_16;
    dt4_l1_6 = dt4_l1_6 + (0.10275484621524811)*dt4_g0_17;
    dt4_l1_6 = dt4_l1_6 + (-0.052840493619441986)*dt4_g0_18;
    dt4_l1_6 = dt4_l1_6 + (-0.064061515033245087)*dt4_g0_19;
    dt4_l1_6 = dt4_l1_6 + (0.084928445518016815)*dt4_g0_20;
    dt4_l1_6 = dt4_l1_6 + (-0.10871539264917374)*dt4_g0_21;
    dt4_l1_6 = dt4_l1_6 + (0.17323924601078033)*dt4_g0_22;
    dt4_l1_6 = dt4_l1_6 + (0.063852109014987946)*dt4_g0_23;
    dt4_l1_6 = dt4_l1_6 + (-0.054064754396677017)*dt4_g0_24;
    dt4_l1_6 = dt4_l1_6 + (-0.096406780183315277)*dt4_g0_25;
    dt4_l1_6 = dt4_l1_6 + (0.034694094210863113)*dt4_g0_26;
    dt4_l1_6 = dt4_l1_6 + (-0.040985178202390671)*dt4_g0_27;
    dt4_l1_6 = dt4_l1_6 + (-0.1414448469877243)*dt4_g0_28;
    dt4_l1_6 = dt4_l1_6 + (-0.18324244022369385)*dt4_g0_29;
    dt4_l1_6 = dt4_l1_6 + (-0.0061641675420105457)*dt4_g0_30;
    dt4_l1_6 = dt4_l1_6 + (0.14373365044593811)*dt4_g0_31;
    dt4_l1_7 = 0.15039798617362976;
    dt4_l1_7 = dt4_l1_7 + (0.047673169523477554)*dt4_g0_0;
    dt4_l1_7 = dt4_l1_7 + (0.072389706969261169)*dt4_g0_1;
    dt4_l1_7 = dt4_l1_7 + (-0.065495222806930542)*dt4_g0_2;
    dt4_l1_7 = dt4_l1_7 + (-0.037528026849031448)*dt4_g0_3;
    dt4_l1_7 = dt4_l1_7 + (-0.10889255255460739)*dt4_g0_4;
    dt4_l1_7 = dt4_l1_7 + (0.11605526506900787)*dt4_g0_5;
    dt4_l1_7 = dt4_l1_7 + (-0.026777036488056183)*dt4_g0_6;
    dt4_l1_7 = dt4_l1_7 + (-0.028399230912327766)*dt4_g0_7;
    dt4_l1_7 = dt4_l1_7 + (0.047372490167617798)*dt4_g0_8;
    dt4_l1_7 = dt4_l1_7 + (-0.012069370597600937)*dt4_g0_9;
    dt4_l1_7 = dt4_l1_7 + (-0.083184346556663513)*dt4_g0_10;
    dt4_l1_7 = dt4_l1_7 + (0.02154984325170517)*dt4_g0_11;
    dt4_l1_7 = dt4_l1_7 + (-0.040346946567296982)*dt4_g0_12;
    dt4_l1_7 = dt4_l1_7 + (-0.16211129724979401)*dt4_g0_13;
    dt4_l1_7 = dt4_l1_7 + (0.13870799541473389)*dt4_g0_14;
    dt4_l1_7 = dt4_l1_7 + (-0.19581884145736694)*dt4_g0_15;
    dt4_l1_7 = dt4_l1_7 + (-0.1117430180311203)*dt4_g0_16;
    dt4_l1_7 = dt4_l1_7 + (0.17394495010375977)*dt4_g0_17;
    dt4_l1_7 = dt4_l1_7 + (-0.00035679028951562941)*dt4_g0_18;
    dt4_l1_7 = dt4_l1_7 + (-0.048673704266548157)*dt4_g0_19;
    dt4_l1_7 = dt4_l1_7 + (0.15421126782894135)*dt4_g0_20;
    dt4_l1_7 = dt4_l1_7 + (0.13505768775939941)*dt4_g0_21;
    dt4_l1_7 = dt4_l1_7 + (0.036396581679582596)*dt4_g0_22;
    dt4_l1_7 = dt4_l1_7 + (0.0034029996022582054)*dt4_g0_23;
    dt4_l1_7 = dt4_l1_7 + (-0.24609997868537903)*dt4_g0_24;
    dt4_l1_7 = dt4_l1_7 + (0.15485222637653351)*dt4_g0_25;
    dt4_l1_7 = dt4_l1_7 + (-0.073318503797054291)*dt4_g0_26;
    dt4_l1_7 = dt4_l1_7 + (0.050975963473320007)*dt4_g0_27;
    dt4_l1_7 = dt4_l1_7 + (0.016177339479327202)*dt4_g0_28;
    dt4_l1_7 = dt4_l1_7 + (0.069688819348812103)*dt4_g0_29;
    dt4_l1_7 = dt4_l1_7 + (0.070944041013717651)*dt4_g0_30;
    dt4_l1_7 = dt4_l1_7 + (0.11156594753265381)*dt4_g0_31;
    dt4_l1_8 = 0.17791567742824554;
    dt4_l1_8 = dt4_l1_8 + (-0.071427121758460999)*dt4_g0_0;
    dt4_l1_8 = dt4_l1_8 + (-0.014428609050810337)*dt4_g0_1;
    dt4_l1_8 = dt4_l1_8 + (-0.1958298534154892)*dt4_g0_2;
    dt4_l1_8 = dt4_l1_8 + (-0.16039794683456421)*dt4_g0_3;
    dt4_l1_8 = dt4_l1_8 + (-0.13343974947929382)*dt4_g0_4;
    dt4_l1_8 = dt4_l1_8 + (0.26373711228370667)*dt4_g0_5;
    dt4_l1_8 = dt4_l1_8 + (0.017795341089367867)*dt4_g0_6;
    dt4_l1_8 = dt4_l1_8 + (-0.021144472062587738)*dt4_g0_7;
    dt4_l1_8 = dt4_l1_8 + (-0.23094122111797333)*dt4_g0_8;
    dt4_l1_8 = dt4_l1_8 + (0.073461614549160004)*dt4_g0_9;
    dt4_l1_8 = dt4_l1_8 + (0.11966696381568909)*dt4_g0_10;
    dt4_l1_8 = dt4_l1_8 + (0.17676906287670135)*dt4_g0_11;
    dt4_l1_8 = dt4_l1_8 + (-0.048930056393146515)*dt4_g0_12;
    dt4_l1_8 = dt4_l1_8 + (-0.14716175198554993)*dt4_g0_13;
    dt4_l1_8 = dt4_l1_8 + (0.11388258635997772)*dt4_g0_14;
    dt4_l1_8 = dt4_l1_8 + (0.082485564053058624)*dt4_g0_15;
    dt4_l1_8 = dt4_l1_8 + (0.46304497122764587)*dt4_g0_16;
    dt4_l1_8 = dt4_l1_8 + (0.00068784336326643825)*dt4_g0_17;
    dt4_l1_8 = dt4_l1_8 + (0.10457544773817062)*dt4_g0_18;
    dt4_l1_8 = dt4_l1_8 + (-0.0063994922675192356)*dt4_g0_19;
    dt4_l1_8 = dt4_l1_8 + (-0.14240989089012146)*dt4_g0_20;
    dt4_l1_8 = dt4_l1_8 + (-0.048434056341648102)*dt4_g0_21;
    dt4_l1_8 = dt4_l1_8 + (0.16329094767570496)*dt4_g0_22;
    dt4_l1_8 = dt4_l1_8 + (-0.080508217215538025)*dt4_g0_23;
    dt4_l1_8 = dt4_l1_8 + (0.18204766511917114)*dt4_g0_24;
    dt4_l1_8 = dt4_l1_8 + (-0.094055630266666412)*dt4_g0_25;
    dt4_l1_8 = dt4_l1_8 + (-0.12780973315238953)*dt4_g0_26;
    dt4_l1_8 = dt4_l1_8 + (-0.11680302768945694)*dt4_g0_27;
    dt4_l1_8 = dt4_l1_8 + (0.25664985179901123)*dt4_g0_28;
    dt4_l1_8 = dt4_l1_8 + (0.050704926252365112)*dt4_g0_29;
    dt4_l1_8 = dt4_l1_8 + (0.1178852841258049)*dt4_g0_30;
    dt4_l1_8 = dt4_l1_8 + (0.23110063374042511)*dt4_g0_31;
    dt4_l1_9 = -0.13868293166160583;
    dt4_l1_9 = dt4_l1_9 + (0.023834094405174255)*dt4_g0_0;
    dt4_l1_9 = dt4_l1_9 + (0.13403761386871338)*dt4_g0_1;
    dt4_l1_9 = dt4_l1_9 + (0.15153506398200989)*dt4_g0_2;
    dt4_l1_9 = dt4_l1_9 + (0.017937421798706055)*dt4_g0_3;
    dt4_l1_9 = dt4_l1_9 + (0.156947061419487)*dt4_g0_4;
    dt4_l1_9 = dt4_l1_9 + (-0.23003552854061127)*dt4_g0_5;
    dt4_l1_9 = dt4_l1_9 + (-0.11289767175912857)*dt4_g0_6;
    dt4_l1_9 = dt4_l1_9 + (0.049387767910957336)*dt4_g0_7;
    dt4_l1_9 = dt4_l1_9 + (0.21174226701259613)*dt4_g0_8;
    dt4_l1_9 = dt4_l1_9 + (0.18910692632198334)*dt4_g0_9;
    dt4_l1_9 = dt4_l1_9 + (0.10178250819444656)*dt4_g0_10;
    dt4_l1_9 = dt4_l1_9 + (-0.13315603137016296)*dt4_g0_11;
    dt4_l1_9 = dt4_l1_9 + (0.10240495204925537)*dt4_g0_12;
    dt4_l1_9 = dt4_l1_9 + (0.045188978314399719)*dt4_g0_13;
    dt4_l1_9 = dt4_l1_9 + (0.12674446403980255)*dt4_g0_14;
    dt4_l1_9 = dt4_l1_9 + (-0.018667533993721008)*dt4_g0_15;
    dt4_l1_9 = dt4_l1_9 + (0.054173573851585388)*dt4_g0_16;
    dt4_l1_9 = dt4_l1_9 + (-0.050129134207963943)*dt4_g0_17;
    dt4_l1_9 = dt4_l1_9 + (0.10595974326133728)*dt4_g0_18;
    dt4_l1_9 = dt4_l1_9 + (-0.029256910085678101)*dt4_g0_19;
    dt4_l1_9 = dt4_l1_9 + (-0.0041289492510259151)*dt4_g0_20;
    dt4_l1_9 = dt4_l1_9 + (0.067040741443634033)*dt4_g0_21;
    dt4_l1_9 = dt4_l1_9 + (0.28273269534111023)*dt4_g0_22;
    dt4_l1_9 = dt4_l1_9 + (-0.08960222452878952)*dt4_g0_23;
    dt4_l1_9 = dt4_l1_9 + (0.23507948219776154)*dt4_g0_24;
    dt4_l1_9 = dt4_l1_9 + (0.11662031710147858)*dt4_g0_25;
    dt4_l1_9 = dt4_l1_9 + (-0.1481965184211731)*dt4_g0_26;
    dt4_l1_9 = dt4_l1_9 + (0.068826325237751007)*dt4_g0_27;
    dt4_l1_9 = dt4_l1_9 + (-0.41048020124435425)*dt4_g0_28;
    dt4_l1_9 = dt4_l1_9 + (0.028586402535438538)*dt4_g0_29;
    dt4_l1_9 = dt4_l1_9 + (0.093711540102958679)*dt4_g0_30;
    dt4_l1_9 = dt4_l1_9 + (-0.16042201220989227)*dt4_g0_31;
    dt4_l1_10 = -0.078292421996593475;
    dt4_l1_10 = dt4_l1_10 + (0.38613796234130859)*dt4_g0_0;
    dt4_l1_10 = dt4_l1_10 + (0.16861145198345184)*dt4_g0_1;
    dt4_l1_10 = dt4_l1_10 + (-0.034250523895025253)*dt4_g0_2;
    dt4_l1_10 = dt4_l1_10 + (0.12220780551433563)*dt4_g0_3;
    dt4_l1_10 = dt4_l1_10 + (0.076330028474330902)*dt4_g0_4;
    dt4_l1_10 = dt4_l1_10 + (0.45561903715133667)*dt4_g0_5;
    dt4_l1_10 = dt4_l1_10 + (0.09523686021566391)*dt4_g0_6;
    dt4_l1_10 = dt4_l1_10 + (-0.031291704624891281)*dt4_g0_7;
    dt4_l1_10 = dt4_l1_10 + (-0.16195787489414215)*dt4_g0_8;
    dt4_l1_10 = dt4_l1_10 + (-0.12284358590841293)*dt4_g0_9;
    dt4_l1_10 = dt4_l1_10 + (0.19868870079517365)*dt4_g0_10;
    dt4_l1_10 = dt4_l1_10 + (-0.059839930385351181)*dt4_g0_11;
    dt4_l1_10 = dt4_l1_10 + (0.016507105901837349)*dt4_g0_12;
    dt4_l1_10 = dt4_l1_10 + (0.089055366814136505)*dt4_g0_13;
    dt4_l1_10 = dt4_l1_10 + (-0.073398031294345856)*dt4_g0_14;
    dt4_l1_10 = dt4_l1_10 + (0.12010634690523148)*dt4_g0_15;
    dt4_l1_10 = dt4_l1_10 + (-0.56620091199874878)*dt4_g0_16;
    dt4_l1_10 = dt4_l1_10 + (0.032096225768327713)*dt4_g0_17;
    dt4_l1_10 = dt4_l1_10 + (0.060803625732660294)*dt4_g0_18;
    dt4_l1_10 = dt4_l1_10 + (-0.1705658882856369)*dt4_g0_19;
    dt4_l1_10 = dt4_l1_10 + (-0.13755302131175995)*dt4_g0_20;
    dt4_l1_10 = dt4_l1_10 + (-0.087579868733882904)*dt4_g0_21;
    dt4_l1_10 = dt4_l1_10 + (-0.1278015673160553)*dt4_g0_22;
    dt4_l1_10 = dt4_l1_10 + (0.18843105435371399)*dt4_g0_23;
    dt4_l1_10 = dt4_l1_10 + (0.1520625501871109)*dt4_g0_24;
    dt4_l1_10 = dt4_l1_10 + (0.079296454787254333)*dt4_g0_25;
    dt4_l1_10 = dt4_l1_10 + (-0.24782979488372803)*dt4_g0_26;
    dt4_l1_10 = dt4_l1_10 + (-0.039584934711456299)*dt4_g0_27;
    dt4_l1_10 = dt4_l1_10 + (0.37787425518035889)*dt4_g0_28;
    dt4_l1_10 = dt4_l1_10 + (0.11145026236772537)*dt4_g0_29;
    dt4_l1_10 = dt4_l1_10 + (-0.16598974168300629)*dt4_g0_30;
    dt4_l1_10 = dt4_l1_10 + (0.0084111606702208519)*dt4_g0_31;
    dt4_l1_11 = -0.062137391418218613;
    dt4_l1_11 = dt4_l1_11 + (-0.17376498878002167)*dt4_g0_0;
    dt4_l1_11 = dt4_l1_11 + (0.096284717321395874)*dt4_g0_1;
    dt4_l1_11 = dt4_l1_11 + (-0.091086395084857941)*dt4_g0_2;
    dt4_l1_11 = dt4_l1_11 + (-0.098921611905097961)*dt4_g0_3;
    dt4_l1_11 = dt4_l1_11 + (-0.13950799405574799)*dt4_g0_4;
    dt4_l1_11 = dt4_l1_11 + (-0.21119497716426849)*dt4_g0_5;
    dt4_l1_11 = dt4_l1_11 + (-0.29174453020095825)*dt4_g0_6;
    dt4_l1_11 = dt4_l1_11 + (-0.041246883571147919)*dt4_g0_7;
    dt4_l1_11 = dt4_l1_11 + (-0.19079685211181641)*dt4_g0_8;
    dt4_l1_11 = dt4_l1_11 + (-0.063988305628299713)*dt4_g0_9;
    dt4_l1_11 = dt4_l1_11 + (0.19126258790493011)*dt4_g0_10;
    dt4_l1_11 = dt4_l1_11 + (-0.17825838923454285)*dt4_g0_11;
    dt4_l1_11 = dt4_l1_11 + (-0.15225179493427277)*dt4_g0_12;
    dt4_l1_11 = dt4_l1_11 + (-0.16363492608070374)*dt4_g0_13;
    dt4_l1_11 = dt4_l1_11 + (-0.10237506777048111)*dt4_g0_14;
    dt4_l1_11 = dt4_l1_11 + (0.18985816836357117)*dt4_g0_15;
    dt4_l1_11 = dt4_l1_11 + (0.11689111590385437)*dt4_g0_16;
    dt4_l1_11 = dt4_l1_11 + (-0.27802398800849915)*dt4_g0_17;
    dt4_l1_11 = dt4_l1_11 + (0.030934391543269157)*dt4_g0_18;
    dt4_l1_11 = dt4_l1_11 + (0.1008097305893898)*dt4_g0_19;
    dt4_l1_11 = dt4_l1_11 + (0.098364770412445068)*dt4_g0_20;
    dt4_l1_11 = dt4_l1_11 + (-0.010569779202342033)*dt4_g0_21;
    dt4_l1_11 = dt4_l1_11 + (0.0079128220677375793)*dt4_g0_22;
    dt4_l1_11 = dt4_l1_11 + (-0.079806827008724213)*dt4_g0_23;
    dt4_l1_11 = dt4_l1_11 + (0.27011299133300781)*dt4_g0_24;
    dt4_l1_11 = dt4_l1_11 + (0.070469021797180176)*dt4_g0_25;
    dt4_l1_11 = dt4_l1_11 + (-0.38286259770393372)*dt4_g0_26;
    dt4_l1_11 = dt4_l1_11 + (-0.14456358551979065)*dt4_g0_27;
    dt4_l1_11 = dt4_l1_11 + (-0.52179837226867676)*dt4_g0_28;
    dt4_l1_11 = dt4_l1_11 + (-0.073391132056713104)*dt4_g0_29;
    dt4_l1_11 = dt4_l1_11 + (0.10099390894174576)*dt4_g0_30;
    dt4_l1_11 = dt4_l1_11 + (-0.2381131649017334)*dt4_g0_31;
    dt4_l1_12 = -0.077903278172016144;
    dt4_l1_12 = dt4_l1_12 + (-0.024478539824485779)*dt4_g0_0;
    dt4_l1_12 = dt4_l1_12 + (0.15509465336799622)*dt4_g0_1;
    dt4_l1_12 = dt4_l1_12 + (0.021082784980535507)*dt4_g0_2;
    dt4_l1_12 = dt4_l1_12 + (-0.089185543358325958)*dt4_g0_3;
    dt4_l1_12 = dt4_l1_12 + (0.0031038988381624222)*dt4_g0_4;
    dt4_l1_12 = dt4_l1_12 + (0.10395709425210953)*dt4_g0_5;
    dt4_l1_12 = dt4_l1_12 + (-0.26505029201507568)*dt4_g0_6;
    dt4_l1_12 = dt4_l1_12 + (-0.10546328872442245)*dt4_g0_7;
    dt4_l1_12 = dt4_l1_12 + (-0.12884120643138885)*dt4_g0_8;
    dt4_l1_12 = dt4_l1_12 + (0.11630596220493317)*dt4_g0_9;
    dt4_l1_12 = dt4_l1_12 + (0.0063452315516769886)*dt4_g0_10;
    dt4_l1_12 = dt4_l1_12 + (-0.0063953367061913013)*dt4_g0_11;
    dt4_l1_12 = dt4_l1_12 + (-0.021227281540632248)*dt4_g0_12;
    dt4_l1_12 = dt4_l1_12 + (-0.10694406181573868)*dt4_g0_13;
    dt4_l1_12 = dt4_l1_12 + (-0.051671974360942841)*dt4_g0_14;
    dt4_l1_12 = dt4_l1_12 + (0.014918405562639236)*dt4_g0_15;
    dt4_l1_12 = dt4_l1_12 + (-0.33986765146255493)*dt4_g0_16;
    dt4_l1_12 = dt4_l1_12 + (0.024092648178339005)*dt4_g0_17;
    dt4_l1_12 = dt4_l1_12 + (0.090858824551105499)*dt4_g0_18;
    dt4_l1_12 = dt4_l1_12 + (0.19264908134937286)*dt4_g0_19;
    dt4_l1_12 = dt4_l1_12 + (-0.082039140164852142)*dt4_g0_20;
    dt4_l1_12 = dt4_l1_12 + (0.0058428267948329449)*dt4_g0_21;
    dt4_l1_12 = dt4_l1_12 + (0.25755473971366882)*dt4_g0_22;
    dt4_l1_12 = dt4_l1_12 + (0.048122107982635498)*dt4_g0_23;
    dt4_l1_12 = dt4_l1_12 + (-0.25055438280105591)*dt4_g0_24;
    dt4_l1_12 = dt4_l1_12 + (0.016316866502165794)*dt4_g0_25;
    dt4_l1_12 = dt4_l1_12 + (-0.081792674958705902)*dt4_g0_26;
    dt4_l1_12 = dt4_l1_12 + (-0.063519790768623352)*dt4_g0_27;
    dt4_l1_12 = dt4_l1_12 + (0.50614690780639648)*dt4_g0_28;
    dt4_l1_12 = dt4_l1_12 + (-0.066375598311424255)*dt4_g0_29;
    dt4_l1_12 = dt4_l1_12 + (0.090680874884128571)*dt4_g0_30;
    dt4_l1_12 = dt4_l1_12 + (-0.073922984302043915)*dt4_g0_31;
    dt4_l1_13 = -0.12205866724252701;
    dt4_l1_13 = dt4_l1_13 + (-0.25504162907600403)*dt4_g0_0;
    dt4_l1_13 = dt4_l1_13 + (-0.049930181354284286)*dt4_g0_1;
    dt4_l1_13 = dt4_l1_13 + (0.14232224225997925)*dt4_g0_2;
    dt4_l1_13 = dt4_l1_13 + (0.15969088673591614)*dt4_g0_3;
    dt4_l1_13 = dt4_l1_13 + (0.14399471879005432)*dt4_g0_4;
    dt4_l1_13 = dt4_l1_13 + (-0.058044787496328354)*dt4_g0_5;
    dt4_l1_13 = dt4_l1_13 + (0.11529924720525742)*dt4_g0_6;
    dt4_l1_13 = dt4_l1_13 + (0.039351854473352432)*dt4_g0_7;
    dt4_l1_13 = dt4_l1_13 + (0.12985527515411377)*dt4_g0_8;
    dt4_l1_13 = dt4_l1_13 + (-0.055830512195825577)*dt4_g0_9;
    dt4_l1_13 = dt4_l1_13 + (-0.11088638752698898)*dt4_g0_10;
    dt4_l1_13 = dt4_l1_13 + (-0.071301668882369995)*dt4_g0_11;
    dt4_l1_13 = dt4_l1_13 + (0.059834972023963928)*dt4_g0_12;
    dt4_l1_13 = dt4_l1_13 + (-0.026034511625766754)*dt4_g0_13;
    dt4_l1_13 = dt4_l1_13 + (0.18610493838787079)*dt4_g0_14;
    dt4_l1_13 = dt4_l1_13 + (-0.070099622011184692)*dt4_g0_15;
    dt4_l1_13 = dt4_l1_13 + (0.2838326096534729)*dt4_g0_16;
    dt4_l1_13 = dt4_l1_13 + (-0.037520397454500198)*dt4_g0_17;
    dt4_l1_13 = dt4_l1_13 + (0.13068065047264099)*dt4_g0_18;
    dt4_l1_13 = dt4_l1_13 + (0.066525585949420929)*dt4_g0_19;
    dt4_l1_13 = dt4_l1_13 + (-0.049645096063613892)*dt4_g0_20;
    dt4_l1_13 = dt4_l1_13 + (0.054189886897802353)*dt4_g0_21;
    dt4_l1_13 = dt4_l1_13 + (-0.17614948749542236)*dt4_g0_22;
    dt4_l1_13 = dt4_l1_13 + (0.0069473623298108578)*dt4_g0_23;
    dt4_l1_13 = dt4_l1_13 + (-0.071386918425559998)*dt4_g0_24;
    dt4_l1_13 = dt4_l1_13 + (-0.1061040461063385)*dt4_g0_25;
    dt4_l1_13 = dt4_l1_13 + (0.24330644309520721)*dt4_g0_26;
    dt4_l1_13 = dt4_l1_13 + (0.13288405537605286)*dt4_g0_27;
    dt4_l1_13 = dt4_l1_13 + (-0.095819815993309021)*dt4_g0_28;
    dt4_l1_13 = dt4_l1_13 + (0.1976703405380249)*dt4_g0_29;
    dt4_l1_13 = dt4_l1_13 + (-0.10413108766078949)*dt4_g0_30;
    dt4_l1_13 = dt4_l1_13 + (-0.066180601716041565)*dt4_g0_31;
    dt4_l1_14 = 0.10435187816619873;
    dt4_l1_14 = dt4_l1_14 + (0.066092170774936676)*dt4_g0_0;
    dt4_l1_14 = dt4_l1_14 + (-0.14066116511821747)*dt4_g0_1;
    dt4_l1_14 = dt4_l1_14 + (0.0070511805824935436)*dt4_g0_2;
    dt4_l1_14 = dt4_l1_14 + (0.016216622665524483)*dt4_g0_3;
    dt4_l1_14 = dt4_l1_14 + (-0.077155455946922302)*dt4_g0_4;
    dt4_l1_14 = dt4_l1_14 + (-0.0035024809185415506)*dt4_g0_5;
    dt4_l1_14 = dt4_l1_14 + (0.16614776849746704)*dt4_g0_6;
    dt4_l1_14 = dt4_l1_14 + (-0.097305327653884888)*dt4_g0_7;
    dt4_l1_14 = dt4_l1_14 + (0.049758661538362503)*dt4_g0_8;
    dt4_l1_14 = dt4_l1_14 + (-0.10961616039276123)*dt4_g0_9;
    dt4_l1_14 = dt4_l1_14 + (0.082717306911945343)*dt4_g0_10;
    dt4_l1_14 = dt4_l1_14 + (0.080690205097198486)*dt4_g0_11;
    dt4_l1_14 = dt4_l1_14 + (-0.019630759954452515)*dt4_g0_12;
    dt4_l1_14 = dt4_l1_14 + (-0.14077238738536835)*dt4_g0_13;
    dt4_l1_14 = dt4_l1_14 + (-0.14777269959449768)*dt4_g0_14;
    dt4_l1_14 = dt4_l1_14 + (0.1627192497253418)*dt4_g0_15;
    dt4_l1_14 = dt4_l1_14 + (-0.27055931091308594)*dt4_g0_16;
    dt4_l1_14 = dt4_l1_14 + (0.24675653874874115)*dt4_g0_17;
    dt4_l1_14 = dt4_l1_14 + (-0.13080167770385742)*dt4_g0_18;
    dt4_l1_14 = dt4_l1_14 + (-0.12526585161685944)*dt4_g0_19;
    dt4_l1_14 = dt4_l1_14 + (0.026029074564576149)*dt4_g0_20;
    dt4_l1_14 = dt4_l1_14 + (0.00069717544829472899)*dt4_g0_21;
    dt4_l1_14 = dt4_l1_14 + (-0.24566978216171265)*dt4_g0_22;
    dt4_l1_14 = dt4_l1_14 + (-0.03789505735039711)*dt4_g0_23;
    dt4_l1_14 = dt4_l1_14 + (0.031554587185382843)*dt4_g0_24;
    dt4_l1_14 = dt4_l1_14 + (-0.16307400166988373)*dt4_g0_25;
    dt4_l1_14 = dt4_l1_14 + (0.18186207115650177)*dt4_g0_26;
    dt4_l1_14 = dt4_l1_14 + (0.10117419809103012)*dt4_g0_27;
    dt4_l1_14 = dt4_l1_14 + (0.71069341897964478)*dt4_g0_28;
    dt4_l1_14 = dt4_l1_14 + (-0.094877868890762329)*dt4_g0_29;
    dt4_l1_14 = dt4_l1_14 + (-0.10863464325666428)*dt4_g0_30;
    dt4_l1_14 = dt4_l1_14 + (0.044603679329156876)*dt4_g0_31;
    dt4_l1_15 = 0.054931297898292542;
    dt4_l1_15 = dt4_l1_15 + (-0.12308650463819504)*dt4_g0_0;
    dt4_l1_15 = dt4_l1_15 + (0.10122453421354294)*dt4_g0_1;
    dt4_l1_15 = dt4_l1_15 + (-0.036758832633495331)*dt4_g0_2;
    dt4_l1_15 = dt4_l1_15 + (-0.055523984134197235)*dt4_g0_3;
    dt4_l1_15 = dt4_l1_15 + (0.024221815168857574)*dt4_g0_4;
    dt4_l1_15 = dt4_l1_15 + (0.36427092552185059)*dt4_g0_5;
    dt4_l1_15 = dt4_l1_15 + (0.013182561844587326)*dt4_g0_6;
    dt4_l1_15 = dt4_l1_15 + (-0.084676198661327362)*dt4_g0_7;
    dt4_l1_15 = dt4_l1_15 + (0.094983756542205811)*dt4_g0_8;
    dt4_l1_15 = dt4_l1_15 + (-0.044733546674251556)*dt4_g0_9;
    dt4_l1_15 = dt4_l1_15 + (-0.068374097347259521)*dt4_g0_10;
    dt4_l1_15 = dt4_l1_15 + (0.073864951729774475)*dt4_g0_11;
    dt4_l1_15 = dt4_l1_15 + (0.040122237056493759)*dt4_g0_12;
    dt4_l1_15 = dt4_l1_15 + (-0.11484098434448242)*dt4_g0_13;
    dt4_l1_15 = dt4_l1_15 + (0.029558604583144188)*dt4_g0_14;
    dt4_l1_15 = dt4_l1_15 + (-0.12961806356906891)*dt4_g0_15;
    dt4_l1_15 = dt4_l1_15 + (-0.68139654397964478)*dt4_g0_16;
    dt4_l1_15 = dt4_l1_15 + (-0.090533196926116943)*dt4_g0_17;
    dt4_l1_15 = dt4_l1_15 + (-0.055364329367876053)*dt4_g0_18;
    dt4_l1_15 = dt4_l1_15 + (-0.037381157279014587)*dt4_g0_19;
    dt4_l1_15 = dt4_l1_15 + (-0.013406396843492985)*dt4_g0_20;
    dt4_l1_15 = dt4_l1_15 + (0.067575834691524506)*dt4_g0_21;
    dt4_l1_15 = dt4_l1_15 + (-0.080908246338367462)*dt4_g0_22;
    dt4_l1_15 = dt4_l1_15 + (0.05767367035150528)*dt4_g0_23;
    dt4_l1_15 = dt4_l1_15 + (0.042280886322259903)*dt4_g0_24;
    dt4_l1_15 = dt4_l1_15 + (-0.18634659051895142)*dt4_g0_25;
    dt4_l1_15 = dt4_l1_15 + (0.31346985697746277)*dt4_g0_26;
    dt4_l1_15 = dt4_l1_15 + (0.038848195225000381)*dt4_g0_27;
    dt4_l1_15 = dt4_l1_15 + (0.23577156662940979)*dt4_g0_28;
    dt4_l1_15 = dt4_l1_15 + (-0.014047614298760891)*dt4_g0_29;
    dt4_l1_15 = dt4_l1_15 + (0.096515163779258728)*dt4_g0_30;
    dt4_l1_15 = dt4_l1_15 + (-0.062498938292264938)*dt4_g0_31;
    // Device token pooling
    hp_0 = (dt0_l1_0 + dt1_l1_0 + dt2_l1_0 + dt3_l1_0 + dt4_l1_0) / 5.0;
    hp_1 = (dt0_l1_1 + dt1_l1_1 + dt2_l1_1 + dt3_l1_1 + dt4_l1_1) / 5.0;
    hp_2 = (dt0_l1_2 + dt1_l1_2 + dt2_l1_2 + dt3_l1_2 + dt4_l1_2) / 5.0;
    hp_3 = (dt0_l1_3 + dt1_l1_3 + dt2_l1_3 + dt3_l1_3 + dt4_l1_3) / 5.0;
    hp_4 = (dt0_l1_4 + dt1_l1_4 + dt2_l1_4 + dt3_l1_4 + dt4_l1_4) / 5.0;
    hp_5 = (dt0_l1_5 + dt1_l1_5 + dt2_l1_5 + dt3_l1_5 + dt4_l1_5) / 5.0;
    hp_6 = (dt0_l1_6 + dt1_l1_6 + dt2_l1_6 + dt3_l1_6 + dt4_l1_6) / 5.0;
    hp_7 = (dt0_l1_7 + dt1_l1_7 + dt2_l1_7 + dt3_l1_7 + dt4_l1_7) / 5.0;
    hp_8 = (dt0_l1_8 + dt1_l1_8 + dt2_l1_8 + dt3_l1_8 + dt4_l1_8) / 5.0;
    hp_9 = (dt0_l1_9 + dt1_l1_9 + dt2_l1_9 + dt3_l1_9 + dt4_l1_9) / 5.0;
    hp_10 = (dt0_l1_10 + dt1_l1_10 + dt2_l1_10 + dt3_l1_10 + dt4_l1_10) / 5.0;
    hp_11 = (dt0_l1_11 + dt1_l1_11 + dt2_l1_11 + dt3_l1_11 + dt4_l1_11) / 5.0;
    hp_12 = (dt0_l1_12 + dt1_l1_12 + dt2_l1_12 + dt3_l1_12 + dt4_l1_12) / 5.0;
    hp_13 = (dt0_l1_13 + dt1_l1_13 + dt2_l1_13 + dt3_l1_13 + dt4_l1_13) / 5.0;
    hp_14 = (dt0_l1_14 + dt1_l1_14 + dt2_l1_14 + dt3_l1_14 + dt4_l1_14) / 5.0;
    hp_15 = (dt0_l1_15 + dt1_l1_15 + dt2_l1_15 + dt3_l1_15 + dt4_l1_15) / 5.0;
    hp_mean = (hp_0 + hp_1 + hp_2 + hp_3 + hp_4 + hp_5 + hp_6 + hp_7 + hp_8 + hp_9 + hp_10 + hp_11 + hp_12 + hp_13 + hp_14 + hp_15) / 16;
    hp_var = (((hp_0) - hp_mean)*((hp_0) - hp_mean) + ((hp_1) - hp_mean)*((hp_1) - hp_mean) + ((hp_2) - hp_mean)*((hp_2) - hp_mean) + ((hp_3) - hp_mean)*((hp_3) - hp_mean) + ((hp_4) - hp_mean)*((hp_4) - hp_mean) + ((hp_5) - hp_mean)*((hp_5) - hp_mean) + ((hp_6) - hp_mean)*((hp_6) - hp_mean) + ((hp_7) - hp_mean)*((hp_7) - hp_mean) + ((hp_8) - hp_mean)*((hp_8) - hp_mean) + ((hp_9) - hp_mean)*((hp_9) - hp_mean) + ((hp_10) - hp_mean)*((hp_10) - hp_mean) + ((hp_11) - hp_mean)*((hp_11) - hp_mean) + ((hp_12) - hp_mean)*((hp_12) - hp_mean) + ((hp_13) - hp_mean)*((hp_13) - hp_mean) + ((hp_14) - hp_mean)*((hp_14) - hp_mean) + ((hp_15) - hp_mean)*((hp_15) - hp_mean)) / 16;
    hpn_0 = ((hp_0) - hp_mean) / sqrt(hp_var + ln_eps);
    hpn_1 = ((hp_1) - hp_mean) / sqrt(hp_var + ln_eps);
    hpn_2 = ((hp_2) - hp_mean) / sqrt(hp_var + ln_eps);
    hpn_3 = ((hp_3) - hp_mean) / sqrt(hp_var + ln_eps);
    hpn_4 = ((hp_4) - hp_mean) / sqrt(hp_var + ln_eps);
    hpn_5 = ((hp_5) - hp_mean) / sqrt(hp_var + ln_eps);
    hpn_6 = ((hp_6) - hp_mean) / sqrt(hp_var + ln_eps);
    hpn_7 = ((hp_7) - hp_mean) / sqrt(hp_var + ln_eps);
    hpn_8 = ((hp_8) - hp_mean) / sqrt(hp_var + ln_eps);
    hpn_9 = ((hp_9) - hp_mean) / sqrt(hp_var + ln_eps);
    hpn_10 = ((hp_10) - hp_mean) / sqrt(hp_var + ln_eps);
    hpn_11 = ((hp_11) - hp_mean) / sqrt(hp_var + ln_eps);
    hpn_12 = ((hp_12) - hp_mean) / sqrt(hp_var + ln_eps);
    hpn_13 = ((hp_13) - hp_mean) / sqrt(hp_var + ln_eps);
    hpn_14 = ((hp_14) - hp_mean) / sqrt(hp_var + ln_eps);
    hpn_15 = ((hp_15) - hp_mean) / sqrt(hp_var + ln_eps);
    // Bias tower
    bt_l0_0 = 0.41217249631881714;
    bt_l0_0 = bt_l0_0 + (0.11610304564237595)*vgs_scaled;
    bt_l0_0 = bt_l0_0 + (-0.41179183125495911)*vds_scaled;
    bt_l0_1 = 0.70382744073867798;
    bt_l0_1 = bt_l0_1 + (-0.11506199091672897)*vgs_scaled;
    bt_l0_1 = bt_l0_1 + (0.33021193742752075)*vds_scaled;
    bt_l0_2 = -0.078339889645576477;
    bt_l0_2 = bt_l0_2 + (0.26907196640968323)*vgs_scaled;
    bt_l0_2 = bt_l0_2 + (-0.023570623248815536)*vds_scaled;
    bt_l0_3 = 0.17702068388462067;
    bt_l0_3 = bt_l0_3 + (0.080380678176879883)*vgs_scaled;
    bt_l0_3 = bt_l0_3 + (0.15623335540294647)*vds_scaled;
    bt_l0_4 = 0.63863843679428101;
    bt_l0_4 = bt_l0_4 + (0.4069417417049408)*vgs_scaled;
    bt_l0_4 = bt_l0_4 + (0.51145064830780029)*vds_scaled;
    bt_l0_5 = -0.75582563877105713;
    bt_l0_5 = bt_l0_5 + (0.83339887857437134)*vgs_scaled;
    bt_l0_5 = bt_l0_5 + (0.34021422266960144)*vds_scaled;
    bt_l0_6 = 0.45615676045417786;
    bt_l0_6 = bt_l0_6 + (-0.22059352695941925)*vgs_scaled;
    bt_l0_6 = bt_l0_6 + (0.67025727033615112)*vds_scaled;
    bt_l0_7 = -0.48840665817260742;
    bt_l0_7 = bt_l0_7 + (-0.043097048997879028)*vgs_scaled;
    bt_l0_7 = bt_l0_7 + (-0.33646684885025024)*vds_scaled;
    bt_l0_8 = -0.39824250340461731;
    bt_l0_8 = bt_l0_8 + (0.64367467164993286)*vgs_scaled;
    bt_l0_8 = bt_l0_8 + (-0.057120896875858307)*vds_scaled;
    bt_l0_9 = -0.38752183318138123;
    bt_l0_9 = bt_l0_9 + (0.36326080560684204)*vgs_scaled;
    bt_l0_9 = bt_l0_9 + (-0.072656407952308655)*vds_scaled;
    bt_l0_10 = 0.31530353426933289;
    bt_l0_10 = bt_l0_10 + (-0.35407492518424988)*vgs_scaled;
    bt_l0_10 = bt_l0_10 + (-0.44307330250740051)*vds_scaled;
    bt_l0_11 = 0.48027628660202026;
    bt_l0_11 = bt_l0_11 + (0.42302072048187256)*vgs_scaled;
    bt_l0_11 = bt_l0_11 + (0.70947396755218506)*vds_scaled;
    bt_l0_12 = -0.017808416858315468;
    bt_l0_12 = bt_l0_12 + (0.10193386673927307)*vgs_scaled;
    bt_l0_12 = bt_l0_12 + (-0.27037966251373291)*vds_scaled;
    bt_l0_13 = 0.17224040627479553;
    bt_l0_13 = bt_l0_13 + (0.57407695055007935)*vgs_scaled;
    bt_l0_13 = bt_l0_13 + (0.19430677592754364)*vds_scaled;
    bt_l0_14 = -0.30802932381629944;
    bt_l0_14 = bt_l0_14 + (0.31872475147247314)*vgs_scaled;
    bt_l0_14 = bt_l0_14 + (-0.48638862371444702)*vds_scaled;
    bt_l0_15 = -0.57783240079879761;
    bt_l0_15 = bt_l0_15 + (0.55227893590927124)*vgs_scaled;
    bt_l0_15 = bt_l0_15 + (0.030222514644265175)*vds_scaled;
    bt_l0_16 = -0.61591440439224243;
    bt_l0_16 = bt_l0_16 + (0.73985838890075684)*vgs_scaled;
    bt_l0_16 = bt_l0_16 + (0.433491051197052)*vds_scaled;
    bt_l0_17 = -0.080858312547206879;
    bt_l0_17 = bt_l0_17 + (0.31457722187042236)*vgs_scaled;
    bt_l0_17 = bt_l0_17 + (0.12835690379142761)*vds_scaled;
    bt_l0_18 = 0.56372469663619995;
    bt_l0_18 = bt_l0_18 + (0.15229867398738861)*vgs_scaled;
    bt_l0_18 = bt_l0_18 + (0.23245716094970703)*vds_scaled;
    bt_l0_19 = 0.50737327337265015;
    bt_l0_19 = bt_l0_19 + (0.42468121647834778)*vgs_scaled;
    bt_l0_19 = bt_l0_19 + (0.38743171095848083)*vds_scaled;
    bt_l0_20 = -0.21655946969985962;
    bt_l0_20 = bt_l0_20 + (-0.048251263797283173)*vgs_scaled;
    bt_l0_20 = bt_l0_20 + (0.24445900321006775)*vds_scaled;
    bt_l0_21 = 0.30658417940139771;
    bt_l0_21 = bt_l0_21 + (0.014167681336402893)*vgs_scaled;
    bt_l0_21 = bt_l0_21 + (0.33849164843559265)*vds_scaled;
    bt_l0_22 = 0.76780605316162109;
    bt_l0_22 = bt_l0_22 + (-0.28922247886657715)*vgs_scaled;
    bt_l0_22 = bt_l0_22 + (0.48020201921463013)*vds_scaled;
    bt_l0_23 = -0.67952060699462891;
    bt_l0_23 = bt_l0_23 + (0.587807297706604)*vgs_scaled;
    bt_l0_23 = bt_l0_23 + (-0.53519660234451294)*vds_scaled;
    bt_l0_24 = -0.66402620077133179;
    bt_l0_24 = bt_l0_24 + (-0.62478220462799072)*vgs_scaled;
    bt_l0_24 = bt_l0_24 + (-0.13868139684200287)*vds_scaled;
    bt_l0_25 = -0.5099521279335022;
    bt_l0_25 = bt_l0_25 + (0.27462327480316162)*vgs_scaled;
    bt_l0_25 = bt_l0_25 + (0.6591683030128479)*vds_scaled;
    bt_l0_26 = 0.53205525875091553;
    bt_l0_26 = bt_l0_26 + (-0.63173055648803711)*vgs_scaled;
    bt_l0_26 = bt_l0_26 + (-0.072895660996437073)*vds_scaled;
    bt_l0_27 = -0.57960891723632812;
    bt_l0_27 = bt_l0_27 + (0.054380815476179123)*vgs_scaled;
    bt_l0_27 = bt_l0_27 + (-0.3857196569442749)*vds_scaled;
    bt_l0_28 = -0.57704025506973267;
    bt_l0_28 = bt_l0_28 + (-0.53479880094528198)*vgs_scaled;
    bt_l0_28 = bt_l0_28 + (0.20759981870651245)*vds_scaled;
    bt_l0_29 = 0.23054338991641998;
    bt_l0_29 = bt_l0_29 + (0.14212365448474884)*vgs_scaled;
    bt_l0_29 = bt_l0_29 + (-0.028845379129052162)*vds_scaled;
    bt_l0_30 = 0.39184853434562683;
    bt_l0_30 = bt_l0_30 + (0.24732783436775208)*vgs_scaled;
    bt_l0_30 = bt_l0_30 + (0.14282064139842987)*vds_scaled;
    bt_l0_31 = 0.3451293408870697;
    bt_l0_31 = bt_l0_31 + (0.33852282166481018)*vgs_scaled;
    bt_l0_31 = bt_l0_31 + (0.23521323502063751)*vds_scaled;
    bt_l0_32 = -0.61072885990142822;
    bt_l0_32 = bt_l0_32 + (0.14133787155151367)*vgs_scaled;
    bt_l0_32 = bt_l0_32 + (-0.37081623077392578)*vds_scaled;
    bt_l0_33 = 0.80412459373474121;
    bt_l0_33 = bt_l0_33 + (-0.30126678943634033)*vgs_scaled;
    bt_l0_33 = bt_l0_33 + (0.2400796115398407)*vds_scaled;
    bt_l0_34 = 0.4773213267326355;
    bt_l0_34 = bt_l0_34 + (0.35844969749450684)*vgs_scaled;
    bt_l0_34 = bt_l0_34 + (0.24432140588760376)*vds_scaled;
    bt_l0_35 = -0.083423197269439697;
    bt_l0_35 = bt_l0_35 + (-0.57992422580718994)*vgs_scaled;
    bt_l0_35 = bt_l0_35 + (0.37283259630203247)*vds_scaled;
    bt_l0_36 = -0.54578191041946411;
    bt_l0_36 = bt_l0_36 + (0.77530044317245483)*vgs_scaled;
    bt_l0_36 = bt_l0_36 + (-0.028650969266891479)*vds_scaled;
    bt_l0_37 = -0.35946685075759888;
    bt_l0_37 = bt_l0_37 + (-0.45449650287628174)*vgs_scaled;
    bt_l0_37 = bt_l0_37 + (-0.24095657467842102)*vds_scaled;
    bt_l0_38 = -0.44237634539604187;
    bt_l0_38 = bt_l0_38 + (0.58744674921035767)*vgs_scaled;
    bt_l0_38 = bt_l0_38 + (0.31094080209732056)*vds_scaled;
    bt_l0_39 = -0.48053872585296631;
    bt_l0_39 = bt_l0_39 + (-0.18496683239936829)*vgs_scaled;
    bt_l0_39 = bt_l0_39 + (0.253670334815979)*vds_scaled;
    bt_l0_40 = 0.38644832372665405;
    bt_l0_40 = bt_l0_40 + (-0.046379353851079941)*vgs_scaled;
    bt_l0_40 = bt_l0_40 + (-0.50902438163757324)*vds_scaled;
    bt_l0_41 = 0.53080391883850098;
    bt_l0_41 = bt_l0_41 + (0.28549978137016296)*vgs_scaled;
    bt_l0_41 = bt_l0_41 + (-0.022596906870603561)*vds_scaled;
    bt_l0_42 = 0.36367270350456238;
    bt_l0_42 = bt_l0_42 + (-0.56788456439971924)*vgs_scaled;
    bt_l0_42 = bt_l0_42 + (0.17505878210067749)*vds_scaled;
    bt_l0_43 = 0.27415761351585388;
    bt_l0_43 = bt_l0_43 + (0.28071197867393494)*vgs_scaled;
    bt_l0_43 = bt_l0_43 + (-0.45572054386138916)*vds_scaled;
    bt_l0_44 = -0.5464470386505127;
    bt_l0_44 = bt_l0_44 + (0.13251267373561859)*vgs_scaled;
    bt_l0_44 = bt_l0_44 + (-0.70230156183242798)*vds_scaled;
    bt_l0_45 = 0.47278058528900146;
    bt_l0_45 = bt_l0_45 + (0.11631689220666885)*vgs_scaled;
    bt_l0_45 = bt_l0_45 + (0.092013724148273468)*vds_scaled;
    bt_l0_46 = 0.54555946588516235;
    bt_l0_46 = bt_l0_46 + (0.16103994846343994)*vgs_scaled;
    bt_l0_46 = bt_l0_46 + (-0.0021820985712110996)*vds_scaled;
    bt_l0_47 = 0.24956183135509491;
    bt_l0_47 = bt_l0_47 + (0.40508198738098145)*vgs_scaled;
    bt_l0_47 = bt_l0_47 + (-0.52116942405700684)*vds_scaled;
    bt_l0_48 = 0.6520463228225708;
    bt_l0_48 = bt_l0_48 + (-0.18691177666187286)*vgs_scaled;
    bt_l0_48 = bt_l0_48 + (-0.42503681778907776)*vds_scaled;
    bt_l0_49 = -0.14904680848121643;
    bt_l0_49 = bt_l0_49 + (-0.48656332492828369)*vgs_scaled;
    bt_l0_49 = bt_l0_49 + (0.50253415107727051)*vds_scaled;
    bt_l0_50 = 0.22061842679977417;
    bt_l0_50 = bt_l0_50 + (0.31948423385620117)*vgs_scaled;
    bt_l0_50 = bt_l0_50 + (0.57755380868911743)*vds_scaled;
    bt_l0_51 = -0.38017365336418152;
    bt_l0_51 = bt_l0_51 + (0.30339309573173523)*vgs_scaled;
    bt_l0_51 = bt_l0_51 + (-0.34110447764396667)*vds_scaled;
    bt_l0_52 = -0.24180558323860168;
    bt_l0_52 = bt_l0_52 + (-0.0097698597237467766)*vgs_scaled;
    bt_l0_52 = bt_l0_52 + (-0.57339334487915039)*vds_scaled;
    bt_l0_53 = 0.69256407022476196;
    bt_l0_53 = bt_l0_53 + (0.4486483633518219)*vgs_scaled;
    bt_l0_53 = bt_l0_53 + (0.011936466209590435)*vds_scaled;
    bt_l0_54 = 0.11726944148540497;
    bt_l0_54 = bt_l0_54 + (0.10131064057350159)*vgs_scaled;
    bt_l0_54 = bt_l0_54 + (0.18543992936611176)*vds_scaled;
    bt_l0_55 = 0.085611626505851746;
    bt_l0_55 = bt_l0_55 + (0.10197044163942337)*vgs_scaled;
    bt_l0_55 = bt_l0_55 + (-0.20345976948738098)*vds_scaled;
    bt_l0_56 = 0.21475872397422791;
    bt_l0_56 = bt_l0_56 + (0.10658007115125656)*vgs_scaled;
    bt_l0_56 = bt_l0_56 + (0.26469755172729492)*vds_scaled;
    bt_l0_57 = -0.13145561516284943;
    bt_l0_57 = bt_l0_57 + (0.27543085813522339)*vgs_scaled;
    bt_l0_57 = bt_l0_57 + (-0.45290869474411011)*vds_scaled;
    bt_l0_58 = -0.4097190797328949;
    bt_l0_58 = bt_l0_58 + (0.70595753192901611)*vgs_scaled;
    bt_l0_58 = bt_l0_58 + (0.20913302898406982)*vds_scaled;
    bt_l0_59 = 0.63533604145050049;
    bt_l0_59 = bt_l0_59 + (-0.5636170506477356)*vgs_scaled;
    bt_l0_59 = bt_l0_59 + (-0.0052803033031523228)*vds_scaled;
    bt_l0_60 = 0.76314002275466919;
    bt_l0_60 = bt_l0_60 + (-0.39715424180030823)*vgs_scaled;
    bt_l0_60 = bt_l0_60 + (0.065382756292819977)*vds_scaled;
    bt_l0_61 = -0.29608699679374695;
    bt_l0_61 = bt_l0_61 + (-0.63812565803527832)*vgs_scaled;
    bt_l0_61 = bt_l0_61 + (-0.1896025538444519)*vds_scaled;
    bt_l0_62 = -0.75197798013687134;
    bt_l0_62 = bt_l0_62 + (0.74614799022674561)*vgs_scaled;
    bt_l0_62 = bt_l0_62 + (-0.055198844522237778)*vds_scaled;
    bt_l0_63 = -0.17306056618690491;
    bt_l0_63 = bt_l0_63 + (0.18266962468624115)*vgs_scaled;
    bt_l0_63 = bt_l0_63 + (-0.29270261526107788)*vds_scaled;
    bt0_mean = (bt_l0_0 + bt_l0_1 + bt_l0_2 + bt_l0_3 + bt_l0_4 + bt_l0_5 + bt_l0_6 + bt_l0_7 + bt_l0_8 + bt_l0_9 + bt_l0_10 + bt_l0_11 + bt_l0_12 + bt_l0_13 + bt_l0_14 + bt_l0_15 + bt_l0_16 + bt_l0_17 + bt_l0_18 + bt_l0_19 + bt_l0_20 + bt_l0_21 + bt_l0_22 + bt_l0_23 + bt_l0_24 + bt_l0_25 + bt_l0_26 + bt_l0_27 + bt_l0_28 + bt_l0_29 + bt_l0_30 + bt_l0_31 + bt_l0_32 + bt_l0_33 + bt_l0_34 + bt_l0_35 + bt_l0_36 + bt_l0_37 + bt_l0_38 + bt_l0_39 + bt_l0_40 + bt_l0_41 + bt_l0_42 + bt_l0_43 + bt_l0_44 + bt_l0_45 + bt_l0_46 + bt_l0_47 + bt_l0_48 + bt_l0_49 + bt_l0_50 + bt_l0_51 + bt_l0_52 + bt_l0_53 + bt_l0_54 + bt_l0_55 + bt_l0_56 + bt_l0_57 + bt_l0_58 + bt_l0_59 + bt_l0_60 + bt_l0_61 + bt_l0_62 + bt_l0_63) / 64;
    bt0_var = (((bt_l0_0) - bt0_mean)*((bt_l0_0) - bt0_mean) + ((bt_l0_1) - bt0_mean)*((bt_l0_1) - bt0_mean) + ((bt_l0_2) - bt0_mean)*((bt_l0_2) - bt0_mean) + ((bt_l0_3) - bt0_mean)*((bt_l0_3) - bt0_mean) + ((bt_l0_4) - bt0_mean)*((bt_l0_4) - bt0_mean) + ((bt_l0_5) - bt0_mean)*((bt_l0_5) - bt0_mean) + ((bt_l0_6) - bt0_mean)*((bt_l0_6) - bt0_mean) + ((bt_l0_7) - bt0_mean)*((bt_l0_7) - bt0_mean) + ((bt_l0_8) - bt0_mean)*((bt_l0_8) - bt0_mean) + ((bt_l0_9) - bt0_mean)*((bt_l0_9) - bt0_mean) + ((bt_l0_10) - bt0_mean)*((bt_l0_10) - bt0_mean) + ((bt_l0_11) - bt0_mean)*((bt_l0_11) - bt0_mean) + ((bt_l0_12) - bt0_mean)*((bt_l0_12) - bt0_mean) + ((bt_l0_13) - bt0_mean)*((bt_l0_13) - bt0_mean) + ((bt_l0_14) - bt0_mean)*((bt_l0_14) - bt0_mean) + ((bt_l0_15) - bt0_mean)*((bt_l0_15) - bt0_mean) + ((bt_l0_16) - bt0_mean)*((bt_l0_16) - bt0_mean) + ((bt_l0_17) - bt0_mean)*((bt_l0_17) - bt0_mean) + ((bt_l0_18) - bt0_mean)*((bt_l0_18) - bt0_mean) + ((bt_l0_19) - bt0_mean)*((bt_l0_19) - bt0_mean) + ((bt_l0_20) - bt0_mean)*((bt_l0_20) - bt0_mean) + ((bt_l0_21) - bt0_mean)*((bt_l0_21) - bt0_mean) + ((bt_l0_22) - bt0_mean)*((bt_l0_22) - bt0_mean) + ((bt_l0_23) - bt0_mean)*((bt_l0_23) - bt0_mean) + ((bt_l0_24) - bt0_mean)*((bt_l0_24) - bt0_mean) + ((bt_l0_25) - bt0_mean)*((bt_l0_25) - bt0_mean) + ((bt_l0_26) - bt0_mean)*((bt_l0_26) - bt0_mean) + ((bt_l0_27) - bt0_mean)*((bt_l0_27) - bt0_mean) + ((bt_l0_28) - bt0_mean)*((bt_l0_28) - bt0_mean) + ((bt_l0_29) - bt0_mean)*((bt_l0_29) - bt0_mean) + ((bt_l0_30) - bt0_mean)*((bt_l0_30) - bt0_mean) + ((bt_l0_31) - bt0_mean)*((bt_l0_31) - bt0_mean) + ((bt_l0_32) - bt0_mean)*((bt_l0_32) - bt0_mean) + ((bt_l0_33) - bt0_mean)*((bt_l0_33) - bt0_mean) + ((bt_l0_34) - bt0_mean)*((bt_l0_34) - bt0_mean) + ((bt_l0_35) - bt0_mean)*((bt_l0_35) - bt0_mean) + ((bt_l0_36) - bt0_mean)*((bt_l0_36) - bt0_mean) + ((bt_l0_37) - bt0_mean)*((bt_l0_37) - bt0_mean) + ((bt_l0_38) - bt0_mean)*((bt_l0_38) - bt0_mean) + ((bt_l0_39) - bt0_mean)*((bt_l0_39) - bt0_mean) + ((bt_l0_40) - bt0_mean)*((bt_l0_40) - bt0_mean) + ((bt_l0_41) - bt0_mean)*((bt_l0_41) - bt0_mean) + ((bt_l0_42) - bt0_mean)*((bt_l0_42) - bt0_mean) + ((bt_l0_43) - bt0_mean)*((bt_l0_43) - bt0_mean) + ((bt_l0_44) - bt0_mean)*((bt_l0_44) - bt0_mean) + ((bt_l0_45) - bt0_mean)*((bt_l0_45) - bt0_mean) + ((bt_l0_46) - bt0_mean)*((bt_l0_46) - bt0_mean) + ((bt_l0_47) - bt0_mean)*((bt_l0_47) - bt0_mean) + ((bt_l0_48) - bt0_mean)*((bt_l0_48) - bt0_mean) + ((bt_l0_49) - bt0_mean)*((bt_l0_49) - bt0_mean) + ((bt_l0_50) - bt0_mean)*((bt_l0_50) - bt0_mean) + ((bt_l0_51) - bt0_mean)*((bt_l0_51) - bt0_mean) + ((bt_l0_52) - bt0_mean)*((bt_l0_52) - bt0_mean) + ((bt_l0_53) - bt0_mean)*((bt_l0_53) - bt0_mean) + ((bt_l0_54) - bt0_mean)*((bt_l0_54) - bt0_mean) + ((bt_l0_55) - bt0_mean)*((bt_l0_55) - bt0_mean) + ((bt_l0_56) - bt0_mean)*((bt_l0_56) - bt0_mean) + ((bt_l0_57) - bt0_mean)*((bt_l0_57) - bt0_mean) + ((bt_l0_58) - bt0_mean)*((bt_l0_58) - bt0_mean) + ((bt_l0_59) - bt0_mean)*((bt_l0_59) - bt0_mean) + ((bt_l0_60) - bt0_mean)*((bt_l0_60) - bt0_mean) + ((bt_l0_61) - bt0_mean)*((bt_l0_61) - bt0_mean) + ((bt_l0_62) - bt0_mean)*((bt_l0_62) - bt0_mean) + ((bt_l0_63) - bt0_mean)*((bt_l0_63) - bt0_mean)) / 64;
    bt_n0_0 = (((bt_l0_0) - bt0_mean) / sqrt(bt0_var + ln_eps)) * (0.70601826906204224) + (-0.30136185884475708);
    bt_g0_0 = gelu_approx(bt_n0_0);
    bt_n0_1 = (((bt_l0_1) - bt0_mean) / sqrt(bt0_var + ln_eps)) * (1.0884741544723511) + (0.039073240011930466);
    bt_g0_1 = gelu_approx(bt_n0_1);
    bt_n0_2 = (((bt_l0_2) - bt0_mean) / sqrt(bt0_var + ln_eps)) * (0.8307870626449585) + (-0.17313103377819061);
    bt_g0_2 = gelu_approx(bt_n0_2);
    bt_n0_3 = (((bt_l0_3) - bt0_mean) / sqrt(bt0_var + ln_eps)) * (0.86564004421234131) + (-0.016464691609144211);
    bt_g0_3 = gelu_approx(bt_n0_3);
    bt_n0_4 = (((bt_l0_4) - bt0_mean) / sqrt(bt0_var + ln_eps)) * (0.61075705289840698) + (-0.21842701733112335);
    bt_g0_4 = gelu_approx(bt_n0_4);
    bt_n0_5 = (((bt_l0_5) - bt0_mean) / sqrt(bt0_var + ln_eps)) * (1.410320520401001) + (0.0089713744819164276);
    bt_g0_5 = gelu_approx(bt_n0_5);
    bt_n0_6 = (((bt_l0_6) - bt0_mean) / sqrt(bt0_var + ln_eps)) * (1.0368642807006836) + (-0.021668499335646629);
    bt_g0_6 = gelu_approx(bt_n0_6);
    bt_n0_7 = (((bt_l0_7) - bt0_mean) / sqrt(bt0_var + ln_eps)) * (1.5501596927642822) + (0.071778453886508942);
    bt_g0_7 = gelu_approx(bt_n0_7);
    bt_n0_8 = (((bt_l0_8) - bt0_mean) / sqrt(bt0_var + ln_eps)) * (1.1129821538925171) + (-0.047802776098251343);
    bt_g0_8 = gelu_approx(bt_n0_8);
    bt_n0_9 = (((bt_l0_9) - bt0_mean) / sqrt(bt0_var + ln_eps)) * (1.1569110155105591) + (-0.023660745471715927);
    bt_g0_9 = gelu_approx(bt_n0_9);
    bt_n0_10 = (((bt_l0_10) - bt0_mean) / sqrt(bt0_var + ln_eps)) * (0.79849743843078613) + (-0.058868050575256348);
    bt_g0_10 = gelu_approx(bt_n0_10);
    bt_n0_11 = (((bt_l0_11) - bt0_mean) / sqrt(bt0_var + ln_eps)) * (0.7244458794593811) + (-0.22516535222530365);
    bt_g0_11 = gelu_approx(bt_n0_11);
    bt_n0_12 = (((bt_l0_12) - bt0_mean) / sqrt(bt0_var + ln_eps)) * (0.83625483512878418) + (-0.12221680581569672);
    bt_g0_12 = gelu_approx(bt_n0_12);
    bt_n0_13 = (((bt_l0_13) - bt0_mean) / sqrt(bt0_var + ln_eps)) * (0.83587551116943359) + (-0.16755887866020203);
    bt_g0_13 = gelu_approx(bt_n0_13);
    bt_n0_14 = (((bt_l0_14) - bt0_mean) / sqrt(bt0_var + ln_eps)) * (0.94115978479385376) + (-0.12916892766952515);
    bt_g0_14 = gelu_approx(bt_n0_14);
    bt_n0_15 = (((bt_l0_15) - bt0_mean) / sqrt(bt0_var + ln_eps)) * (2.188817024230957) + (0.11440914124250412);
    bt_g0_15 = gelu_approx(bt_n0_15);
    bt_n0_16 = (((bt_l0_16) - bt0_mean) / sqrt(bt0_var + ln_eps)) * (1.2047877311706543) + (0.0382404625415802);
    bt_g0_16 = gelu_approx(bt_n0_16);
    bt_n0_17 = (((bt_l0_17) - bt0_mean) / sqrt(bt0_var + ln_eps)) * (0.82530105113983154) + (-0.15227483212947845);
    bt_g0_17 = gelu_approx(bt_n0_17);
    bt_n0_18 = (((bt_l0_18) - bt0_mean) / sqrt(bt0_var + ln_eps)) * (0.99504584074020386) + (-0.057513274252414703);
    bt_g0_18 = gelu_approx(bt_n0_18);
    bt_n0_19 = (((bt_l0_19) - bt0_mean) / sqrt(bt0_var + ln_eps)) * (0.75464433431625366) + (-0.16527901589870453);
    bt_g0_19 = gelu_approx(bt_n0_19);
    bt_n0_20 = (((bt_l0_20) - bt0_mean) / sqrt(bt0_var + ln_eps)) * (1.382543683052063) + (-0.0020523446146398783);
    bt_g0_20 = gelu_approx(bt_n0_20);
    bt_n0_21 = (((bt_l0_21) - bt0_mean) / sqrt(bt0_var + ln_eps)) * (0.76189738512039185) + (-0.081297248601913452);
    bt_g0_21 = gelu_approx(bt_n0_21);
    bt_n0_22 = (((bt_l0_22) - bt0_mean) / sqrt(bt0_var + ln_eps)) * (1.0059499740600586) + (0.0033096969127655029);
    bt_g0_22 = gelu_approx(bt_n0_22);
    bt_n0_23 = (((bt_l0_23) - bt0_mean) / sqrt(bt0_var + ln_eps)) * (1.1821558475494385) + (-0.013313718140125275);
    bt_g0_23 = gelu_approx(bt_n0_23);
    bt_n0_24 = (((bt_l0_24) - bt0_mean) / sqrt(bt0_var + ln_eps)) * (1.2110868692398071) + (0.047790709882974625);
    bt_g0_24 = gelu_approx(bt_n0_24);
    bt_n0_25 = (((bt_l0_25) - bt0_mean) / sqrt(bt0_var + ln_eps)) * (1.3599786758422852) + (0.046665042638778687);
    bt_g0_25 = gelu_approx(bt_n0_25);
    bt_n0_26 = (((bt_l0_26) - bt0_mean) / sqrt(bt0_var + ln_eps)) * (1.0665498971939087) + (-0.027400800958275795);
    bt_g0_26 = gelu_approx(bt_n0_26);
    bt_n0_27 = (((bt_l0_27) - bt0_mean) / sqrt(bt0_var + ln_eps)) * (2.0962145328521729) + (0.091945715248584747);
    bt_g0_27 = gelu_approx(bt_n0_27);
    bt_n0_28 = (((bt_l0_28) - bt0_mean) / sqrt(bt0_var + ln_eps)) * (1.1761734485626221) + (-2.0324519937275909e-05);
    bt_g0_28 = gelu_approx(bt_n0_28);
    bt_n0_29 = (((bt_l0_29) - bt0_mean) / sqrt(bt0_var + ln_eps)) * (0.78795289993286133) + (-0.22935739159584045);
    bt_g0_29 = gelu_approx(bt_n0_29);
    bt_n0_30 = (((bt_l0_30) - bt0_mean) / sqrt(bt0_var + ln_eps)) * (0.8580784797668457) + (-0.14502950012683868);
    bt_g0_30 = gelu_approx(bt_n0_30);
    bt_n0_31 = (((bt_l0_31) - bt0_mean) / sqrt(bt0_var + ln_eps)) * (0.78919482231140137) + (-0.15608523786067963);
    bt_g0_31 = gelu_approx(bt_n0_31);
    bt_n0_32 = (((bt_l0_32) - bt0_mean) / sqrt(bt0_var + ln_eps)) * (1.8652966022491455) + (0.15021051466464996);
    bt_g0_32 = gelu_approx(bt_n0_32);
    bt_n0_33 = (((bt_l0_33) - bt0_mean) / sqrt(bt0_var + ln_eps)) * (1.1178435087203979) + (0.041114922612905502);
    bt_g0_33 = gelu_approx(bt_n0_33);
    bt_n0_34 = (((bt_l0_34) - bt0_mean) / sqrt(bt0_var + ln_eps)) * (0.6132664680480957) + (-0.22138603031635284);
    bt_g0_34 = gelu_approx(bt_n0_34);
    bt_n0_35 = (((bt_l0_35) - bt0_mean) / sqrt(bt0_var + ln_eps)) * (1.0278489589691162) + (0.011826019734144211);
    bt_g0_35 = gelu_approx(bt_n0_35);
    bt_n0_36 = (((bt_l0_36) - bt0_mean) / sqrt(bt0_var + ln_eps)) * (1.2020623683929443) + (0.0022277901880443096);
    bt_g0_36 = gelu_approx(bt_n0_36);
    bt_n0_37 = (((bt_l0_37) - bt0_mean) / sqrt(bt0_var + ln_eps)) * (1.0679060220718384) + (0.0087980711832642555);
    bt_g0_37 = gelu_approx(bt_n0_37);
    bt_n0_38 = (((bt_l0_38) - bt0_mean) / sqrt(bt0_var + ln_eps)) * (1.1817353963851929) + (0.021504547446966171);
    bt_g0_38 = gelu_approx(bt_n0_38);
    bt_n0_39 = (((bt_l0_39) - bt0_mean) / sqrt(bt0_var + ln_eps)) * (1.3807941675186157) + (0.10997098684310913);
    bt_g0_39 = gelu_approx(bt_n0_39);
    bt_n0_40 = (((bt_l0_40) - bt0_mean) / sqrt(bt0_var + ln_eps)) * (0.84206932783126831) + (-0.15903653204441071);
    bt_g0_40 = gelu_approx(bt_n0_40);
    bt_n0_41 = (((bt_l0_41) - bt0_mean) / sqrt(bt0_var + ln_eps)) * (0.87919026613235474) + (-0.11504388600587845);
    bt_g0_41 = gelu_approx(bt_n0_41);
    bt_n0_42 = (((bt_l0_42) - bt0_mean) / sqrt(bt0_var + ln_eps)) * (1.0603529214859009) + (-0.042093731462955475);
    bt_g0_42 = gelu_approx(bt_n0_42);
    bt_n0_43 = (((bt_l0_43) - bt0_mean) / sqrt(bt0_var + ln_eps)) * (0.824146568775177) + (-0.19809390604496002);
    bt_g0_43 = gelu_approx(bt_n0_43);
    bt_n0_44 = (((bt_l0_44) - bt0_mean) / sqrt(bt0_var + ln_eps)) * (1.2313311100006104) + (-0.0043377014808356762);
    bt_g0_44 = gelu_approx(bt_n0_44);
    bt_n0_45 = (((bt_l0_45) - bt0_mean) / sqrt(bt0_var + ln_eps)) * (1.0343461036682129) + (-0.044233273714780807);
    bt_g0_45 = gelu_approx(bt_n0_45);
    bt_n0_46 = (((bt_l0_46) - bt0_mean) / sqrt(bt0_var + ln_eps)) * (0.79878658056259155) + (-0.20818206667900085);
    bt_g0_46 = gelu_approx(bt_n0_46);
    bt_n0_47 = (((bt_l0_47) - bt0_mean) / sqrt(bt0_var + ln_eps)) * (0.66295194625854492) + (-0.31399059295654297);
    bt_g0_47 = gelu_approx(bt_n0_47);
    bt_n0_48 = (((bt_l0_48) - bt0_mean) / sqrt(bt0_var + ln_eps)) * (0.99930489063262939) + (-0.060251407325267792);
    bt_g0_48 = gelu_approx(bt_n0_48);
    bt_n0_49 = (((bt_l0_49) - bt0_mean) / sqrt(bt0_var + ln_eps)) * (1.0450742244720459) + (-0.0058458233252167702);
    bt_g0_49 = gelu_approx(bt_n0_49);
    bt_n0_50 = (((bt_l0_50) - bt0_mean) / sqrt(bt0_var + ln_eps)) * (0.89079546928405762) + (-0.27743542194366455);
    bt_g0_50 = gelu_approx(bt_n0_50);
    bt_n0_51 = (((bt_l0_51) - bt0_mean) / sqrt(bt0_var + ln_eps)) * (1.018502950668335) + (-0.0535111203789711);
    bt_g0_51 = gelu_approx(bt_n0_51);
    bt_n0_52 = (((bt_l0_52) - bt0_mean) / sqrt(bt0_var + ln_eps)) * (0.99236106872558594) + (-0.060492072254419327);
    bt_g0_52 = gelu_approx(bt_n0_52);
    bt_n0_53 = (((bt_l0_53) - bt0_mean) / sqrt(bt0_var + ln_eps)) * (0.89554119110107422) + (-0.12536022067070007);
    bt_g0_53 = gelu_approx(bt_n0_53);
    bt_n0_54 = (((bt_l0_54) - bt0_mean) / sqrt(bt0_var + ln_eps)) * (0.92008548974990845) + (-0.004705705214291811);
    bt_g0_54 = gelu_approx(bt_n0_54);
    bt_n0_55 = (((bt_l0_55) - bt0_mean) / sqrt(bt0_var + ln_eps)) * (0.74099177122116089) + (-0.1592339426279068);
    bt_g0_55 = gelu_approx(bt_n0_55);
    bt_n0_56 = (((bt_l0_56) - bt0_mean) / sqrt(bt0_var + ln_eps)) * (0.71842777729034424) + (-0.036044768989086151);
    bt_g0_56 = gelu_approx(bt_n0_56);
    bt_n0_57 = (((bt_l0_57) - bt0_mean) / sqrt(bt0_var + ln_eps)) * (0.80585169792175293) + (-0.21489210426807404);
    bt_g0_57 = gelu_approx(bt_n0_57);
    bt_n0_58 = (((bt_l0_58) - bt0_mean) / sqrt(bt0_var + ln_eps)) * (1.1499437093734741) + (-0.034955728799104691);
    bt_g0_58 = gelu_approx(bt_n0_58);
    bt_n0_59 = (((bt_l0_59) - bt0_mean) / sqrt(bt0_var + ln_eps)) * (0.96530890464782715) + (-0.082696340978145599);
    bt_g0_59 = gelu_approx(bt_n0_59);
    bt_n0_60 = (((bt_l0_60) - bt0_mean) / sqrt(bt0_var + ln_eps)) * (1.0859452486038208) + (0.025805069133639336);
    bt_g0_60 = gelu_approx(bt_n0_60);
    bt_n0_61 = (((bt_l0_61) - bt0_mean) / sqrt(bt0_var + ln_eps)) * (1.0796912908554077) + (0.045560620725154877);
    bt_g0_61 = gelu_approx(bt_n0_61);
    bt_n0_62 = (((bt_l0_62) - bt0_mean) / sqrt(bt0_var + ln_eps)) * (1.7626711130142212) + (0.048493806272745132);
    bt_g0_62 = gelu_approx(bt_n0_62);
    bt_n0_63 = (((bt_l0_63) - bt0_mean) / sqrt(bt0_var + ln_eps)) * (0.97060865163803101) + (-0.066258907318115234);
    bt_g0_63 = gelu_approx(bt_n0_63);
    bt_l1_0 = -0.062124975025653839;
    bt_l1_0 = bt_l1_0 + (-0.021330578252673149)*bt_g0_0;
    bt_l1_0 = bt_l1_0 + (0.079873189330101013)*bt_g0_1;
    bt_l1_0 = bt_l1_0 + (-0.064875409007072449)*bt_g0_2;
    bt_l1_0 = bt_l1_0 + (0.024601152166724205)*bt_g0_3;
    bt_l1_0 = bt_l1_0 + (-0.039698425680398941)*bt_g0_4;
    bt_l1_0 = bt_l1_0 + (-0.040837816894054413)*bt_g0_5;
    bt_l1_0 = bt_l1_0 + (-0.086331762373447418)*bt_g0_6;
    bt_l1_0 = bt_l1_0 + (-0.068581528961658478)*bt_g0_7;
    bt_l1_0 = bt_l1_0 + (-0.098178617656230927)*bt_g0_8;
    bt_l1_0 = bt_l1_0 + (0.024348387494683266)*bt_g0_9;
    bt_l1_0 = bt_l1_0 + (-0.0086067784577608109)*bt_g0_10;
    bt_l1_0 = bt_l1_0 + (-0.18355901539325714)*bt_g0_11;
    bt_l1_0 = bt_l1_0 + (-0.034693434834480286)*bt_g0_12;
    bt_l1_0 = bt_l1_0 + (0.048140935599803925)*bt_g0_13;
    bt_l1_0 = bt_l1_0 + (-0.27095082402229309)*bt_g0_14;
    bt_l1_0 = bt_l1_0 + (0.1857486218214035)*bt_g0_15;
    bt_l1_0 = bt_l1_0 + (-0.14297574758529663)*bt_g0_16;
    bt_l1_0 = bt_l1_0 + (-0.13564352691173553)*bt_g0_17;
    bt_l1_0 = bt_l1_0 + (0.01197794359177351)*bt_g0_18;
    bt_l1_0 = bt_l1_0 + (-0.042196124792098999)*bt_g0_19;
    bt_l1_0 = bt_l1_0 + (0.024858733639121056)*bt_g0_20;
    bt_l1_0 = bt_l1_0 + (-0.071867510676383972)*bt_g0_21;
    bt_l1_0 = bt_l1_0 + (0.059483565390110016)*bt_g0_22;
    bt_l1_0 = bt_l1_0 + (-0.11170009523630142)*bt_g0_23;
    bt_l1_0 = bt_l1_0 + (-0.25538566708564758)*bt_g0_24;
    bt_l1_0 = bt_l1_0 + (0.020224738866090775)*bt_g0_25;
    bt_l1_0 = bt_l1_0 + (0.21295399963855743)*bt_g0_26;
    bt_l1_0 = bt_l1_0 + (-0.057968426495790482)*bt_g0_27;
    bt_l1_0 = bt_l1_0 + (-0.15519464015960693)*bt_g0_28;
    bt_l1_0 = bt_l1_0 + (0.073705174028873444)*bt_g0_29;
    bt_l1_0 = bt_l1_0 + (-0.12972442805767059)*bt_g0_30;
    bt_l1_0 = bt_l1_0 + (0.051568124443292618)*bt_g0_31;
    bt_l1_0 = bt_l1_0 + (-0.19231604039669037)*bt_g0_32;
    bt_l1_0 = bt_l1_0 + (0.10765954852104187)*bt_g0_33;
    bt_l1_0 = bt_l1_0 + (-0.078125014901161194)*bt_g0_34;
    bt_l1_0 = bt_l1_0 + (-0.1239255890250206)*bt_g0_35;
    bt_l1_0 = bt_l1_0 + (0.0245785191655159)*bt_g0_36;
    bt_l1_0 = bt_l1_0 + (0.14324349164962769)*bt_g0_37;
    bt_l1_0 = bt_l1_0 + (0.014396791346371174)*bt_g0_38;
    bt_l1_0 = bt_l1_0 + (-0.0037506481166929007)*bt_g0_39;
    bt_l1_0 = bt_l1_0 + (-0.033376853913068771)*bt_g0_40;
    bt_l1_0 = bt_l1_0 + (-0.078620389103889465)*bt_g0_41;
    bt_l1_0 = bt_l1_0 + (0.048675067722797394)*bt_g0_42;
    bt_l1_0 = bt_l1_0 + (0.02639060840010643)*bt_g0_43;
    bt_l1_0 = bt_l1_0 + (-0.54036277532577515)*bt_g0_44;
    bt_l1_0 = bt_l1_0 + (0.093005076050758362)*bt_g0_45;
    bt_l1_0 = bt_l1_0 + (-0.052312593907117844)*bt_g0_46;
    bt_l1_0 = bt_l1_0 + (0.079405106604099274)*bt_g0_47;
    bt_l1_0 = bt_l1_0 + (0.12498168647289276)*bt_g0_48;
    bt_l1_0 = bt_l1_0 + (-0.013333773240447044)*bt_g0_49;
    bt_l1_0 = bt_l1_0 + (-0.15117476880550385)*bt_g0_50;
    bt_l1_0 = bt_l1_0 + (-0.11770343780517578)*bt_g0_51;
    bt_l1_0 = bt_l1_0 + (-0.089240826666355133)*bt_g0_52;
    bt_l1_0 = bt_l1_0 + (-0.01111745648086071)*bt_g0_53;
    bt_l1_0 = bt_l1_0 + (0.0033583794720470905)*bt_g0_54;
    bt_l1_0 = bt_l1_0 + (0.04086511954665184)*bt_g0_55;
    bt_l1_0 = bt_l1_0 + (-0.1131511852145195)*bt_g0_56;
    bt_l1_0 = bt_l1_0 + (-0.07184639573097229)*bt_g0_57;
    bt_l1_0 = bt_l1_0 + (-0.017712580040097237)*bt_g0_58;
    bt_l1_0 = bt_l1_0 + (0.0063369958661496639)*bt_g0_59;
    bt_l1_0 = bt_l1_0 + (0.052897084504365921)*bt_g0_60;
    bt_l1_0 = bt_l1_0 + (0.1542477160692215)*bt_g0_61;
    bt_l1_0 = bt_l1_0 + (0.24761457741260529)*bt_g0_62;
    bt_l1_0 = bt_l1_0 + (-0.083055004477500916)*bt_g0_63;
    bt_l1_1 = -0.070877134799957275;
    bt_l1_1 = bt_l1_1 + (-0.099473893642425537)*bt_g0_0;
    bt_l1_1 = bt_l1_1 + (-0.49564710259437561)*bt_g0_1;
    bt_l1_1 = bt_l1_1 + (0.11779431998729706)*bt_g0_2;
    bt_l1_1 = bt_l1_1 + (-0.080267943441867828)*bt_g0_3;
    bt_l1_1 = bt_l1_1 + (-0.0037038740701973438)*bt_g0_4;
    bt_l1_1 = bt_l1_1 + (0.48450183868408203)*bt_g0_5;
    bt_l1_1 = bt_l1_1 + (-0.18920107185840607)*bt_g0_6;
    bt_l1_1 = bt_l1_1 + (-0.031950343400239944)*bt_g0_7;
    bt_l1_1 = bt_l1_1 + (0.18493011593818665)*bt_g0_8;
    bt_l1_1 = bt_l1_1 + (0.13879229128360748)*bt_g0_9;
    bt_l1_1 = bt_l1_1 + (-0.035452529788017273)*bt_g0_10;
    bt_l1_1 = bt_l1_1 + (-0.12953586876392365)*bt_g0_11;
    bt_l1_1 = bt_l1_1 + (0.051726974546909332)*bt_g0_12;
    bt_l1_1 = bt_l1_1 + (0.12081561237573624)*bt_g0_13;
    bt_l1_1 = bt_l1_1 + (0.10919755697250366)*bt_g0_14;
    bt_l1_1 = bt_l1_1 + (0.94662171602249146)*bt_g0_15;
    bt_l1_1 = bt_l1_1 + (0.28758028149604797)*bt_g0_16;
    bt_l1_1 = bt_l1_1 + (0.14075632393360138)*bt_g0_17;
    bt_l1_1 = bt_l1_1 + (-0.15382927656173706)*bt_g0_18;
    bt_l1_1 = bt_l1_1 + (-0.085766158998012543)*bt_g0_19;
    bt_l1_1 = bt_l1_1 + (-0.055710874497890472)*bt_g0_20;
    bt_l1_1 = bt_l1_1 + (-0.08153998851776123)*bt_g0_21;
    bt_l1_1 = bt_l1_1 + (-0.27632027864456177)*bt_g0_22;
    bt_l1_1 = bt_l1_1 + (0.16306771337985992)*bt_g0_23;
    bt_l1_1 = bt_l1_1 + (0.43113628029823303)*bt_g0_24;
    bt_l1_1 = bt_l1_1 + (-0.14016346633434296)*bt_g0_25;
    bt_l1_1 = bt_l1_1 + (0.044565260410308838)*bt_g0_26;
    bt_l1_1 = bt_l1_1 + (-0.03513500839471817)*bt_g0_27;
    bt_l1_1 = bt_l1_1 + (0.22727689146995544)*bt_g0_28;
    bt_l1_1 = bt_l1_1 + (-0.11600399017333984)*bt_g0_29;
    bt_l1_1 = bt_l1_1 + (-0.16162629425525665)*bt_g0_30;
    bt_l1_1 = bt_l1_1 + (-0.0883592888712883)*bt_g0_31;
    bt_l1_1 = bt_l1_1 + (0.0028589945286512375)*bt_g0_32;
    bt_l1_1 = bt_l1_1 + (-0.54720133543014526)*bt_g0_33;
    bt_l1_1 = bt_l1_1 + (-0.020468264818191528)*bt_g0_34;
    bt_l1_1 = bt_l1_1 + (0.19748565554618835)*bt_g0_35;
    bt_l1_1 = bt_l1_1 + (0.37075397372245789)*bt_g0_36;
    bt_l1_1 = bt_l1_1 + (0.22941264510154724)*bt_g0_37;
    bt_l1_1 = bt_l1_1 + (0.44488382339477539)*bt_g0_38;
    bt_l1_1 = bt_l1_1 + (-0.036757670342922211)*bt_g0_39;
    bt_l1_1 = bt_l1_1 + (-0.21306908130645752)*bt_g0_40;
    bt_l1_1 = bt_l1_1 + (-0.15984596312046051)*bt_g0_41;
    bt_l1_1 = bt_l1_1 + (0.19109342992305756)*bt_g0_42;
    bt_l1_1 = bt_l1_1 + (-0.10688662528991699)*bt_g0_43;
    bt_l1_1 = bt_l1_1 + (-0.11276805400848389)*bt_g0_44;
    bt_l1_1 = bt_l1_1 + (-0.10324749350547791)*bt_g0_45;
    bt_l1_1 = bt_l1_1 + (-0.11173667013645172)*bt_g0_46;
    bt_l1_1 = bt_l1_1 + (0.039580322802066803)*bt_g0_47;
    bt_l1_1 = bt_l1_1 + (-0.17616662383079529)*bt_g0_48;
    bt_l1_1 = bt_l1_1 + (0.27312052249908447)*bt_g0_49;
    bt_l1_1 = bt_l1_1 + (-0.15274207293987274)*bt_g0_50;
    bt_l1_1 = bt_l1_1 + (0.045434903353452682)*bt_g0_51;
    bt_l1_1 = bt_l1_1 + (-0.093623608350753784)*bt_g0_52;
    bt_l1_1 = bt_l1_1 + (0.00064183806534856558)*bt_g0_53;
    bt_l1_1 = bt_l1_1 + (-0.054879751056432724)*bt_g0_54;
    bt_l1_1 = bt_l1_1 + (0.0030958827119320631)*bt_g0_55;
    bt_l1_1 = bt_l1_1 + (-0.073327973484992981)*bt_g0_56;
    bt_l1_1 = bt_l1_1 + (0.049387510865926743)*bt_g0_57;
    bt_l1_1 = bt_l1_1 + (0.44187188148498535)*bt_g0_58;
    bt_l1_1 = bt_l1_1 + (0.052991840988397598)*bt_g0_59;
    bt_l1_1 = bt_l1_1 + (-0.38308218121528625)*bt_g0_60;
    bt_l1_1 = bt_l1_1 + (0.26730239391326904)*bt_g0_61;
    bt_l1_1 = bt_l1_1 + (0.60549747943878174)*bt_g0_62;
    bt_l1_1 = bt_l1_1 + (0.05229920893907547)*bt_g0_63;
    bt_l1_2 = -0.041885942220687866;
    bt_l1_2 = bt_l1_2 + (-0.026520660147070885)*bt_g0_0;
    bt_l1_2 = bt_l1_2 + (-0.12965358793735504)*bt_g0_1;
    bt_l1_2 = bt_l1_2 + (-0.042754184454679489)*bt_g0_2;
    bt_l1_2 = bt_l1_2 + (-0.056254658848047256)*bt_g0_3;
    bt_l1_2 = bt_l1_2 + (-0.07734236866235733)*bt_g0_4;
    bt_l1_2 = bt_l1_2 + (-0.12748116254806519)*bt_g0_5;
    bt_l1_2 = bt_l1_2 + (0.0057656210847198963)*bt_g0_6;
    bt_l1_2 = bt_l1_2 + (-0.041745185852050781)*bt_g0_7;
    bt_l1_2 = bt_l1_2 + (0.071551956236362457)*bt_g0_8;
    bt_l1_2 = bt_l1_2 + (-0.10173565149307251)*bt_g0_9;
    bt_l1_2 = bt_l1_2 + (-0.01422173622995615)*bt_g0_10;
    bt_l1_2 = bt_l1_2 + (0.056755304336547852)*bt_g0_11;
    bt_l1_2 = bt_l1_2 + (0.023504240438342094)*bt_g0_12;
    bt_l1_2 = bt_l1_2 + (0.02427152544260025)*bt_g0_13;
    bt_l1_2 = bt_l1_2 + (0.038656521588563919)*bt_g0_14;
    bt_l1_2 = bt_l1_2 + (0.0014620954170823097)*bt_g0_15;
    bt_l1_2 = bt_l1_2 + (0.028774941340088844)*bt_g0_16;
    bt_l1_2 = bt_l1_2 + (-0.024962848052382469)*bt_g0_17;
    bt_l1_2 = bt_l1_2 + (-0.13957008719444275)*bt_g0_18;
    bt_l1_2 = bt_l1_2 + (0.025473551824688911)*bt_g0_19;
    bt_l1_2 = bt_l1_2 + (0.13742931187152863)*bt_g0_20;
    bt_l1_2 = bt_l1_2 + (0.047517672181129456)*bt_g0_21;
    bt_l1_2 = bt_l1_2 + (0.10214383900165558)*bt_g0_22;
    bt_l1_2 = bt_l1_2 + (-0.0027344734407961369)*bt_g0_23;
    bt_l1_2 = bt_l1_2 + (-0.048115994781255722)*bt_g0_24;
    bt_l1_2 = bt_l1_2 + (0.056577987968921661)*bt_g0_25;
    bt_l1_2 = bt_l1_2 + (0.083662621676921844)*bt_g0_26;
    bt_l1_2 = bt_l1_2 + (-0.051236465573310852)*bt_g0_27;
    bt_l1_2 = bt_l1_2 + (-0.086805351078510284)*bt_g0_28;
    bt_l1_2 = bt_l1_2 + (-0.0037518925964832306)*bt_g0_29;
    bt_l1_2 = bt_l1_2 + (-0.067607909440994263)*bt_g0_30;
    bt_l1_2 = bt_l1_2 + (-0.071180813014507294)*bt_g0_31;
    bt_l1_2 = bt_l1_2 + (-0.24650834500789642)*bt_g0_32;
    bt_l1_2 = bt_l1_2 + (0.05347568541765213)*bt_g0_33;
    bt_l1_2 = bt_l1_2 + (-0.059394232928752899)*bt_g0_34;
    bt_l1_2 = bt_l1_2 + (0.016848124563694)*bt_g0_35;
    bt_l1_2 = bt_l1_2 + (0.20254820585250854)*bt_g0_36;
    bt_l1_2 = bt_l1_2 + (0.061229567974805832)*bt_g0_37;
    bt_l1_2 = bt_l1_2 + (0.028713595122098923)*bt_g0_38;
    bt_l1_2 = bt_l1_2 + (0.023028243333101273)*bt_g0_39;
    bt_l1_2 = bt_l1_2 + (0.0038288305513560772)*bt_g0_40;
    bt_l1_2 = bt_l1_2 + (0.061314277350902557)*bt_g0_41;
    bt_l1_2 = bt_l1_2 + (-0.069539360702037811)*bt_g0_42;
    bt_l1_2 = bt_l1_2 + (-0.018692916259169579)*bt_g0_43;
    bt_l1_2 = bt_l1_2 + (-0.11601350456476212)*bt_g0_44;
    bt_l1_2 = bt_l1_2 + (0.068362079560756683)*bt_g0_45;
    bt_l1_2 = bt_l1_2 + (0.066866651177406311)*bt_g0_46;
    bt_l1_2 = bt_l1_2 + (0.13566185534000397)*bt_g0_47;
    bt_l1_2 = bt_l1_2 + (-0.070772238075733185)*bt_g0_48;
    bt_l1_2 = bt_l1_2 + (0.11018894612789154)*bt_g0_49;
    bt_l1_2 = bt_l1_2 + (-0.009136466309428215)*bt_g0_50;
    bt_l1_2 = bt_l1_2 + (-0.10076723247766495)*bt_g0_51;
    bt_l1_2 = bt_l1_2 + (-0.089726336300373077)*bt_g0_52;
    bt_l1_2 = bt_l1_2 + (-0.051996879279613495)*bt_g0_53;
    bt_l1_2 = bt_l1_2 + (0.034274205565452576)*bt_g0_54;
    bt_l1_2 = bt_l1_2 + (0.050846904516220093)*bt_g0_55;
    bt_l1_2 = bt_l1_2 + (-0.088679701089859009)*bt_g0_56;
    bt_l1_2 = bt_l1_2 + (-0.024087265133857727)*bt_g0_57;
    bt_l1_2 = bt_l1_2 + (0.20636613667011261)*bt_g0_58;
    bt_l1_2 = bt_l1_2 + (0.01535270269960165)*bt_g0_59;
    bt_l1_2 = bt_l1_2 + (-0.1083720400929451)*bt_g0_60;
    bt_l1_2 = bt_l1_2 + (0.10251754522323608)*bt_g0_61;
    bt_l1_2 = bt_l1_2 + (-0.057002328336238861)*bt_g0_62;
    bt_l1_2 = bt_l1_2 + (-0.067450739443302155)*bt_g0_63;
    bt_l1_3 = -0.087063252925872803;
    bt_l1_3 = bt_l1_3 + (-0.011788844130933285)*bt_g0_0;
    bt_l1_3 = bt_l1_3 + (-0.10878536105155945)*bt_g0_1;
    bt_l1_3 = bt_l1_3 + (-0.036111500114202499)*bt_g0_2;
    bt_l1_3 = bt_l1_3 + (-0.061884433031082153)*bt_g0_3;
    bt_l1_3 = bt_l1_3 + (0.020018033683300018)*bt_g0_4;
    bt_l1_3 = bt_l1_3 + (-0.062459498643875122)*bt_g0_5;
    bt_l1_3 = bt_l1_3 + (0.060047656297683716)*bt_g0_6;
    bt_l1_3 = bt_l1_3 + (0.03364294022321701)*bt_g0_7;
    bt_l1_3 = bt_l1_3 + (-0.12326601147651672)*bt_g0_8;
    bt_l1_3 = bt_l1_3 + (0.11463158577680588)*bt_g0_9;
    bt_l1_3 = bt_l1_3 + (-0.020018627867102623)*bt_g0_10;
    bt_l1_3 = bt_l1_3 + (-0.00047428329708054662)*bt_g0_11;
    bt_l1_3 = bt_l1_3 + (-0.015141157433390617)*bt_g0_12;
    bt_l1_3 = bt_l1_3 + (0.075525745749473572)*bt_g0_13;
    bt_l1_3 = bt_l1_3 + (0.02070273645222187)*bt_g0_14;
    bt_l1_3 = bt_l1_3 + (-0.0082961050793528557)*bt_g0_15;
    bt_l1_3 = bt_l1_3 + (0.0089067574590444565)*bt_g0_16;
    bt_l1_3 = bt_l1_3 + (-0.078239172697067261)*bt_g0_17;
    bt_l1_3 = bt_l1_3 + (0.056642249226570129)*bt_g0_18;
    bt_l1_3 = bt_l1_3 + (3.5090542951365933e-05)*bt_g0_19;
    bt_l1_3 = bt_l1_3 + (-0.10100644826889038)*bt_g0_20;
    bt_l1_3 = bt_l1_3 + (-0.081916391849517822)*bt_g0_21;
    bt_l1_3 = bt_l1_3 + (0.049413286149501801)*bt_g0_22;
    bt_l1_3 = bt_l1_3 + (-0.0032903214450925589)*bt_g0_23;
    bt_l1_3 = bt_l1_3 + (0.052125543355941772)*bt_g0_24;
    bt_l1_3 = bt_l1_3 + (-0.14647871255874634)*bt_g0_25;
    bt_l1_3 = bt_l1_3 + (0.044959273189306259)*bt_g0_26;
    bt_l1_3 = bt_l1_3 + (-0.22372478246688843)*bt_g0_27;
    bt_l1_3 = bt_l1_3 + (-0.011683535762131214)*bt_g0_28;
    bt_l1_3 = bt_l1_3 + (0.10501626133918762)*bt_g0_29;
    bt_l1_3 = bt_l1_3 + (0.035734117031097412)*bt_g0_30;
    bt_l1_3 = bt_l1_3 + (0.043373126536607742)*bt_g0_31;
    bt_l1_3 = bt_l1_3 + (-0.0030949432402849197)*bt_g0_32;
    bt_l1_3 = bt_l1_3 + (0.028522983193397522)*bt_g0_33;
    bt_l1_3 = bt_l1_3 + (0.038698814809322357)*bt_g0_34;
    bt_l1_3 = bt_l1_3 + (-0.098156504333019257)*bt_g0_35;
    bt_l1_3 = bt_l1_3 + (-0.034162305295467377)*bt_g0_36;
    bt_l1_3 = bt_l1_3 + (-0.12035118788480759)*bt_g0_37;
    bt_l1_3 = bt_l1_3 + (0.019073348492383957)*bt_g0_38;
    bt_l1_3 = bt_l1_3 + (0.025858882814645767)*bt_g0_39;
    bt_l1_3 = bt_l1_3 + (-0.023485215380787849)*bt_g0_40;
    bt_l1_3 = bt_l1_3 + (0.11327044665813446)*bt_g0_41;
    bt_l1_3 = bt_l1_3 + (-0.082058995962142944)*bt_g0_42;
    bt_l1_3 = bt_l1_3 + (0.083372719585895538)*bt_g0_43;
    bt_l1_3 = bt_l1_3 + (-0.058752395212650299)*bt_g0_44;
    bt_l1_3 = bt_l1_3 + (-0.081572487950325012)*bt_g0_45;
    bt_l1_3 = bt_l1_3 + (0.09298233687877655)*bt_g0_46;
    bt_l1_3 = bt_l1_3 + (0.085193261504173279)*bt_g0_47;
    bt_l1_3 = bt_l1_3 + (0.1498677134513855)*bt_g0_48;
    bt_l1_3 = bt_l1_3 + (0.02182786725461483)*bt_g0_49;
    bt_l1_3 = bt_l1_3 + (-0.045133095234632492)*bt_g0_50;
    bt_l1_3 = bt_l1_3 + (0.084871292114257812)*bt_g0_51;
    bt_l1_3 = bt_l1_3 + (0.071927249431610107)*bt_g0_52;
    bt_l1_3 = bt_l1_3 + (-0.018561298027634621)*bt_g0_53;
    bt_l1_3 = bt_l1_3 + (-0.056852854788303375)*bt_g0_54;
    bt_l1_3 = bt_l1_3 + (-0.017768053337931633)*bt_g0_55;
    bt_l1_3 = bt_l1_3 + (-0.15868391096591949)*bt_g0_56;
    bt_l1_3 = bt_l1_3 + (0.15832380950450897)*bt_g0_57;
    bt_l1_3 = bt_l1_3 + (-0.012853138148784637)*bt_g0_58;
    bt_l1_3 = bt_l1_3 + (0.030755555257201195)*bt_g0_59;
    bt_l1_3 = bt_l1_3 + (-0.02611377090215683)*bt_g0_60;
    bt_l1_3 = bt_l1_3 + (-0.25185257196426392)*bt_g0_61;
    bt_l1_3 = bt_l1_3 + (-0.1527644544839859)*bt_g0_62;
    bt_l1_3 = bt_l1_3 + (0.002220414113253355)*bt_g0_63;
    bt_l1_4 = 0.03016776405274868;
    bt_l1_4 = bt_l1_4 + (-0.11701030284166336)*bt_g0_0;
    bt_l1_4 = bt_l1_4 + (-0.037241227924823761)*bt_g0_1;
    bt_l1_4 = bt_l1_4 + (0.027141166850924492)*bt_g0_2;
    bt_l1_4 = bt_l1_4 + (-0.10270702838897705)*bt_g0_3;
    bt_l1_4 = bt_l1_4 + (-0.17156170308589935)*bt_g0_4;
    bt_l1_4 = bt_l1_4 + (-0.095970399677753448)*bt_g0_5;
    bt_l1_4 = bt_l1_4 + (-0.01984710805118084)*bt_g0_6;
    bt_l1_4 = bt_l1_4 + (-0.090459086000919342)*bt_g0_7;
    bt_l1_4 = bt_l1_4 + (0.3606264591217041)*bt_g0_8;
    bt_l1_4 = bt_l1_4 + (-0.0072877546772360802)*bt_g0_9;
    bt_l1_4 = bt_l1_4 + (-0.026758862659335136)*bt_g0_10;
    bt_l1_4 = bt_l1_4 + (-0.009791945107281208)*bt_g0_11;
    bt_l1_4 = bt_l1_4 + (0.064821474254131317)*bt_g0_12;
    bt_l1_4 = bt_l1_4 + (0.031907431781291962)*bt_g0_13;
    bt_l1_4 = bt_l1_4 + (-0.075733169913291931)*bt_g0_14;
    bt_l1_4 = bt_l1_4 + (0.25200751423835754)*bt_g0_15;
    bt_l1_4 = bt_l1_4 + (0.092991501092910767)*bt_g0_16;
    bt_l1_4 = bt_l1_4 + (0.09823162853717804)*bt_g0_17;
    bt_l1_4 = bt_l1_4 + (-0.1363731324672699)*bt_g0_18;
    bt_l1_4 = bt_l1_4 + (-0.20310293138027191)*bt_g0_19;
    bt_l1_4 = bt_l1_4 + (-0.085760749876499176)*bt_g0_20;
    bt_l1_4 = bt_l1_4 + (-0.080571845173835754)*bt_g0_21;
    bt_l1_4 = bt_l1_4 + (0.048957828432321548)*bt_g0_22;
    bt_l1_4 = bt_l1_4 + (0.23909799754619598)*bt_g0_23;
    bt_l1_4 = bt_l1_4 + (-0.38581320643424988)*bt_g0_24;
    bt_l1_4 = bt_l1_4 + (0.15738601982593536)*bt_g0_25;
    bt_l1_4 = bt_l1_4 + (0.057149145752191544)*bt_g0_26;
    bt_l1_4 = bt_l1_4 + (-0.20314881205558777)*bt_g0_27;
    bt_l1_4 = bt_l1_4 + (-0.33221516013145447)*bt_g0_28;
    bt_l1_4 = bt_l1_4 + (-0.23582462966442108)*bt_g0_29;
    bt_l1_4 = bt_l1_4 + (-0.12472931295633316)*bt_g0_30;
    bt_l1_4 = bt_l1_4 + (-0.2592121958732605)*bt_g0_31;
    bt_l1_4 = bt_l1_4 + (0.04731324315071106)*bt_g0_32;
    bt_l1_4 = bt_l1_4 + (0.062026754021644592)*bt_g0_33;
    bt_l1_4 = bt_l1_4 + (-0.18893353641033173)*bt_g0_34;
    bt_l1_4 = bt_l1_4 + (0.15905909240245819)*bt_g0_35;
    bt_l1_4 = bt_l1_4 + (0.58429557085037231)*bt_g0_36;
    bt_l1_4 = bt_l1_4 + (0.23580785095691681)*bt_g0_37;
    bt_l1_4 = bt_l1_4 + (0.19608399271965027)*bt_g0_38;
    bt_l1_4 = bt_l1_4 + (0.026628321036696434)*bt_g0_39;
    bt_l1_4 = bt_l1_4 + (-0.029829405248165131)*bt_g0_40;
    bt_l1_4 = bt_l1_4 + (-0.17077574133872986)*bt_g0_41;
    bt_l1_4 = bt_l1_4 + (0.20167537033557892)*bt_g0_42;
    bt_l1_4 = bt_l1_4 + (-0.020554039627313614)*bt_g0_43;
    bt_l1_4 = bt_l1_4 + (0.048076320439577103)*bt_g0_44;
    bt_l1_4 = bt_l1_4 + (-0.092806525528430939)*bt_g0_45;
    bt_l1_4 = bt_l1_4 + (-0.19752731919288635)*bt_g0_46;
    bt_l1_4 = bt_l1_4 + (0.091830931603908539)*bt_g0_47;
    bt_l1_4 = bt_l1_4 + (-0.035576432943344116)*bt_g0_48;
    bt_l1_4 = bt_l1_4 + (0.093304961919784546)*bt_g0_49;
    bt_l1_4 = bt_l1_4 + (-0.10921597480773926)*bt_g0_50;
    bt_l1_4 = bt_l1_4 + (0.015073454007506371)*bt_g0_51;
    bt_l1_4 = bt_l1_4 + (0.035260114818811417)*bt_g0_52;
    bt_l1_4 = bt_l1_4 + (-0.27970358729362488)*bt_g0_53;
    bt_l1_4 = bt_l1_4 + (0.04840710386633873)*bt_g0_54;
    bt_l1_4 = bt_l1_4 + (0.029132097959518433)*bt_g0_55;
    bt_l1_4 = bt_l1_4 + (-0.13110277056694031)*bt_g0_56;
    bt_l1_4 = bt_l1_4 + (0.029147686436772346)*bt_g0_57;
    bt_l1_4 = bt_l1_4 + (0.35982176661491394)*bt_g0_58;
    bt_l1_4 = bt_l1_4 + (0.0061063370667397976)*bt_g0_59;
    bt_l1_4 = bt_l1_4 + (0.10520739853382111)*bt_g0_60;
    bt_l1_4 = bt_l1_4 + (0.10750199109315872)*bt_g0_61;
    bt_l1_4 = bt_l1_4 + (0.44402715563774109)*bt_g0_62;
    bt_l1_4 = bt_l1_4 + (-0.11388245970010757)*bt_g0_63;
    bt_l1_5 = -0.038558069616556168;
    bt_l1_5 = bt_l1_5 + (0.046676374971866608)*bt_g0_0;
    bt_l1_5 = bt_l1_5 + (-0.043239694088697433)*bt_g0_1;
    bt_l1_5 = bt_l1_5 + (-0.099599234759807587)*bt_g0_2;
    bt_l1_5 = bt_l1_5 + (-0.078315280377864838)*bt_g0_3;
    bt_l1_5 = bt_l1_5 + (0.18162389099597931)*bt_g0_4;
    bt_l1_5 = bt_l1_5 + (-0.28620234131813049)*bt_g0_5;
    bt_l1_5 = bt_l1_5 + (-0.23998832702636719)*bt_g0_6;
    bt_l1_5 = bt_l1_5 + (-0.051319964230060577)*bt_g0_7;
    bt_l1_5 = bt_l1_5 + (-0.054432418197393417)*bt_g0_8;
    bt_l1_5 = bt_l1_5 + (-0.1518665999174118)*bt_g0_9;
    bt_l1_5 = bt_l1_5 + (-0.16938063502311707)*bt_g0_10;
    bt_l1_5 = bt_l1_5 + (0.019222253933548927)*bt_g0_11;
    bt_l1_5 = bt_l1_5 + (-0.066848717629909515)*bt_g0_12;
    bt_l1_5 = bt_l1_5 + (0.094973206520080566)*bt_g0_13;
    bt_l1_5 = bt_l1_5 + (-0.093475647270679474)*bt_g0_14;
    bt_l1_5 = bt_l1_5 + (-0.56728506088256836)*bt_g0_15;
    bt_l1_5 = bt_l1_5 + (-0.053025159984827042)*bt_g0_16;
    bt_l1_5 = bt_l1_5 + (0.057234335690736771)*bt_g0_17;
    bt_l1_5 = bt_l1_5 + (0.18793478608131409)*bt_g0_18;
    bt_l1_5 = bt_l1_5 + (0.099554814398288727)*bt_g0_19;
    bt_l1_5 = bt_l1_5 + (-0.087372839450836182)*bt_g0_20;
    bt_l1_5 = bt_l1_5 + (0.017374454066157341)*bt_g0_21;
    bt_l1_5 = bt_l1_5 + (-0.20729435980319977)*bt_g0_22;
    bt_l1_5 = bt_l1_5 + (-0.44842413067817688)*bt_g0_23;
    bt_l1_5 = bt_l1_5 + (0.87485188245773315)*bt_g0_24;
    bt_l1_5 = bt_l1_5 + (0.11151996254920959)*bt_g0_25;
    bt_l1_5 = bt_l1_5 + (-0.15750247240066528)*bt_g0_26;
    bt_l1_5 = bt_l1_5 + (-0.020862286910414696)*bt_g0_27;
    bt_l1_5 = bt_l1_5 + (0.60272467136383057)*bt_g0_28;
    bt_l1_5 = bt_l1_5 + (0.08989579975605011)*bt_g0_29;
    bt_l1_5 = bt_l1_5 + (0.098198175430297852)*bt_g0_30;
    bt_l1_5 = bt_l1_5 + (0.089119702577590942)*bt_g0_31;
    bt_l1_5 = bt_l1_5 + (-0.033364977687597275)*bt_g0_32;
    bt_l1_5 = bt_l1_5 + (-0.18978786468505859)*bt_g0_33;
    bt_l1_5 = bt_l1_5 + (0.034325364977121353)*bt_g0_34;
    bt_l1_5 = bt_l1_5 + (-0.0010479221818968654)*bt_g0_35;
    bt_l1_5 = bt_l1_5 + (-0.11733822524547577)*bt_g0_36;
    bt_l1_5 = bt_l1_5 + (0.068479247391223907)*bt_g0_37;
    bt_l1_5 = bt_l1_5 + (-0.049287803471088409)*bt_g0_38;
    bt_l1_5 = bt_l1_5 + (0.035406388342380524)*bt_g0_39;
    bt_l1_5 = bt_l1_5 + (0.17072820663452148)*bt_g0_40;
    bt_l1_5 = bt_l1_5 + (0.17516607046127319)*bt_g0_41;
    bt_l1_5 = bt_l1_5 + (-0.29017940163612366)*bt_g0_42;
    bt_l1_5 = bt_l1_5 + (-0.066915817558765411)*bt_g0_43;
    bt_l1_5 = bt_l1_5 + (-0.026855191215872765)*bt_g0_44;
    bt_l1_5 = bt_l1_5 + (0.07470693439245224)*bt_g0_45;
    bt_l1_5 = bt_l1_5 + (0.10307901352643967)*bt_g0_46;
    bt_l1_5 = bt_l1_5 + (-0.035567104816436768)*bt_g0_47;
    bt_l1_5 = bt_l1_5 + (0.098212450742721558)*bt_g0_48;
    bt_l1_5 = bt_l1_5 + (-0.24289646744728088)*bt_g0_49;
    bt_l1_5 = bt_l1_5 + (0.20416548848152161)*bt_g0_50;
    bt_l1_5 = bt_l1_5 + (-0.27923667430877686)*bt_g0_51;
    bt_l1_5 = bt_l1_5 + (0.13237930834293365)*bt_g0_52;
    bt_l1_5 = bt_l1_5 + (0.15664520859718323)*bt_g0_53;
    bt_l1_5 = bt_l1_5 + (-0.0015542343026027083)*bt_g0_54;
    bt_l1_5 = bt_l1_5 + (-0.068479955196380615)*bt_g0_55;
    bt_l1_5 = bt_l1_5 + (0.026183754205703735)*bt_g0_56;
    bt_l1_5 = bt_l1_5 + (0.06456930935382843)*bt_g0_57;
    bt_l1_5 = bt_l1_5 + (-0.053585197776556015)*bt_g0_58;
    bt_l1_5 = bt_l1_5 + (-0.25033172965049744)*bt_g0_59;
    bt_l1_5 = bt_l1_5 + (-0.3262743353843689)*bt_g0_60;
    bt_l1_5 = bt_l1_5 + (0.041329246014356613)*bt_g0_61;
    bt_l1_5 = bt_l1_5 + (-0.66633802652359009)*bt_g0_62;
    bt_l1_5 = bt_l1_5 + (-0.02831827849149704)*bt_g0_63;
    bt_l1_6 = -0.041180126368999481;
    bt_l1_6 = bt_l1_6 + (-0.057854857295751572)*bt_g0_0;
    bt_l1_6 = bt_l1_6 + (-0.026849826797842979)*bt_g0_1;
    bt_l1_6 = bt_l1_6 + (0.17492634057998657)*bt_g0_2;
    bt_l1_6 = bt_l1_6 + (0.068746067583560944)*bt_g0_3;
    bt_l1_6 = bt_l1_6 + (-0.0050948252901434898)*bt_g0_4;
    bt_l1_6 = bt_l1_6 + (0.050505116581916809)*bt_g0_5;
    bt_l1_6 = bt_l1_6 + (0.05056353285908699)*bt_g0_6;
    bt_l1_6 = bt_l1_6 + (0.046573013067245483)*bt_g0_7;
    bt_l1_6 = bt_l1_6 + (0.13996946811676025)*bt_g0_8;
    bt_l1_6 = bt_l1_6 + (0.0269343052059412)*bt_g0_9;
    bt_l1_6 = bt_l1_6 + (-0.13262215256690979)*bt_g0_10;
    bt_l1_6 = bt_l1_6 + (0.067988857626914978)*bt_g0_11;
    bt_l1_6 = bt_l1_6 + (0.035010449588298798)*bt_g0_12;
    bt_l1_6 = bt_l1_6 + (0.05533955991268158)*bt_g0_13;
    bt_l1_6 = bt_l1_6 + (0.0018314017215743661)*bt_g0_14;
    bt_l1_6 = bt_l1_6 + (-0.095843635499477386)*bt_g0_15;
    bt_l1_6 = bt_l1_6 + (-0.23679558932781219)*bt_g0_16;
    bt_l1_6 = bt_l1_6 + (-0.068501889705657959)*bt_g0_17;
    bt_l1_6 = bt_l1_6 + (-0.083870433270931244)*bt_g0_18;
    bt_l1_6 = bt_l1_6 + (-0.024349329993128777)*bt_g0_19;
    bt_l1_6 = bt_l1_6 + (0.066299237310886383)*bt_g0_20;
    bt_l1_6 = bt_l1_6 + (-0.12783215939998627)*bt_g0_21;
    bt_l1_6 = bt_l1_6 + (-0.046694207936525345)*bt_g0_22;
    bt_l1_6 = bt_l1_6 + (-0.084802217781543732)*bt_g0_23;
    bt_l1_6 = bt_l1_6 + (0.051806055009365082)*bt_g0_24;
    bt_l1_6 = bt_l1_6 + (-0.1501036137342453)*bt_g0_25;
    bt_l1_6 = bt_l1_6 + (-0.012552605010569096)*bt_g0_26;
    bt_l1_6 = bt_l1_6 + (0.0028308669570833445)*bt_g0_27;
    bt_l1_6 = bt_l1_6 + (-0.25670880079269409)*bt_g0_28;
    bt_l1_6 = bt_l1_6 + (0.11171071976423264)*bt_g0_29;
    bt_l1_6 = bt_l1_6 + (-0.086065225303173065)*bt_g0_30;
    bt_l1_6 = bt_l1_6 + (0.032608192414045334)*bt_g0_31;
    bt_l1_6 = bt_l1_6 + (-0.1415318101644516)*bt_g0_32;
    bt_l1_6 = bt_l1_6 + (0.083609551191329956)*bt_g0_33;
    bt_l1_6 = bt_l1_6 + (0.075100503861904144)*bt_g0_34;
    bt_l1_6 = bt_l1_6 + (0.0020970467012375593)*bt_g0_35;
    bt_l1_6 = bt_l1_6 + (0.092617794871330261)*bt_g0_36;
    bt_l1_6 = bt_l1_6 + (-7.6793789048679173e-05)*bt_g0_37;
    bt_l1_6 = bt_l1_6 + (-0.15958799421787262)*bt_g0_38;
    bt_l1_6 = bt_l1_6 + (-0.10010915994644165)*bt_g0_39;
    bt_l1_6 = bt_l1_6 + (-0.10426731407642365)*bt_g0_40;
    bt_l1_6 = bt_l1_6 + (0.12614306807518005)*bt_g0_41;
    bt_l1_6 = bt_l1_6 + (0.092750228941440582)*bt_g0_42;
    bt_l1_6 = bt_l1_6 + (-0.073726728558540344)*bt_g0_43;
    bt_l1_6 = bt_l1_6 + (0.025222102180123329)*bt_g0_44;
    bt_l1_6 = bt_l1_6 + (0.11658733338117599)*bt_g0_45;
    bt_l1_6 = bt_l1_6 + (-0.00082696165191009641)*bt_g0_46;
    bt_l1_6 = bt_l1_6 + (0.10709742456674576)*bt_g0_47;
    bt_l1_6 = bt_l1_6 + (0.08410249650478363)*bt_g0_48;
    bt_l1_6 = bt_l1_6 + (0.11146576702594757)*bt_g0_49;
    bt_l1_6 = bt_l1_6 + (-0.14226976037025452)*bt_g0_50;
    bt_l1_6 = bt_l1_6 + (0.090424999594688416)*bt_g0_51;
    bt_l1_6 = bt_l1_6 + (0.0014724831562489271)*bt_g0_52;
    bt_l1_6 = bt_l1_6 + (0.084142096340656281)*bt_g0_53;
    bt_l1_6 = bt_l1_6 + (-0.16877110302448273)*bt_g0_54;
    bt_l1_6 = bt_l1_6 + (0.044746987521648407)*bt_g0_55;
    bt_l1_6 = bt_l1_6 + (0.034759234637022018)*bt_g0_56;
    bt_l1_6 = bt_l1_6 + (-0.064472921192646027)*bt_g0_57;
    bt_l1_6 = bt_l1_6 + (-0.070360250771045685)*bt_g0_58;
    bt_l1_6 = bt_l1_6 + (-0.10378251969814301)*bt_g0_59;
    bt_l1_6 = bt_l1_6 + (0.0085235359147191048)*bt_g0_60;
    bt_l1_6 = bt_l1_6 + (-0.00053385400678962469)*bt_g0_61;
    bt_l1_6 = bt_l1_6 + (-0.10750246793031693)*bt_g0_62;
    bt_l1_6 = bt_l1_6 + (-0.11205701529979706)*bt_g0_63;
    bt_l1_7 = -0.12519541382789612;
    bt_l1_7 = bt_l1_7 + (-0.06897396594285965)*bt_g0_0;
    bt_l1_7 = bt_l1_7 + (-0.07799084484577179)*bt_g0_1;
    bt_l1_7 = bt_l1_7 + (-0.097156576812267303)*bt_g0_2;
    bt_l1_7 = bt_l1_7 + (0.13057351112365723)*bt_g0_3;
    bt_l1_7 = bt_l1_7 + (0.031047850847244263)*bt_g0_4;
    bt_l1_7 = bt_l1_7 + (0.055401656776666641)*bt_g0_5;
    bt_l1_7 = bt_l1_7 + (0.22819343209266663)*bt_g0_6;
    bt_l1_7 = bt_l1_7 + (0.17465768754482269)*bt_g0_7;
    bt_l1_7 = bt_l1_7 + (-0.093316517770290375)*bt_g0_8;
    bt_l1_7 = bt_l1_7 + (0.0068623749539256096)*bt_g0_9;
    bt_l1_7 = bt_l1_7 + (-0.075791589915752411)*bt_g0_10;
    bt_l1_7 = bt_l1_7 + (0.009888719767332077)*bt_g0_11;
    bt_l1_7 = bt_l1_7 + (0.16376195847988129)*bt_g0_12;
    bt_l1_7 = bt_l1_7 + (0.089379213750362396)*bt_g0_13;
    bt_l1_7 = bt_l1_7 + (0.16676153242588043)*bt_g0_14;
    bt_l1_7 = bt_l1_7 + (-0.32574191689491272)*bt_g0_15;
    bt_l1_7 = bt_l1_7 + (0.331513911485672)*bt_g0_16;
    bt_l1_7 = bt_l1_7 + (0.060564465820789337)*bt_g0_17;
    bt_l1_7 = bt_l1_7 + (-0.13434669375419617)*bt_g0_18;
    bt_l1_7 = bt_l1_7 + (0.087163716554641724)*bt_g0_19;
    bt_l1_7 = bt_l1_7 + (0.082702800631523132)*bt_g0_20;
    bt_l1_7 = bt_l1_7 + (0.064976386725902557)*bt_g0_21;
    bt_l1_7 = bt_l1_7 + (-0.064438559114933014)*bt_g0_22;
    bt_l1_7 = bt_l1_7 + (0.2183513343334198)*bt_g0_23;
    bt_l1_7 = bt_l1_7 + (0.7514081597328186)*bt_g0_24;
    bt_l1_7 = bt_l1_7 + (-0.24776330590248108)*bt_g0_25;
    bt_l1_7 = bt_l1_7 + (-0.22197586297988892)*bt_g0_26;
    bt_l1_7 = bt_l1_7 + (0.21312355995178223)*bt_g0_27;
    bt_l1_7 = bt_l1_7 + (0.77253341674804688)*bt_g0_28;
    bt_l1_7 = bt_l1_7 + (0.0060396753251552582)*bt_g0_29;
    bt_l1_7 = bt_l1_7 + (0.033461082726716995)*bt_g0_30;
    bt_l1_7 = bt_l1_7 + (0.0031440944876521826)*bt_g0_31;
    bt_l1_7 = bt_l1_7 + (0.28420922160148621)*bt_g0_32;
    bt_l1_7 = bt_l1_7 + (-0.16185829043388367)*bt_g0_33;
    bt_l1_7 = bt_l1_7 + (0.083065800368785858)*bt_g0_34;
    bt_l1_7 = bt_l1_7 + (0.0071350117214024067)*bt_g0_35;
    bt_l1_7 = bt_l1_7 + (0.033934451639652252)*bt_g0_36;
    bt_l1_7 = bt_l1_7 + (-0.025842094793915749)*bt_g0_37;
    bt_l1_7 = bt_l1_7 + (0.13909544050693512)*bt_g0_38;
    bt_l1_7 = bt_l1_7 + (-0.073529608547687531)*bt_g0_39;
    bt_l1_7 = bt_l1_7 + (-0.040258489549160004)*bt_g0_40;
    bt_l1_7 = bt_l1_7 + (-0.085137829184532166)*bt_g0_41;
    bt_l1_7 = bt_l1_7 + (-0.21443371474742889)*bt_g0_42;
    bt_l1_7 = bt_l1_7 + (0.068827889859676361)*bt_g0_43;
    bt_l1_7 = bt_l1_7 + (0.47232761979103088)*bt_g0_44;
    bt_l1_7 = bt_l1_7 + (0.070070363581180573)*bt_g0_45;
    bt_l1_7 = bt_l1_7 + (0.05875057727098465)*bt_g0_46;
    bt_l1_7 = bt_l1_7 + (0.055927272886037827)*bt_g0_47;
    bt_l1_7 = bt_l1_7 + (-0.14335697889328003)*bt_g0_48;
    bt_l1_7 = bt_l1_7 + (-0.036559943109750748)*bt_g0_49;
    bt_l1_7 = bt_l1_7 + (0.11303411424160004)*bt_g0_50;
    bt_l1_7 = bt_l1_7 + (0.15237869322299957)*bt_g0_51;
    bt_l1_7 = bt_l1_7 + (0.15776669979095459)*bt_g0_52;
    bt_l1_7 = bt_l1_7 + (0.068618826568126678)*bt_g0_53;
    bt_l1_7 = bt_l1_7 + (0.059062402695417404)*bt_g0_54;
    bt_l1_7 = bt_l1_7 + (0.13392691314220428)*bt_g0_55;
    bt_l1_7 = bt_l1_7 + (0.15480594336986542)*bt_g0_56;
    bt_l1_7 = bt_l1_7 + (0.12134837359189987)*bt_g0_57;
    bt_l1_7 = bt_l1_7 + (-0.019859988242387772)*bt_g0_58;
    bt_l1_7 = bt_l1_7 + (-0.28352245688438416)*bt_g0_59;
    bt_l1_7 = bt_l1_7 + (-0.3199152946472168)*bt_g0_60;
    bt_l1_7 = bt_l1_7 + (-0.06599012017250061)*bt_g0_61;
    bt_l1_7 = bt_l1_7 + (-0.20616532862186432)*bt_g0_62;
    bt_l1_7 = bt_l1_7 + (0.21359308063983917)*bt_g0_63;
    bt_l1_8 = -0.079727105796337128;
    bt_l1_8 = bt_l1_8 + (0.032149158418178558)*bt_g0_0;
    bt_l1_8 = bt_l1_8 + (-0.1361398845911026)*bt_g0_1;
    bt_l1_8 = bt_l1_8 + (0.15874505043029785)*bt_g0_2;
    bt_l1_8 = bt_l1_8 + (-0.10897114872932434)*bt_g0_3;
    bt_l1_8 = bt_l1_8 + (0.025037463754415512)*bt_g0_4;
    bt_l1_8 = bt_l1_8 + (0.20712518692016602)*bt_g0_5;
    bt_l1_8 = bt_l1_8 + (-0.24599063396453857)*bt_g0_6;
    bt_l1_8 = bt_l1_8 + (-0.13827352225780487)*bt_g0_7;
    bt_l1_8 = bt_l1_8 + (0.23390525579452515)*bt_g0_8;
    bt_l1_8 = bt_l1_8 + (0.019370123744010925)*bt_g0_9;
    bt_l1_8 = bt_l1_8 + (-0.12644122540950775)*bt_g0_10;
    bt_l1_8 = bt_l1_8 + (0.094802804291248322)*bt_g0_11;
    bt_l1_8 = bt_l1_8 + (-0.018564118072390556)*bt_g0_12;
    bt_l1_8 = bt_l1_8 + (0.099734872579574585)*bt_g0_13;
    bt_l1_8 = bt_l1_8 + (0.039088573306798935)*bt_g0_14;
    bt_l1_8 = bt_l1_8 + (0.40602988004684448)*bt_g0_15;
    bt_l1_8 = bt_l1_8 + (0.20828899741172791)*bt_g0_16;
    bt_l1_8 = bt_l1_8 + (0.11503387987613678)*bt_g0_17;
    bt_l1_8 = bt_l1_8 + (-0.12204970419406891)*bt_g0_18;
    bt_l1_8 = bt_l1_8 + (0.089151419699192047)*bt_g0_19;
    bt_l1_8 = bt_l1_8 + (-0.10748453438282013)*bt_g0_20;
    bt_l1_8 = bt_l1_8 + (0.025409001857042313)*bt_g0_21;
    bt_l1_8 = bt_l1_8 + (-0.27700433135032654)*bt_g0_22;
    bt_l1_8 = bt_l1_8 + (0.043465990573167801)*bt_g0_23;
    bt_l1_8 = bt_l1_8 + (0.0049335155636072159)*bt_g0_24;
    bt_l1_8 = bt_l1_8 + (-0.024175455793738365)*bt_g0_25;
    bt_l1_8 = bt_l1_8 + (0.16062572598457336)*bt_g0_26;
    bt_l1_8 = bt_l1_8 + (-0.12873528897762299)*bt_g0_27;
    bt_l1_8 = bt_l1_8 + (-0.031824458390474319)*bt_g0_28;
    bt_l1_8 = bt_l1_8 + (0.083630099892616272)*bt_g0_29;
    bt_l1_8 = bt_l1_8 + (-0.096374504268169403)*bt_g0_30;
    bt_l1_8 = bt_l1_8 + (-0.075716309249401093)*bt_g0_31;
    bt_l1_8 = bt_l1_8 + (-0.085947751998901367)*bt_g0_32;
    bt_l1_8 = bt_l1_8 + (-0.2728840708732605)*bt_g0_33;
    bt_l1_8 = bt_l1_8 + (-0.075994342565536499)*bt_g0_34;
    bt_l1_8 = bt_l1_8 + (0.2140943855047226)*bt_g0_35;
    bt_l1_8 = bt_l1_8 + (0.2044159322977066)*bt_g0_36;
    bt_l1_8 = bt_l1_8 + (0.19149067997932434)*bt_g0_37;
    bt_l1_8 = bt_l1_8 + (0.19597534835338593)*bt_g0_38;
    bt_l1_8 = bt_l1_8 + (0.047080595046281815)*bt_g0_39;
    bt_l1_8 = bt_l1_8 + (-0.042104393243789673)*bt_g0_40;
    bt_l1_8 = bt_l1_8 + (-0.070262998342514038)*bt_g0_41;
    bt_l1_8 = bt_l1_8 + (0.086031883955001831)*bt_g0_42;
    bt_l1_8 = bt_l1_8 + (-0.020213719457387924)*bt_g0_43;
    bt_l1_8 = bt_l1_8 + (-0.016812827438116074)*bt_g0_44;
    bt_l1_8 = bt_l1_8 + (0.042121324688196182)*bt_g0_45;
    bt_l1_8 = bt_l1_8 + (0.084795758128166199)*bt_g0_46;
    bt_l1_8 = bt_l1_8 + (-0.044597703963518143)*bt_g0_47;
    bt_l1_8 = bt_l1_8 + (-0.083041906356811523)*bt_g0_48;
    bt_l1_8 = bt_l1_8 + (0.26321816444396973)*bt_g0_49;
    bt_l1_8 = bt_l1_8 + (-0.05597064271569252)*bt_g0_50;
    bt_l1_8 = bt_l1_8 + (0.14902022480964661)*bt_g0_51;
    bt_l1_8 = bt_l1_8 + (0.044250167906284332)*bt_g0_52;
    bt_l1_8 = bt_l1_8 + (0.023020396009087563)*bt_g0_53;
    bt_l1_8 = bt_l1_8 + (-0.069046393036842346)*bt_g0_54;
    bt_l1_8 = bt_l1_8 + (0.036741659045219421)*bt_g0_55;
    bt_l1_8 = bt_l1_8 + (0.078249230980873108)*bt_g0_56;
    bt_l1_8 = bt_l1_8 + (-0.016976324841380119)*bt_g0_57;
    bt_l1_8 = bt_l1_8 + (0.083061963319778442)*bt_g0_58;
    bt_l1_8 = bt_l1_8 + (0.15638136863708496)*bt_g0_59;
    bt_l1_8 = bt_l1_8 + (-0.28978720307350159)*bt_g0_60;
    bt_l1_8 = bt_l1_8 + (0.14752550423145294)*bt_g0_61;
    bt_l1_8 = bt_l1_8 + (0.29423469305038452)*bt_g0_62;
    bt_l1_8 = bt_l1_8 + (-0.01114664226770401)*bt_g0_63;
    bt_l1_9 = -0.068605832755565643;
    bt_l1_9 = bt_l1_9 + (-0.075299911201000214)*bt_g0_0;
    bt_l1_9 = bt_l1_9 + (-0.035353697836399078)*bt_g0_1;
    bt_l1_9 = bt_l1_9 + (-0.045276466757059097)*bt_g0_2;
    bt_l1_9 = bt_l1_9 + (0.03820018470287323)*bt_g0_3;
    bt_l1_9 = bt_l1_9 + (0.11183237284421921)*bt_g0_4;
    bt_l1_9 = bt_l1_9 + (-0.13379567861557007)*bt_g0_5;
    bt_l1_9 = bt_l1_9 + (0.11441906541585922)*bt_g0_6;
    bt_l1_9 = bt_l1_9 + (0.099849224090576172)*bt_g0_7;
    bt_l1_9 = bt_l1_9 + (0.098880499601364136)*bt_g0_8;
    bt_l1_9 = bt_l1_9 + (0.01370280422270298)*bt_g0_9;
    bt_l1_9 = bt_l1_9 + (-0.020081633701920509)*bt_g0_10;
    bt_l1_9 = bt_l1_9 + (-0.0016143399989232421)*bt_g0_11;
    bt_l1_9 = bt_l1_9 + (-0.11959235370159149)*bt_g0_12;
    bt_l1_9 = bt_l1_9 + (0.013540077023208141)*bt_g0_13;
    bt_l1_9 = bt_l1_9 + (-0.1186315193772316)*bt_g0_14;
    bt_l1_9 = bt_l1_9 + (0.067639477550983429)*bt_g0_15;
    bt_l1_9 = bt_l1_9 + (-0.23310939967632294)*bt_g0_16;
    bt_l1_9 = bt_l1_9 + (0.14027322828769684)*bt_g0_17;
    bt_l1_9 = bt_l1_9 + (0.012821505777537823)*bt_g0_18;
    bt_l1_9 = bt_l1_9 + (0.023900501430034637)*bt_g0_19;
    bt_l1_9 = bt_l1_9 + (-0.0096787130460143089)*bt_g0_20;
    bt_l1_9 = bt_l1_9 + (-0.016151711344718933)*bt_g0_21;
    bt_l1_9 = bt_l1_9 + (-0.079907618463039398)*bt_g0_22;
    bt_l1_9 = bt_l1_9 + (-0.15854546427726746)*bt_g0_23;
    bt_l1_9 = bt_l1_9 + (-0.21406289935112)*bt_g0_24;
    bt_l1_9 = bt_l1_9 + (0.037487491965293884)*bt_g0_25;
    bt_l1_9 = bt_l1_9 + (0.088050857186317444)*bt_g0_26;
    bt_l1_9 = bt_l1_9 + (-0.12902438640594482)*bt_g0_27;
    bt_l1_9 = bt_l1_9 + (-0.071637026965618134)*bt_g0_28;
    bt_l1_9 = bt_l1_9 + (-0.032635550945997238)*bt_g0_29;
    bt_l1_9 = bt_l1_9 + (-0.093076668679714203)*bt_g0_30;
    bt_l1_9 = bt_l1_9 + (-0.061344880610704422)*bt_g0_31;
    bt_l1_9 = bt_l1_9 + (-0.3475801944732666)*bt_g0_32;
    bt_l1_9 = bt_l1_9 + (-0.0059964726679027081)*bt_g0_33;
    bt_l1_9 = bt_l1_9 + (0.093880809843540192)*bt_g0_34;
    bt_l1_9 = bt_l1_9 + (0.038479704409837723)*bt_g0_35;
    bt_l1_9 = bt_l1_9 + (0.1794060617685318)*bt_g0_36;
    bt_l1_9 = bt_l1_9 + (0.20388150215148926)*bt_g0_37;
    bt_l1_9 = bt_l1_9 + (-0.05971110612154007)*bt_g0_38;
    bt_l1_9 = bt_l1_9 + (0.059249524027109146)*bt_g0_39;
    bt_l1_9 = bt_l1_9 + (0.091759130358695984)*bt_g0_40;
    bt_l1_9 = bt_l1_9 + (0.061143185943365097)*bt_g0_41;
    bt_l1_9 = bt_l1_9 + (0.13442292809486389)*bt_g0_42;
    bt_l1_9 = bt_l1_9 + (0.11117623001337051)*bt_g0_43;
    bt_l1_9 = bt_l1_9 + (-0.15638230741024017)*bt_g0_44;
    bt_l1_9 = bt_l1_9 + (-0.081476785242557526)*bt_g0_45;
    bt_l1_9 = bt_l1_9 + (-0.068476252257823944)*bt_g0_46;
    bt_l1_9 = bt_l1_9 + (0.048050377517938614)*bt_g0_47;
    bt_l1_9 = bt_l1_9 + (-0.0070696296170353889)*bt_g0_48;
    bt_l1_9 = bt_l1_9 + (0.14662382006645203)*bt_g0_49;
    bt_l1_9 = bt_l1_9 + (0.052764300256967545)*bt_g0_50;
    bt_l1_9 = bt_l1_9 + (-0.1575201004743576)*bt_g0_51;
    bt_l1_9 = bt_l1_9 + (0.055619638413190842)*bt_g0_52;
    bt_l1_9 = bt_l1_9 + (-0.14137978851795197)*bt_g0_53;
    bt_l1_9 = bt_l1_9 + (0.014260330237448215)*bt_g0_54;
    bt_l1_9 = bt_l1_9 + (-0.12653256952762604)*bt_g0_55;
    bt_l1_9 = bt_l1_9 + (0.073153339326381683)*bt_g0_56;
    bt_l1_9 = bt_l1_9 + (0.053372200578451157)*bt_g0_57;
    bt_l1_9 = bt_l1_9 + (0.071781806647777557)*bt_g0_58;
    bt_l1_9 = bt_l1_9 + (0.021356603130698204)*bt_g0_59;
    bt_l1_9 = bt_l1_9 + (0.088171333074569702)*bt_g0_60;
    bt_l1_9 = bt_l1_9 + (0.0037103691138327122)*bt_g0_61;
    bt_l1_9 = bt_l1_9 + (0.17182818055152893)*bt_g0_62;
    bt_l1_9 = bt_l1_9 + (-0.16543295979499817)*bt_g0_63;
    bt_l1_10 = 0.12752765417098999;
    bt_l1_10 = bt_l1_10 + (0.031853232532739639)*bt_g0_0;
    bt_l1_10 = bt_l1_10 + (-0.24387885630130768)*bt_g0_1;
    bt_l1_10 = bt_l1_10 + (-0.077705651521682739)*bt_g0_2;
    bt_l1_10 = bt_l1_10 + (-0.064340695738792419)*bt_g0_3;
    bt_l1_10 = bt_l1_10 + (-0.032147318124771118)*bt_g0_4;
    bt_l1_10 = bt_l1_10 + (0.040757689625024796)*bt_g0_5;
    bt_l1_10 = bt_l1_10 + (0.20414464175701141)*bt_g0_6;
    bt_l1_10 = bt_l1_10 + (0.056700833141803741)*bt_g0_7;
    bt_l1_10 = bt_l1_10 + (0.16210532188415527)*bt_g0_8;
    bt_l1_10 = bt_l1_10 + (-0.052720826119184494)*bt_g0_9;
    bt_l1_10 = bt_l1_10 + (-0.032249782234430313)*bt_g0_10;
    bt_l1_10 = bt_l1_10 + (-0.033926233649253845)*bt_g0_11;
    bt_l1_10 = bt_l1_10 + (0.054201733320951462)*bt_g0_12;
    bt_l1_10 = bt_l1_10 + (-0.045618467032909393)*bt_g0_13;
    bt_l1_10 = bt_l1_10 + (0.055030554533004761)*bt_g0_14;
    bt_l1_10 = bt_l1_10 + (0.031324632465839386)*bt_g0_15;
    bt_l1_10 = bt_l1_10 + (-0.040654052048921585)*bt_g0_16;
    bt_l1_10 = bt_l1_10 + (-0.063810780644416809)*bt_g0_17;
    bt_l1_10 = bt_l1_10 + (-0.13582044839859009)*bt_g0_18;
    bt_l1_10 = bt_l1_10 + (-0.070998556911945343)*bt_g0_19;
    bt_l1_10 = bt_l1_10 + (-0.11830523610115051)*bt_g0_20;
    bt_l1_10 = bt_l1_10 + (-0.094522468745708466)*bt_g0_21;
    bt_l1_10 = bt_l1_10 + (-0.093744806945323944)*bt_g0_22;
    bt_l1_10 = bt_l1_10 + (0.14474533498287201)*bt_g0_23;
    bt_l1_10 = bt_l1_10 + (0.50999683141708374)*bt_g0_24;
    bt_l1_10 = bt_l1_10 + (0.18882511556148529)*bt_g0_25;
    bt_l1_10 = bt_l1_10 + (-0.13021299242973328)*bt_g0_26;
    bt_l1_10 = bt_l1_10 + (-0.053519405424594879)*bt_g0_27;
    bt_l1_10 = bt_l1_10 + (-0.10892719775438309)*bt_g0_28;
    bt_l1_10 = bt_l1_10 + (0.014388134703040123)*bt_g0_29;
    bt_l1_10 = bt_l1_10 + (-0.11135400831699371)*bt_g0_30;
    bt_l1_10 = bt_l1_10 + (-0.041439920663833618)*bt_g0_31;
    bt_l1_10 = bt_l1_10 + (0.15322153270244598)*bt_g0_32;
    bt_l1_10 = bt_l1_10 + (-0.074980363249778748)*bt_g0_33;
    bt_l1_10 = bt_l1_10 + (0.0021339929662644863)*bt_g0_34;
    bt_l1_10 = bt_l1_10 + (-0.097000338137149811)*bt_g0_35;
    bt_l1_10 = bt_l1_10 + (0.016509855166077614)*bt_g0_36;
    bt_l1_10 = bt_l1_10 + (0.026797940954566002)*bt_g0_37;
    bt_l1_10 = bt_l1_10 + (0.06525709480047226)*bt_g0_38;
    bt_l1_10 = bt_l1_10 + (0.044829107820987701)*bt_g0_39;
    bt_l1_10 = bt_l1_10 + (0.0427660271525383)*bt_g0_40;
    bt_l1_10 = bt_l1_10 + (-0.071414515376091003)*bt_g0_41;
    bt_l1_10 = bt_l1_10 + (-0.028557194396853447)*bt_g0_42;
    bt_l1_10 = bt_l1_10 + (-0.037864997982978821)*bt_g0_43;
    bt_l1_10 = bt_l1_10 + (0.2958376407623291)*bt_g0_44;
    bt_l1_10 = bt_l1_10 + (-0.13847552239894867)*bt_g0_45;
    bt_l1_10 = bt_l1_10 + (0.015297023579478264)*bt_g0_46;
    bt_l1_10 = bt_l1_10 + (0.090576395392417908)*bt_g0_47;
    bt_l1_10 = bt_l1_10 + (-0.09695754200220108)*bt_g0_48;
    bt_l1_10 = bt_l1_10 + (0.064348854124546051)*bt_g0_49;
    bt_l1_10 = bt_l1_10 + (0.013457088731229305)*bt_g0_50;
    bt_l1_10 = bt_l1_10 + (0.17342092096805573)*bt_g0_51;
    bt_l1_10 = bt_l1_10 + (0.22561672329902649)*bt_g0_52;
    bt_l1_10 = bt_l1_10 + (-0.055242959409952164)*bt_g0_53;
    bt_l1_10 = bt_l1_10 + (-0.15153588354587555)*bt_g0_54;
    bt_l1_10 = bt_l1_10 + (-0.0010737946722656488)*bt_g0_55;
    bt_l1_10 = bt_l1_10 + (-0.1562398374080658)*bt_g0_56;
    bt_l1_10 = bt_l1_10 + (0.10288914293050766)*bt_g0_57;
    bt_l1_10 = bt_l1_10 + (0.064735241234302521)*bt_g0_58;
    bt_l1_10 = bt_l1_10 + (-0.11415357887744904)*bt_g0_59;
    bt_l1_10 = bt_l1_10 + (-0.1546282023191452)*bt_g0_60;
    bt_l1_10 = bt_l1_10 + (0.29464516043663025)*bt_g0_61;
    bt_l1_10 = bt_l1_10 + (0.12959818542003632)*bt_g0_62;
    bt_l1_10 = bt_l1_10 + (0.21973384916782379)*bt_g0_63;
    bt_l1_11 = -0.01833701878786087;
    bt_l1_11 = bt_l1_11 + (3.7642203096766025e-05)*bt_g0_0;
    bt_l1_11 = bt_l1_11 + (-0.039650164544582367)*bt_g0_1;
    bt_l1_11 = bt_l1_11 + (0.080435268580913544)*bt_g0_2;
    bt_l1_11 = bt_l1_11 + (-0.066144570708274841)*bt_g0_3;
    bt_l1_11 = bt_l1_11 + (0.09360426664352417)*bt_g0_4;
    bt_l1_11 = bt_l1_11 + (-0.0067647313699126244)*bt_g0_5;
    bt_l1_11 = bt_l1_11 + (-0.014338727109134197)*bt_g0_6;
    bt_l1_11 = bt_l1_11 + (-0.19063261151313782)*bt_g0_7;
    bt_l1_11 = bt_l1_11 + (0.079751215875148773)*bt_g0_8;
    bt_l1_11 = bt_l1_11 + (0.085764847695827484)*bt_g0_9;
    bt_l1_11 = bt_l1_11 + (-0.1237761452794075)*bt_g0_10;
    bt_l1_11 = bt_l1_11 + (0.098730020225048065)*bt_g0_11;
    bt_l1_11 = bt_l1_11 + (0.041206728667020798)*bt_g0_12;
    bt_l1_11 = bt_l1_11 + (0.14295321702957153)*bt_g0_13;
    bt_l1_11 = bt_l1_11 + (0.13762041926383972)*bt_g0_14;
    bt_l1_11 = bt_l1_11 + (0.070514246821403503)*bt_g0_15;
    bt_l1_11 = bt_l1_11 + (0.044213362038135529)*bt_g0_16;
    bt_l1_11 = bt_l1_11 + (0.024977011606097221)*bt_g0_17;
    bt_l1_11 = bt_l1_11 + (0.048967771232128143)*bt_g0_18;
    bt_l1_11 = bt_l1_11 + (-0.071831345558166504)*bt_g0_19;
    bt_l1_11 = bt_l1_11 + (0.04814751073718071)*bt_g0_20;
    bt_l1_11 = bt_l1_11 + (0.04967285692691803)*bt_g0_21;
    bt_l1_11 = bt_l1_11 + (-0.097534269094467163)*bt_g0_22;
    bt_l1_11 = bt_l1_11 + (-0.011151762679219246)*bt_g0_23;
    bt_l1_11 = bt_l1_11 + (0.47729209065437317)*bt_g0_24;
    bt_l1_11 = bt_l1_11 + (0.27729484438896179)*bt_g0_25;
    bt_l1_11 = bt_l1_11 + (-0.03917481005191803)*bt_g0_26;
    bt_l1_11 = bt_l1_11 + (-0.24972076714038849)*bt_g0_27;
    bt_l1_11 = bt_l1_11 + (0.11615017801523209)*bt_g0_28;
    bt_l1_11 = bt_l1_11 + (0.034437842667102814)*bt_g0_29;
    bt_l1_11 = bt_l1_11 + (0.091732025146484375)*bt_g0_30;
    bt_l1_11 = bt_l1_11 + (-0.09292341023683548)*bt_g0_31;
    bt_l1_11 = bt_l1_11 + (-0.16624775528907776)*bt_g0_32;
    bt_l1_11 = bt_l1_11 + (-0.062162823975086212)*bt_g0_33;
    bt_l1_11 = bt_l1_11 + (0.0037600288633257151)*bt_g0_34;
    bt_l1_11 = bt_l1_11 + (-0.079694047570228577)*bt_g0_35;
    bt_l1_11 = bt_l1_11 + (0.19228070974349976)*bt_g0_36;
    bt_l1_11 = bt_l1_11 + (0.090839684009552002)*bt_g0_37;
    bt_l1_11 = bt_l1_11 + (0.19445168972015381)*bt_g0_38;
    bt_l1_11 = bt_l1_11 + (-0.11375421285629272)*bt_g0_39;
    bt_l1_11 = bt_l1_11 + (0.15519416332244873)*bt_g0_40;
    bt_l1_11 = bt_l1_11 + (-0.068833999335765839)*bt_g0_41;
    bt_l1_11 = bt_l1_11 + (-0.12891039252281189)*bt_g0_42;
    bt_l1_11 = bt_l1_11 + (0.10771570354700089)*bt_g0_43;
    bt_l1_11 = bt_l1_11 + (-0.11426886171102524)*bt_g0_44;
    bt_l1_11 = bt_l1_11 + (-0.042296268045902252)*bt_g0_45;
    bt_l1_11 = bt_l1_11 + (0.025144180282950401)*bt_g0_46;
    bt_l1_11 = bt_l1_11 + (0.15989413857460022)*bt_g0_47;
    bt_l1_11 = bt_l1_11 + (0.016297459602355957)*bt_g0_48;
    bt_l1_11 = bt_l1_11 + (-0.21284939348697662)*bt_g0_49;
    bt_l1_11 = bt_l1_11 + (-0.042285196483135223)*bt_g0_50;
    bt_l1_11 = bt_l1_11 + (-0.033253148198127747)*bt_g0_51;
    bt_l1_11 = bt_l1_11 + (-0.032643783837556839)*bt_g0_52;
    bt_l1_11 = bt_l1_11 + (0.12057224661111832)*bt_g0_53;
    bt_l1_11 = bt_l1_11 + (0.074796512722969055)*bt_g0_54;
    bt_l1_11 = bt_l1_11 + (0.069052040576934814)*bt_g0_55;
    bt_l1_11 = bt_l1_11 + (-0.10116516798734665)*bt_g0_56;
    bt_l1_11 = bt_l1_11 + (0.010271291248500347)*bt_g0_57;
    bt_l1_11 = bt_l1_11 + (0.13573098182678223)*bt_g0_58;
    bt_l1_11 = bt_l1_11 + (-0.0086689246818423271)*bt_g0_59;
    bt_l1_11 = bt_l1_11 + (-0.13464227318763733)*bt_g0_60;
    bt_l1_11 = bt_l1_11 + (0.11272400617599487)*bt_g0_61;
    bt_l1_11 = bt_l1_11 + (0.039595998823642731)*bt_g0_62;
    bt_l1_11 = bt_l1_11 + (-0.032317273318767548)*bt_g0_63;
    bt_l1_12 = 0.11111277341842651;
    bt_l1_12 = bt_l1_12 + (0.10057698935270309)*bt_g0_0;
    bt_l1_12 = bt_l1_12 + (0.16281758248806)*bt_g0_1;
    bt_l1_12 = bt_l1_12 + (-0.19188603758811951)*bt_g0_2;
    bt_l1_12 = bt_l1_12 + (0.1737324446439743)*bt_g0_3;
    bt_l1_12 = bt_l1_12 + (-0.051868624985218048)*bt_g0_4;
    bt_l1_12 = bt_l1_12 + (-0.061647497117519379)*bt_g0_5;
    bt_l1_12 = bt_l1_12 + (0.16116242110729218)*bt_g0_6;
    bt_l1_12 = bt_l1_12 + (-0.030832035467028618)*bt_g0_7;
    bt_l1_12 = bt_l1_12 + (-0.41286152601242065)*bt_g0_8;
    bt_l1_12 = bt_l1_12 + (-0.0059102880768477917)*bt_g0_9;
    bt_l1_12 = bt_l1_12 + (0.1002141460776329)*bt_g0_10;
    bt_l1_12 = bt_l1_12 + (0.048863571137189865)*bt_g0_11;
    bt_l1_12 = bt_l1_12 + (-0.086647175252437592)*bt_g0_12;
    bt_l1_12 = bt_l1_12 + (-0.13203807175159454)*bt_g0_13;
    bt_l1_12 = bt_l1_12 + (-0.063512749969959259)*bt_g0_14;
    bt_l1_12 = bt_l1_12 + (0.011301585473120213)*bt_g0_15;
    bt_l1_12 = bt_l1_12 + (-0.10411576926708221)*bt_g0_16;
    bt_l1_12 = bt_l1_12 + (0.0019866130314767361)*bt_g0_17;
    bt_l1_12 = bt_l1_12 + (0.1430916041135788)*bt_g0_18;
    bt_l1_12 = bt_l1_12 + (-0.0093518532812595367)*bt_g0_19;
    bt_l1_12 = bt_l1_12 + (-0.018544360995292664)*bt_g0_20;
    bt_l1_12 = bt_l1_12 + (0.030581459403038025)*bt_g0_21;
    bt_l1_12 = bt_l1_12 + (0.11327137798070908)*bt_g0_22;
    bt_l1_12 = bt_l1_12 + (0.053967736661434174)*bt_g0_23;
    bt_l1_12 = bt_l1_12 + (-0.2146352231502533)*bt_g0_24;
    bt_l1_12 = bt_l1_12 + (0.18649971485137939)*bt_g0_25;
    bt_l1_12 = bt_l1_12 + (0.074289076030254364)*bt_g0_26;
    bt_l1_12 = bt_l1_12 + (0.012650851160287857)*bt_g0_27;
    bt_l1_12 = bt_l1_12 + (-0.14851658046245575)*bt_g0_28;
    bt_l1_12 = bt_l1_12 + (-0.085086330771446228)*bt_g0_29;
    bt_l1_12 = bt_l1_12 + (-0.091188855469226837)*bt_g0_30;
    bt_l1_12 = bt_l1_12 + (0.065376587212085724)*bt_g0_31;
    bt_l1_12 = bt_l1_12 + (0.10983046889305115)*bt_g0_32;
    bt_l1_12 = bt_l1_12 + (0.10199659317731857)*bt_g0_33;
    bt_l1_12 = bt_l1_12 + (-0.091707773506641388)*bt_g0_34;
    bt_l1_12 = bt_l1_12 + (0.10078327357769012)*bt_g0_35;
    bt_l1_12 = bt_l1_12 + (-0.54979145526885986)*bt_g0_36;
    bt_l1_12 = bt_l1_12 + (-0.13940824568271637)*bt_g0_37;
    bt_l1_12 = bt_l1_12 + (-0.1814272403717041)*bt_g0_38;
    bt_l1_12 = bt_l1_12 + (0.015639008954167366)*bt_g0_39;
    bt_l1_12 = bt_l1_12 + (0.063894115388393402)*bt_g0_40;
    bt_l1_12 = bt_l1_12 + (0.096824511885643005)*bt_g0_41;
    bt_l1_12 = bt_l1_12 + (0.18310807645320892)*bt_g0_42;
    bt_l1_12 = bt_l1_12 + (-0.063725344836711884)*bt_g0_43;
    bt_l1_12 = bt_l1_12 + (0.088769853115081787)*bt_g0_44;
    bt_l1_12 = bt_l1_12 + (-0.065716743469238281)*bt_g0_45;
    bt_l1_12 = bt_l1_12 + (0.081314727663993835)*bt_g0_46;
    bt_l1_12 = bt_l1_12 + (-0.16392967104911804)*bt_g0_47;
    bt_l1_12 = bt_l1_12 + (-0.005796775221824646)*bt_g0_48;
    bt_l1_12 = bt_l1_12 + (0.13787198066711426)*bt_g0_49;
    bt_l1_12 = bt_l1_12 + (0.051436431705951691)*bt_g0_50;
    bt_l1_12 = bt_l1_12 + (-0.1618204265832901)*bt_g0_51;
    bt_l1_12 = bt_l1_12 + (0.070753425359725952)*bt_g0_52;
    bt_l1_12 = bt_l1_12 + (0.063601329922676086)*bt_g0_53;
    bt_l1_12 = bt_l1_12 + (0.16026462614536285)*bt_g0_54;
    bt_l1_12 = bt_l1_12 + (0.078880935907363892)*bt_g0_55;
    bt_l1_12 = bt_l1_12 + (0.049716919660568237)*bt_g0_56;
    bt_l1_12 = bt_l1_12 + (-0.027533859014511108)*bt_g0_57;
    bt_l1_12 = bt_l1_12 + (-0.35492551326751709)*bt_g0_58;
    bt_l1_12 = bt_l1_12 + (0.062525972723960876)*bt_g0_59;
    bt_l1_12 = bt_l1_12 + (0.10023261606693268)*bt_g0_60;
    bt_l1_12 = bt_l1_12 + (-0.10301224142313004)*bt_g0_61;
    bt_l1_12 = bt_l1_12 + (-0.10997101664543152)*bt_g0_62;
    bt_l1_12 = bt_l1_12 + (-0.092242561280727386)*bt_g0_63;
    bt_l1_13 = 0.081546343863010406;
    bt_l1_13 = bt_l1_13 + (-0.083030633628368378)*bt_g0_0;
    bt_l1_13 = bt_l1_13 + (-0.11893718689680099)*bt_g0_1;
    bt_l1_13 = bt_l1_13 + (0.016313198953866959)*bt_g0_2;
    bt_l1_13 = bt_l1_13 + (0.075141355395317078)*bt_g0_3;
    bt_l1_13 = bt_l1_13 + (0.015855709090828896)*bt_g0_4;
    bt_l1_13 = bt_l1_13 + (-0.10054194927215576)*bt_g0_5;
    bt_l1_13 = bt_l1_13 + (-0.10275401175022125)*bt_g0_6;
    bt_l1_13 = bt_l1_13 + (0.1535688191652298)*bt_g0_7;
    bt_l1_13 = bt_l1_13 + (0.32434427738189697)*bt_g0_8;
    bt_l1_13 = bt_l1_13 + (0.024627160280942917)*bt_g0_9;
    bt_l1_13 = bt_l1_13 + (0.15256334841251373)*bt_g0_10;
    bt_l1_13 = bt_l1_13 + (-0.0072405925020575523)*bt_g0_11;
    bt_l1_13 = bt_l1_13 + (0.11697965115308762)*bt_g0_12;
    bt_l1_13 = bt_l1_13 + (0.065032564103603363)*bt_g0_13;
    bt_l1_13 = bt_l1_13 + (-0.22583077847957611)*bt_g0_14;
    bt_l1_13 = bt_l1_13 + (0.0058439536951482296)*bt_g0_15;
    bt_l1_13 = bt_l1_13 + (-0.23159593343734741)*bt_g0_16;
    bt_l1_13 = bt_l1_13 + (0.08996213972568512)*bt_g0_17;
    bt_l1_13 = bt_l1_13 + (0.038812693208456039)*bt_g0_18;
    bt_l1_13 = bt_l1_13 + (-0.16338126361370087)*bt_g0_19;
    bt_l1_13 = bt_l1_13 + (0.12846030294895172)*bt_g0_20;
    bt_l1_13 = bt_l1_13 + (-0.012047863565385342)*bt_g0_21;
    bt_l1_13 = bt_l1_13 + (-0.077502921223640442)*bt_g0_22;
    bt_l1_13 = bt_l1_13 + (-0.029282975941896439)*bt_g0_23;
    bt_l1_13 = bt_l1_13 + (0.18234296143054962)*bt_g0_24;
    bt_l1_13 = bt_l1_13 + (0.069852739572525024)*bt_g0_25;
    bt_l1_13 = bt_l1_13 + (0.14827394485473633)*bt_g0_26;
    bt_l1_13 = bt_l1_13 + (0.055944453924894333)*bt_g0_27;
    bt_l1_13 = bt_l1_13 + (0.15850426256656647)*bt_g0_28;
    bt_l1_13 = bt_l1_13 + (-0.093577571213245392)*bt_g0_29;
    bt_l1_13 = bt_l1_13 + (-0.26709756255149841)*bt_g0_30;
    bt_l1_13 = bt_l1_13 + (-0.17143510282039642)*bt_g0_31;
    bt_l1_13 = bt_l1_13 + (-0.07736680656671524)*bt_g0_32;
    bt_l1_13 = bt_l1_13 + (0.13013330101966858)*bt_g0_33;
    bt_l1_13 = bt_l1_13 + (-0.18185217678546906)*bt_g0_34;
    bt_l1_13 = bt_l1_13 + (0.15606056153774261)*bt_g0_35;
    bt_l1_13 = bt_l1_13 + (0.27757656574249268)*bt_g0_36;
    bt_l1_13 = bt_l1_13 + (0.1647043377161026)*bt_g0_37;
    bt_l1_13 = bt_l1_13 + (0.043895803391933441)*bt_g0_38;
    bt_l1_13 = bt_l1_13 + (0.074476227164268494)*bt_g0_39;
    bt_l1_13 = bt_l1_13 + (0.031138740479946136)*bt_g0_40;
    bt_l1_13 = bt_l1_13 + (-0.11232767999172211)*bt_g0_41;
    bt_l1_13 = bt_l1_13 + (0.17943228781223297)*bt_g0_42;
    bt_l1_13 = bt_l1_13 + (-0.074233792722225189)*bt_g0_43;
    bt_l1_13 = bt_l1_13 + (0.051940768957138062)*bt_g0_44;
    bt_l1_13 = bt_l1_13 + (0.068873517215251923)*bt_g0_45;
    bt_l1_13 = bt_l1_13 + (-0.11461468040943146)*bt_g0_46;
    bt_l1_13 = bt_l1_13 + (-0.19337919354438782)*bt_g0_47;
    bt_l1_13 = bt_l1_13 + (0.05685713142156601)*bt_g0_48;
    bt_l1_13 = bt_l1_13 + (0.14128343760967255)*bt_g0_49;
    bt_l1_13 = bt_l1_13 + (-0.097772568464279175)*bt_g0_50;
    bt_l1_13 = bt_l1_13 + (-0.18253125250339508)*bt_g0_51;
    bt_l1_13 = bt_l1_13 + (0.012382941320538521)*bt_g0_52;
    bt_l1_13 = bt_l1_13 + (-0.17966492474079132)*bt_g0_53;
    bt_l1_13 = bt_l1_13 + (0.054786007851362228)*bt_g0_54;
    bt_l1_13 = bt_l1_13 + (-0.0032892990857362747)*bt_g0_55;
    bt_l1_13 = bt_l1_13 + (0.063874512910842896)*bt_g0_56;
    bt_l1_13 = bt_l1_13 + (-0.15215079486370087)*bt_g0_57;
    bt_l1_13 = bt_l1_13 + (0.29571694135665894)*bt_g0_58;
    bt_l1_13 = bt_l1_13 + (-0.033457845449447632)*bt_g0_59;
    bt_l1_13 = bt_l1_13 + (0.173489049077034)*bt_g0_60;
    bt_l1_13 = bt_l1_13 + (0.22081150114536285)*bt_g0_61;
    bt_l1_13 = bt_l1_13 + (0.31052321195602417)*bt_g0_62;
    bt_l1_13 = bt_l1_13 + (0.052589148283004761)*bt_g0_63;
    bt_l1_14 = 0.094557210803031921;
    bt_l1_14 = bt_l1_14 + (-0.024643043056130409)*bt_g0_0;
    bt_l1_14 = bt_l1_14 + (-0.088265664875507355)*bt_g0_1;
    bt_l1_14 = bt_l1_14 + (0.035726297646760941)*bt_g0_2;
    bt_l1_14 = bt_l1_14 + (0.068969585001468658)*bt_g0_3;
    bt_l1_14 = bt_l1_14 + (0.14506874978542328)*bt_g0_4;
    bt_l1_14 = bt_l1_14 + (-0.21794131398200989)*bt_g0_5;
    bt_l1_14 = bt_l1_14 + (-0.10019686073064804)*bt_g0_6;
    bt_l1_14 = bt_l1_14 + (-0.020503528416156769)*bt_g0_7;
    bt_l1_14 = bt_l1_14 + (0.063721396028995514)*bt_g0_8;
    bt_l1_14 = bt_l1_14 + (-0.15922477841377258)*bt_g0_9;
    bt_l1_14 = bt_l1_14 + (-0.20838417112827301)*bt_g0_10;
    bt_l1_14 = bt_l1_14 + (0.015277603641152382)*bt_g0_11;
    bt_l1_14 = bt_l1_14 + (0.038546483963727951)*bt_g0_12;
    bt_l1_14 = bt_l1_14 + (0.067470952868461609)*bt_g0_13;
    bt_l1_14 = bt_l1_14 + (-0.112284816801548)*bt_g0_14;
    bt_l1_14 = bt_l1_14 + (-0.042709246277809143)*bt_g0_15;
    bt_l1_14 = bt_l1_14 + (-0.18278190493583679)*bt_g0_16;
    bt_l1_14 = bt_l1_14 + (0.023476980626583099)*bt_g0_17;
    bt_l1_14 = bt_l1_14 + (0.043576225638389587)*bt_g0_18;
    bt_l1_14 = bt_l1_14 + (-0.082290835678577423)*bt_g0_19;
    bt_l1_14 = bt_l1_14 + (-0.02767501212656498)*bt_g0_20;
    bt_l1_14 = bt_l1_14 + (0.044971693307161331)*bt_g0_21;
    bt_l1_14 = bt_l1_14 + (-0.1269955039024353)*bt_g0_22;
    bt_l1_14 = bt_l1_14 + (-0.20824861526489258)*bt_g0_23;
    bt_l1_14 = bt_l1_14 + (-0.43472614884376526)*bt_g0_24;
    bt_l1_14 = bt_l1_14 + (-0.29347541928291321)*bt_g0_25;
    bt_l1_14 = bt_l1_14 + (0.044574324041604996)*bt_g0_26;
    bt_l1_14 = bt_l1_14 + (0.0016521161887794733)*bt_g0_27;
    bt_l1_14 = bt_l1_14 + (-0.35247653722763062)*bt_g0_28;
    bt_l1_14 = bt_l1_14 + (0.10652603954076767)*bt_g0_29;
    bt_l1_14 = bt_l1_14 + (0.1002599373459816)*bt_g0_30;
    bt_l1_14 = bt_l1_14 + (0.10382997989654541)*bt_g0_31;
    bt_l1_14 = bt_l1_14 + (-0.23555463552474976)*bt_g0_32;
    bt_l1_14 = bt_l1_14 + (-0.059677477926015854)*bt_g0_33;
    bt_l1_14 = bt_l1_14 + (-0.030439678579568863)*bt_g0_34;
    bt_l1_14 = bt_l1_14 + (0.14825977385044098)*bt_g0_35;
    bt_l1_14 = bt_l1_14 + (0.010613233782351017)*bt_g0_36;
    bt_l1_14 = bt_l1_14 + (0.014030846767127514)*bt_g0_37;
    bt_l1_14 = bt_l1_14 + (-0.20291745662689209)*bt_g0_38;
    bt_l1_14 = bt_l1_14 + (-0.071479178965091705)*bt_g0_39;
    bt_l1_14 = bt_l1_14 + (0.0058703869581222534)*bt_g0_40;
    bt_l1_14 = bt_l1_14 + (-0.052733041346073151)*bt_g0_41;
    bt_l1_14 = bt_l1_14 + (0.097231946885585785)*bt_g0_42;
    bt_l1_14 = bt_l1_14 + (0.054146613925695419)*bt_g0_43;
    bt_l1_14 = bt_l1_14 + (-0.15926368534564972)*bt_g0_44;
    bt_l1_14 = bt_l1_14 + (0.11659569293260574)*bt_g0_45;
    bt_l1_14 = bt_l1_14 + (0.095272049307823181)*bt_g0_46;
    bt_l1_14 = bt_l1_14 + (0.13728973269462585)*bt_g0_47;
    bt_l1_14 = bt_l1_14 + (-0.010991519317030907)*bt_g0_48;
    bt_l1_14 = bt_l1_14 + (0.2539631724357605)*bt_g0_49;
    bt_l1_14 = bt_l1_14 + (-0.23501366376876831)*bt_g0_50;
    bt_l1_14 = bt_l1_14 + (-0.0025586725678294897)*bt_g0_51;
    bt_l1_14 = bt_l1_14 + (-0.00040742161218076944)*bt_g0_52;
    bt_l1_14 = bt_l1_14 + (0.080728933215141296)*bt_g0_53;
    bt_l1_14 = bt_l1_14 + (-0.092804901301860809)*bt_g0_54;
    bt_l1_14 = bt_l1_14 + (-0.062175896018743515)*bt_g0_55;
    bt_l1_14 = bt_l1_14 + (0.023839531466364861)*bt_g0_56;
    bt_l1_14 = bt_l1_14 + (0.018574697896838188)*bt_g0_57;
    bt_l1_14 = bt_l1_14 + (0.10328227281570435)*bt_g0_58;
    bt_l1_14 = bt_l1_14 + (0.040415946394205093)*bt_g0_59;
    bt_l1_14 = bt_l1_14 + (0.013879526406526566)*bt_g0_60;
    bt_l1_14 = bt_l1_14 + (0.035335078835487366)*bt_g0_61;
    bt_l1_14 = bt_l1_14 + (-0.077477037906646729)*bt_g0_62;
    bt_l1_14 = bt_l1_14 + (-0.14986991882324219)*bt_g0_63;
    bt_l1_15 = 0.13704666495323181;
    bt_l1_15 = bt_l1_15 + (-0.09742225706577301)*bt_g0_0;
    bt_l1_15 = bt_l1_15 + (-0.11485200375318527)*bt_g0_1;
    bt_l1_15 = bt_l1_15 + (0.010608291253447533)*bt_g0_2;
    bt_l1_15 = bt_l1_15 + (-0.035493917763233185)*bt_g0_3;
    bt_l1_15 = bt_l1_15 + (0.12564480304718018)*bt_g0_4;
    bt_l1_15 = bt_l1_15 + (-0.23125021159648895)*bt_g0_5;
    bt_l1_15 = bt_l1_15 + (0.040472898632287979)*bt_g0_6;
    bt_l1_15 = bt_l1_15 + (-0.163334921002388)*bt_g0_7;
    bt_l1_15 = bt_l1_15 + (0.13645680248737335)*bt_g0_8;
    bt_l1_15 = bt_l1_15 + (0.074210770428180695)*bt_g0_9;
    bt_l1_15 = bt_l1_15 + (-0.0089003574103116989)*bt_g0_10;
    bt_l1_15 = bt_l1_15 + (-0.012467691674828529)*bt_g0_11;
    bt_l1_15 = bt_l1_15 + (-0.062806874513626099)*bt_g0_12;
    bt_l1_15 = bt_l1_15 + (0.10265669226646423)*bt_g0_13;
    bt_l1_15 = bt_l1_15 + (0.018933814018964767)*bt_g0_14;
    bt_l1_15 = bt_l1_15 + (-0.1178332045674324)*bt_g0_15;
    bt_l1_15 = bt_l1_15 + (-0.16446773707866669)*bt_g0_16;
    bt_l1_15 = bt_l1_15 + (-0.051442619413137436)*bt_g0_17;
    bt_l1_15 = bt_l1_15 + (-0.0073942984454333782)*bt_g0_18;
    bt_l1_15 = bt_l1_15 + (0.17032898962497711)*bt_g0_19;
    bt_l1_15 = bt_l1_15 + (0.15750704705715179)*bt_g0_20;
    bt_l1_15 = bt_l1_15 + (0.04467923566699028)*bt_g0_21;
    bt_l1_15 = bt_l1_15 + (-0.0036301699001342058)*bt_g0_22;
    bt_l1_15 = bt_l1_15 + (0.097688928246498108)*bt_g0_23;
    bt_l1_15 = bt_l1_15 + (0.24410882592201233)*bt_g0_24;
    bt_l1_15 = bt_l1_15 + (-0.13665851950645447)*bt_g0_25;
    bt_l1_15 = bt_l1_15 + (-0.066417470574378967)*bt_g0_26;
    bt_l1_15 = bt_l1_15 + (-0.075468994677066803)*bt_g0_27;
    bt_l1_15 = bt_l1_15 + (0.1147802323102951)*bt_g0_28;
    bt_l1_15 = bt_l1_15 + (-0.055296644568443298)*bt_g0_29;
    bt_l1_15 = bt_l1_15 + (0.022476628422737122)*bt_g0_30;
    bt_l1_15 = bt_l1_15 + (-0.060696963220834732)*bt_g0_31;
    bt_l1_15 = bt_l1_15 + (-0.20453976094722748)*bt_g0_32;
    bt_l1_15 = bt_l1_15 + (0.074956715106964111)*bt_g0_33;
    bt_l1_15 = bt_l1_15 + (0.067135646939277649)*bt_g0_34;
    bt_l1_15 = bt_l1_15 + (0.011104719713330269)*bt_g0_35;
    bt_l1_15 = bt_l1_15 + (-0.11543035507202148)*bt_g0_36;
    bt_l1_15 = bt_l1_15 + (0.042099647223949432)*bt_g0_37;
    bt_l1_15 = bt_l1_15 + (0.052922997623682022)*bt_g0_38;
    bt_l1_15 = bt_l1_15 + (0.31007459759712219)*bt_g0_39;
    bt_l1_15 = bt_l1_15 + (-0.18170543015003204)*bt_g0_40;
    bt_l1_15 = bt_l1_15 + (0.014708651229739189)*bt_g0_41;
    bt_l1_15 = bt_l1_15 + (0.045205660164356232)*bt_g0_42;
    bt_l1_15 = bt_l1_15 + (0.14389659464359283)*bt_g0_43;
    bt_l1_15 = bt_l1_15 + (-0.013877496123313904)*bt_g0_44;
    bt_l1_15 = bt_l1_15 + (-0.091957338154315948)*bt_g0_45;
    bt_l1_15 = bt_l1_15 + (-0.072985649108886719)*bt_g0_46;
    bt_l1_15 = bt_l1_15 + (0.012520479969680309)*bt_g0_47;
    bt_l1_15 = bt_l1_15 + (-0.0018965911585837603)*bt_g0_48;
    bt_l1_15 = bt_l1_15 + (-0.058000911027193069)*bt_g0_49;
    bt_l1_15 = bt_l1_15 + (0.020980114117264748)*bt_g0_50;
    bt_l1_15 = bt_l1_15 + (0.080409824848175049)*bt_g0_51;
    bt_l1_15 = bt_l1_15 + (-0.13969805836677551)*bt_g0_52;
    bt_l1_15 = bt_l1_15 + (0.031534180045127869)*bt_g0_53;
    bt_l1_15 = bt_l1_15 + (0.078127540647983551)*bt_g0_54;
    bt_l1_15 = bt_l1_15 + (-0.069202855229377747)*bt_g0_55;
    bt_l1_15 = bt_l1_15 + (0.092235416173934937)*bt_g0_56;
    bt_l1_15 = bt_l1_15 + (-0.015825854614377022)*bt_g0_57;
    bt_l1_15 = bt_l1_15 + (0.09445258229970932)*bt_g0_58;
    bt_l1_15 = bt_l1_15 + (-0.065739743411540985)*bt_g0_59;
    bt_l1_15 = bt_l1_15 + (-0.16897119581699371)*bt_g0_60;
    bt_l1_15 = bt_l1_15 + (0.082090213894844055)*bt_g0_61;
    bt_l1_15 = bt_l1_15 + (-0.23370413482189178)*bt_g0_62;
    bt_l1_15 = bt_l1_15 + (0.078098580241203308)*bt_g0_63;
    bt_l1_16 = -0.05261518806219101;
    bt_l1_16 = bt_l1_16 + (-0.021605243906378746)*bt_g0_0;
    bt_l1_16 = bt_l1_16 + (-0.24839003384113312)*bt_g0_1;
    bt_l1_16 = bt_l1_16 + (0.048509310930967331)*bt_g0_2;
    bt_l1_16 = bt_l1_16 + (0.018322041258215904)*bt_g0_3;
    bt_l1_16 = bt_l1_16 + (-0.05727674812078476)*bt_g0_4;
    bt_l1_16 = bt_l1_16 + (-0.01144164614379406)*bt_g0_5;
    bt_l1_16 = bt_l1_16 + (-0.029289115220308304)*bt_g0_6;
    bt_l1_16 = bt_l1_16 + (0.13117799162864685)*bt_g0_7;
    bt_l1_16 = bt_l1_16 + (0.21713525056838989)*bt_g0_8;
    bt_l1_16 = bt_l1_16 + (0.036800194531679153)*bt_g0_9;
    bt_l1_16 = bt_l1_16 + (-0.063141502439975739)*bt_g0_10;
    bt_l1_16 = bt_l1_16 + (-0.096123337745666504)*bt_g0_11;
    bt_l1_16 = bt_l1_16 + (-0.082541093230247498)*bt_g0_12;
    bt_l1_16 = bt_l1_16 + (-0.050003711134195328)*bt_g0_13;
    bt_l1_16 = bt_l1_16 + (0.078758664429187775)*bt_g0_14;
    bt_l1_16 = bt_l1_16 + (0.22158487141132355)*bt_g0_15;
    bt_l1_16 = bt_l1_16 + (0.20465952157974243)*bt_g0_16;
    bt_l1_16 = bt_l1_16 + (0.07642635703086853)*bt_g0_17;
    bt_l1_16 = bt_l1_16 + (-0.079454846680164337)*bt_g0_18;
    bt_l1_16 = bt_l1_16 + (0.11433181166648865)*bt_g0_19;
    bt_l1_16 = bt_l1_16 + (-0.010828645899891853)*bt_g0_20;
    bt_l1_16 = bt_l1_16 + (0.15660221874713898)*bt_g0_21;
    bt_l1_16 = bt_l1_16 + (-0.11608139425516129)*bt_g0_22;
    bt_l1_16 = bt_l1_16 + (0.2196924239397049)*bt_g0_23;
    bt_l1_16 = bt_l1_16 + (-0.049249257892370224)*bt_g0_24;
    bt_l1_16 = bt_l1_16 + (-0.041766904294490814)*bt_g0_25;
    bt_l1_16 = bt_l1_16 + (0.13242843747138977)*bt_g0_26;
    bt_l1_16 = bt_l1_16 + (0.23559331893920898)*bt_g0_27;
    bt_l1_16 = bt_l1_16 + (-0.040592420846223831)*bt_g0_28;
    bt_l1_16 = bt_l1_16 + (-0.12487109750509262)*bt_g0_29;
    bt_l1_16 = bt_l1_16 + (0.0018005456076934934)*bt_g0_30;
    bt_l1_16 = bt_l1_16 + (-0.079241260886192322)*bt_g0_31;
    bt_l1_16 = bt_l1_16 + (0.34661531448364258)*bt_g0_32;
    bt_l1_16 = bt_l1_16 + (-0.23430880904197693)*bt_g0_33;
    bt_l1_16 = bt_l1_16 + (-0.11540190130472183)*bt_g0_34;
    bt_l1_16 = bt_l1_16 + (0.20595064759254456)*bt_g0_35;
    bt_l1_16 = bt_l1_16 + (0.21889598667621613)*bt_g0_36;
    bt_l1_16 = bt_l1_16 + (-0.0366506427526474)*bt_g0_37;
    bt_l1_16 = bt_l1_16 + (0.24245879054069519)*bt_g0_38;
    bt_l1_16 = bt_l1_16 + (-0.033385239541530609)*bt_g0_39;
    bt_l1_16 = bt_l1_16 + (-0.065061084926128387)*bt_g0_40;
    bt_l1_16 = bt_l1_16 + (-0.15025323629379272)*bt_g0_41;
    bt_l1_16 = bt_l1_16 + (0.030969409272074699)*bt_g0_42;
    bt_l1_16 = bt_l1_16 + (0.083836279809474945)*bt_g0_43;
    bt_l1_16 = bt_l1_16 + (0.17362567782402039)*bt_g0_44;
    bt_l1_16 = bt_l1_16 + (-0.23481391370296478)*bt_g0_45;
    bt_l1_16 = bt_l1_16 + (-0.098992951214313507)*bt_g0_46;
    bt_l1_16 = bt_l1_16 + (-0.1168515756726265)*bt_g0_47;
    bt_l1_16 = bt_l1_16 + (-0.028380734845995903)*bt_g0_48;
    bt_l1_16 = bt_l1_16 + (0.1363050639629364)*bt_g0_49;
    bt_l1_16 = bt_l1_16 + (0.0062941042706370354)*bt_g0_50;
    bt_l1_16 = bt_l1_16 + (0.28029742836952209)*bt_g0_51;
    bt_l1_16 = bt_l1_16 + (0.077205315232276917)*bt_g0_52;
    bt_l1_16 = bt_l1_16 + (-0.098607711493968964)*bt_g0_53;
    bt_l1_16 = bt_l1_16 + (-0.0026519265957176685)*bt_g0_54;
    bt_l1_16 = bt_l1_16 + (-0.014329512603580952)*bt_g0_55;
    bt_l1_16 = bt_l1_16 + (0.0064421077258884907)*bt_g0_56;
    bt_l1_16 = bt_l1_16 + (0.012819451279938221)*bt_g0_57;
    bt_l1_16 = bt_l1_16 + (0.16233211755752563)*bt_g0_58;
    bt_l1_16 = bt_l1_16 + (-0.082167819142341614)*bt_g0_59;
    bt_l1_16 = bt_l1_16 + (-0.013679132796823978)*bt_g0_60;
    bt_l1_16 = bt_l1_16 + (-0.075202956795692444)*bt_g0_61;
    bt_l1_16 = bt_l1_16 + (0.32835587859153748)*bt_g0_62;
    bt_l1_16 = bt_l1_16 + (-0.045069616287946701)*bt_g0_63;
    bt_l1_17 = -0.0092484457418322563;
    bt_l1_17 = bt_l1_17 + (0.086327992379665375)*bt_g0_0;
    bt_l1_17 = bt_l1_17 + (0.17083829641342163)*bt_g0_1;
    bt_l1_17 = bt_l1_17 + (-0.056378275156021118)*bt_g0_2;
    bt_l1_17 = bt_l1_17 + (-0.039430990815162659)*bt_g0_3;
    bt_l1_17 = bt_l1_17 + (0.1145898848772049)*bt_g0_4;
    bt_l1_17 = bt_l1_17 + (-0.75738072395324707)*bt_g0_5;
    bt_l1_17 = bt_l1_17 + (-0.23523795604705811)*bt_g0_6;
    bt_l1_17 = bt_l1_17 + (-0.058024898171424866)*bt_g0_7;
    bt_l1_17 = bt_l1_17 + (-0.19176764786243439)*bt_g0_8;
    bt_l1_17 = bt_l1_17 + (-0.10059336572885513)*bt_g0_9;
    bt_l1_17 = bt_l1_17 + (0.056603651493787766)*bt_g0_10;
    bt_l1_17 = bt_l1_17 + (-0.0010963140521198511)*bt_g0_11;
    bt_l1_17 = bt_l1_17 + (-0.13812950253486633)*bt_g0_12;
    bt_l1_17 = bt_l1_17 + (0.13703069090843201)*bt_g0_13;
    bt_l1_17 = bt_l1_17 + (-0.13058850169181824)*bt_g0_14;
    bt_l1_17 = bt_l1_17 + (-1.0797488689422607)*bt_g0_15;
    bt_l1_17 = bt_l1_17 + (-0.52730363607406616)*bt_g0_16;
    bt_l1_17 = bt_l1_17 + (-0.091046452522277832)*bt_g0_17;
    bt_l1_17 = bt_l1_17 + (0.15636913478374481)*bt_g0_18;
    bt_l1_17 = bt_l1_17 + (0.059550795704126358)*bt_g0_19;
    bt_l1_17 = bt_l1_17 + (-0.10174425691366196)*bt_g0_20;
    bt_l1_17 = bt_l1_17 + (0.023215910419821739)*bt_g0_21;
    bt_l1_17 = bt_l1_17 + (-0.044051818549633026)*bt_g0_22;
    bt_l1_17 = bt_l1_17 + (-0.33269572257995605)*bt_g0_23;
    bt_l1_17 = bt_l1_17 + (0.088352344930171967)*bt_g0_24;
    bt_l1_17 = bt_l1_17 + (0.05951111763715744)*bt_g0_25;
    bt_l1_17 = bt_l1_17 + (-0.11954744160175323)*bt_g0_26;
    bt_l1_17 = bt_l1_17 + (0.043175369501113892)*bt_g0_27;
    bt_l1_17 = bt_l1_17 + (0.085229009389877319)*bt_g0_28;
    bt_l1_17 = bt_l1_17 + (0.063692189753055573)*bt_g0_29;
    bt_l1_17 = bt_l1_17 + (0.13331931829452515)*bt_g0_30;
    bt_l1_17 = bt_l1_17 + (0.15137316286563873)*bt_g0_31;
    bt_l1_17 = bt_l1_17 + (-0.042291242629289627)*bt_g0_32;
    bt_l1_17 = bt_l1_17 + (0.0061294804327189922)*bt_g0_33;
    bt_l1_17 = bt_l1_17 + (0.015235107392072678)*bt_g0_34;
    bt_l1_17 = bt_l1_17 + (0.0015297180507332087)*bt_g0_35;
    bt_l1_17 = bt_l1_17 + (-0.29128780961036682)*bt_g0_36;
    bt_l1_17 = bt_l1_17 + (0.00450466712936759)*bt_g0_37;
    bt_l1_17 = bt_l1_17 + (-0.37659928202629089)*bt_g0_38;
    bt_l1_17 = bt_l1_17 + (-0.004014759324491024)*bt_g0_39;
    bt_l1_17 = bt_l1_17 + (0.013609676621854305)*bt_g0_40;
    bt_l1_17 = bt_l1_17 + (0.096860557794570923)*bt_g0_41;
    bt_l1_17 = bt_l1_17 + (-0.086733639240264893)*bt_g0_42;
    bt_l1_17 = bt_l1_17 + (0.13332611322402954)*bt_g0_43;
    bt_l1_17 = bt_l1_17 + (0.0089765014126896858)*bt_g0_44;
    bt_l1_17 = bt_l1_17 + (0.20271717011928558)*bt_g0_45;
    bt_l1_17 = bt_l1_17 + (0.031048828735947609)*bt_g0_46;
    bt_l1_17 = bt_l1_17 + (0.015314563177525997)*bt_g0_47;
    bt_l1_17 = bt_l1_17 + (0.082361534237861633)*bt_g0_48;
    bt_l1_17 = bt_l1_17 + (-0.04237336665391922)*bt_g0_49;
    bt_l1_17 = bt_l1_17 + (-0.047099947929382324)*bt_g0_50;
    bt_l1_17 = bt_l1_17 + (-0.35941696166992188)*bt_g0_51;
    bt_l1_17 = bt_l1_17 + (-0.15158744156360626)*bt_g0_52;
    bt_l1_17 = bt_l1_17 + (0.19064618647098541)*bt_g0_53;
    bt_l1_17 = bt_l1_17 + (-0.099318243563175201)*bt_g0_54;
    bt_l1_17 = bt_l1_17 + (-0.027682783082127571)*bt_g0_55;
    bt_l1_17 = bt_l1_17 + (0.035780474543571472)*bt_g0_56;
    bt_l1_17 = bt_l1_17 + (-0.024292534217238426)*bt_g0_57;
    bt_l1_17 = bt_l1_17 + (-0.13112063705921173)*bt_g0_58;
    bt_l1_17 = bt_l1_17 + (-0.16674570739269257)*bt_g0_59;
    bt_l1_17 = bt_l1_17 + (-0.10183694958686829)*bt_g0_60;
    bt_l1_17 = bt_l1_17 + (0.13299195468425751)*bt_g0_61;
    bt_l1_17 = bt_l1_17 + (-1.1436964273452759)*bt_g0_62;
    bt_l1_17 = bt_l1_17 + (-0.13711519539356232)*bt_g0_63;
    bt_l1_18 = 0.11555948853492737;
    bt_l1_18 = bt_l1_18 + (-0.023178968578577042)*bt_g0_0;
    bt_l1_18 = bt_l1_18 + (-0.067543596029281616)*bt_g0_1;
    bt_l1_18 = bt_l1_18 + (0.15660525858402252)*bt_g0_2;
    bt_l1_18 = bt_l1_18 + (-0.13233515620231628)*bt_g0_3;
    bt_l1_18 = bt_l1_18 + (-0.03915594145655632)*bt_g0_4;
    bt_l1_18 = bt_l1_18 + (-0.075899876654148102)*bt_g0_5;
    bt_l1_18 = bt_l1_18 + (0.067462027072906494)*bt_g0_6;
    bt_l1_18 = bt_l1_18 + (-0.084513016045093536)*bt_g0_7;
    bt_l1_18 = bt_l1_18 + (0.012139234691858292)*bt_g0_8;
    bt_l1_18 = bt_l1_18 + (0.10495531558990479)*bt_g0_9;
    bt_l1_18 = bt_l1_18 + (0.10526260733604431)*bt_g0_10;
    bt_l1_18 = bt_l1_18 + (-0.010541913099586964)*bt_g0_11;
    bt_l1_18 = bt_l1_18 + (-0.1092088371515274)*bt_g0_12;
    bt_l1_18 = bt_l1_18 + (-0.061976425349712372)*bt_g0_13;
    bt_l1_18 = bt_l1_18 + (0.0014750041300430894)*bt_g0_14;
    bt_l1_18 = bt_l1_18 + (-0.1098102331161499)*bt_g0_15;
    bt_l1_18 = bt_l1_18 + (-0.025491019710898399)*bt_g0_16;
    bt_l1_18 = bt_l1_18 + (0.035140093415975571)*bt_g0_17;
    bt_l1_18 = bt_l1_18 + (0.058286253362894058)*bt_g0_18;
    bt_l1_18 = bt_l1_18 + (-0.080035850405693054)*bt_g0_19;
    bt_l1_18 = bt_l1_18 + (-0.16326582431793213)*bt_g0_20;
    bt_l1_18 = bt_l1_18 + (-0.081327751278877258)*bt_g0_21;
    bt_l1_18 = bt_l1_18 + (-0.035035945475101471)*bt_g0_22;
    bt_l1_18 = bt_l1_18 + (0.10352571308612823)*bt_g0_23;
    bt_l1_18 = bt_l1_18 + (-0.097818009555339813)*bt_g0_24;
    bt_l1_18 = bt_l1_18 + (-0.070859804749488831)*bt_g0_25;
    bt_l1_18 = bt_l1_18 + (-0.051504001021385193)*bt_g0_26;
    bt_l1_18 = bt_l1_18 + (-0.17095854878425598)*bt_g0_27;
    bt_l1_18 = bt_l1_18 + (-0.12884914875030518)*bt_g0_28;
    bt_l1_18 = bt_l1_18 + (-0.062480617314577103)*bt_g0_29;
    bt_l1_18 = bt_l1_18 + (0.10976637899875641)*bt_g0_30;
    bt_l1_18 = bt_l1_18 + (-0.072018459439277649)*bt_g0_31;
    bt_l1_18 = bt_l1_18 + (-0.27631598711013794)*bt_g0_32;
    bt_l1_18 = bt_l1_18 + (0.079105719923973083)*bt_g0_33;
    bt_l1_18 = bt_l1_18 + (0.075326256453990936)*bt_g0_34;
    bt_l1_18 = bt_l1_18 + (0.0908631831407547)*bt_g0_35;
    bt_l1_18 = bt_l1_18 + (-0.086143329739570618)*bt_g0_36;
    bt_l1_18 = bt_l1_18 + (0.083634614944458008)*bt_g0_37;
    bt_l1_18 = bt_l1_18 + (0.02218022383749485)*bt_g0_38;
    bt_l1_18 = bt_l1_18 + (-0.11773843318223953)*bt_g0_39;
    bt_l1_18 = bt_l1_18 + (-0.053296774625778198)*bt_g0_40;
    bt_l1_18 = bt_l1_18 + (0.043676149100065231)*bt_g0_41;
    bt_l1_18 = bt_l1_18 + (0.058425549417734146)*bt_g0_42;
    bt_l1_18 = bt_l1_18 + (-0.0047613191418349743)*bt_g0_43;
    bt_l1_18 = bt_l1_18 + (-0.23679728806018829)*bt_g0_44;
    bt_l1_18 = bt_l1_18 + (0.095106445252895355)*bt_g0_45;
    bt_l1_18 = bt_l1_18 + (0.0038214437663555145)*bt_g0_46;
    bt_l1_18 = bt_l1_18 + (0.043759282678365707)*bt_g0_47;
    bt_l1_18 = bt_l1_18 + (-0.031936503946781158)*bt_g0_48;
    bt_l1_18 = bt_l1_18 + (-0.045709926635026932)*bt_g0_49;
    bt_l1_18 = bt_l1_18 + (0.068975120782852173)*bt_g0_50;
    bt_l1_18 = bt_l1_18 + (-0.0075409966520965099)*bt_g0_51;
    bt_l1_18 = bt_l1_18 + (-0.15346643328666687)*bt_g0_52;
    bt_l1_18 = bt_l1_18 + (-0.11393230408430099)*bt_g0_53;
    bt_l1_18 = bt_l1_18 + (-0.063267119228839874)*bt_g0_54;
    bt_l1_18 = bt_l1_18 + (0.072732694447040558)*bt_g0_55;
    bt_l1_18 = bt_l1_18 + (0.067396216094493866)*bt_g0_56;
    bt_l1_18 = bt_l1_18 + (-0.0077940425835549831)*bt_g0_57;
    bt_l1_18 = bt_l1_18 + (0.06393229216337204)*bt_g0_58;
    bt_l1_18 = bt_l1_18 + (-0.039988528937101364)*bt_g0_59;
    bt_l1_18 = bt_l1_18 + (-0.047469370067119598)*bt_g0_60;
    bt_l1_18 = bt_l1_18 + (0.077702894806861877)*bt_g0_61;
    bt_l1_18 = bt_l1_18 + (0.067935869097709656)*bt_g0_62;
    bt_l1_18 = bt_l1_18 + (0.072701156139373779)*bt_g0_63;
    bt_l1_19 = -0.051879279315471649;
    bt_l1_19 = bt_l1_19 + (0.020345140248537064)*bt_g0_0;
    bt_l1_19 = bt_l1_19 + (-0.38689705729484558)*bt_g0_1;
    bt_l1_19 = bt_l1_19 + (0.050075948238372803)*bt_g0_2;
    bt_l1_19 = bt_l1_19 + (0.034595273435115814)*bt_g0_3;
    bt_l1_19 = bt_l1_19 + (-0.055822212249040604)*bt_g0_4;
    bt_l1_19 = bt_l1_19 + (0.14556047320365906)*bt_g0_5;
    bt_l1_19 = bt_l1_19 + (-0.13013818860054016)*bt_g0_6;
    bt_l1_19 = bt_l1_19 + (0.57169967889785767)*bt_g0_7;
    bt_l1_19 = bt_l1_19 + (-0.014495652168989182)*bt_g0_8;
    bt_l1_19 = bt_l1_19 + (0.12576895952224731)*bt_g0_9;
    bt_l1_19 = bt_l1_19 + (-0.041813969612121582)*bt_g0_10;
    bt_l1_19 = bt_l1_19 + (0.16308115422725677)*bt_g0_11;
    bt_l1_19 = bt_l1_19 + (0.035675253719091415)*bt_g0_12;
    bt_l1_19 = bt_l1_19 + (-0.12708038091659546)*bt_g0_13;
    bt_l1_19 = bt_l1_19 + (0.11771871149539948)*bt_g0_14;
    bt_l1_19 = bt_l1_19 + (-0.00059166067512705922)*bt_g0_15;
    bt_l1_19 = bt_l1_19 + (0.28106996417045593)*bt_g0_16;
    bt_l1_19 = bt_l1_19 + (-0.049271438270807266)*bt_g0_17;
    bt_l1_19 = bt_l1_19 + (-0.11976615339517593)*bt_g0_18;
    bt_l1_19 = bt_l1_19 + (-0.14753872156143188)*bt_g0_19;
    bt_l1_19 = bt_l1_19 + (0.13547457754611969)*bt_g0_20;
    bt_l1_19 = bt_l1_19 + (-0.09773196280002594)*bt_g0_21;
    bt_l1_19 = bt_l1_19 + (-0.33940455317497253)*bt_g0_22;
    bt_l1_19 = bt_l1_19 + (0.14150789380073547)*bt_g0_23;
    bt_l1_19 = bt_l1_19 + (0.33384072780609131)*bt_g0_24;
    bt_l1_19 = bt_l1_19 + (0.019446112215518951)*bt_g0_25;
    bt_l1_19 = bt_l1_19 + (-0.019465314224362373)*bt_g0_26;
    bt_l1_19 = bt_l1_19 + (1.0084580183029175)*bt_g0_27;
    bt_l1_19 = bt_l1_19 + (0.15113945305347443)*bt_g0_28;
    bt_l1_19 = bt_l1_19 + (-0.034674711525440216)*bt_g0_29;
    bt_l1_19 = bt_l1_19 + (-0.13079562783241272)*bt_g0_30;
    bt_l1_19 = bt_l1_19 + (-0.042222507297992706)*bt_g0_31;
    bt_l1_19 = bt_l1_19 + (0.83718520402908325)*bt_g0_32;
    bt_l1_19 = bt_l1_19 + (-0.16606290638446808)*bt_g0_33;
    bt_l1_19 = bt_l1_19 + (-0.11842088401317596)*bt_g0_34;
    bt_l1_19 = bt_l1_19 + (-0.32253184914588928)*bt_g0_35;
    bt_l1_19 = bt_l1_19 + (-0.0042144227772951126)*bt_g0_36;
    bt_l1_19 = bt_l1_19 + (0.27734106779098511)*bt_g0_37;
    bt_l1_19 = bt_l1_19 + (0.23096944391727448)*bt_g0_38;
    bt_l1_19 = bt_l1_19 + (0.20109763741493225)*bt_g0_39;
    bt_l1_19 = bt_l1_19 + (-0.12467832863330841)*bt_g0_40;
    bt_l1_19 = bt_l1_19 + (-0.13316705822944641)*bt_g0_41;
    bt_l1_19 = bt_l1_19 + (-0.066936001181602478)*bt_g0_42;
    bt_l1_19 = bt_l1_19 + (-0.075018227100372314)*bt_g0_43;
    bt_l1_19 = bt_l1_19 + (0.46696320176124573)*bt_g0_44;
    bt_l1_19 = bt_l1_19 + (-0.25914844870567322)*bt_g0_45;
    bt_l1_19 = bt_l1_19 + (-0.028372317552566528)*bt_g0_46;
    bt_l1_19 = bt_l1_19 + (-0.022434158250689507)*bt_g0_47;
    bt_l1_19 = bt_l1_19 + (-0.079123705625534058)*bt_g0_48;
    bt_l1_19 = bt_l1_19 + (-0.054338499903678894)*bt_g0_49;
    bt_l1_19 = bt_l1_19 + (0.25266128778457642)*bt_g0_50;
    bt_l1_19 = bt_l1_19 + (0.20587538182735443)*bt_g0_51;
    bt_l1_19 = bt_l1_19 + (0.17403601109981537)*bt_g0_52;
    bt_l1_19 = bt_l1_19 + (-0.20244044065475464)*bt_g0_53;
    bt_l1_19 = bt_l1_19 + (0.11720698326826096)*bt_g0_54;
    bt_l1_19 = bt_l1_19 + (0.041080977767705917)*bt_g0_55;
    bt_l1_19 = bt_l1_19 + (-0.040926702320575714)*bt_g0_56;
    bt_l1_19 = bt_l1_19 + (0.1031515970826149)*bt_g0_57;
    bt_l1_19 = bt_l1_19 + (-0.061547659337520599)*bt_g0_58;
    bt_l1_19 = bt_l1_19 + (-0.012650481425225735)*bt_g0_59;
    bt_l1_19 = bt_l1_19 + (-0.25946280360221863)*bt_g0_60;
    bt_l1_19 = bt_l1_19 + (0.13023382425308228)*bt_g0_61;
    bt_l1_19 = bt_l1_19 + (-0.0075258980505168438)*bt_g0_62;
    bt_l1_19 = bt_l1_19 + (0.10944440960884094)*bt_g0_63;
    bt_l1_20 = 0.037534423172473907;
    bt_l1_20 = bt_l1_20 + (-0.1666417121887207)*bt_g0_0;
    bt_l1_20 = bt_l1_20 + (-0.084057711064815521)*bt_g0_1;
    bt_l1_20 = bt_l1_20 + (0.10830634832382202)*bt_g0_2;
    bt_l1_20 = bt_l1_20 + (-0.002463160315528512)*bt_g0_3;
    bt_l1_20 = bt_l1_20 + (0.14053013920783997)*bt_g0_4;
    bt_l1_20 = bt_l1_20 + (0.0026903825346380472)*bt_g0_5;
    bt_l1_20 = bt_l1_20 + (0.082843147218227386)*bt_g0_6;
    bt_l1_20 = bt_l1_20 + (-0.091128043830394745)*bt_g0_7;
    bt_l1_20 = bt_l1_20 + (0.064043790102005005)*bt_g0_8;
    bt_l1_20 = bt_l1_20 + (-0.092845216393470764)*bt_g0_9;
    bt_l1_20 = bt_l1_20 + (-0.091916166245937347)*bt_g0_10;
    bt_l1_20 = bt_l1_20 + (-0.054241258651018143)*bt_g0_11;
    bt_l1_20 = bt_l1_20 + (-0.15468895435333252)*bt_g0_12;
    bt_l1_20 = bt_l1_20 + (-0.0049950149841606617)*bt_g0_13;
    bt_l1_20 = bt_l1_20 + (-0.10001778602600098)*bt_g0_14;
    bt_l1_20 = bt_l1_20 + (0.079750329256057739)*bt_g0_15;
    bt_l1_20 = bt_l1_20 + (-0.18214990198612213)*bt_g0_16;
    bt_l1_20 = bt_l1_20 + (0.10526644438505173)*bt_g0_17;
    bt_l1_20 = bt_l1_20 + (0.081886947154998779)*bt_g0_18;
    bt_l1_20 = bt_l1_20 + (0.051542885601520538)*bt_g0_19;
    bt_l1_20 = bt_l1_20 + (-0.11428698897361755)*bt_g0_20;
    bt_l1_20 = bt_l1_20 + (-0.087073192000389099)*bt_g0_21;
    bt_l1_20 = bt_l1_20 + (-0.071775525808334351)*bt_g0_22;
    bt_l1_20 = bt_l1_20 + (0.12212297320365906)*bt_g0_23;
    bt_l1_20 = bt_l1_20 + (-0.15108901262283325)*bt_g0_24;
    bt_l1_20 = bt_l1_20 + (-0.074378654360771179)*bt_g0_25;
    bt_l1_20 = bt_l1_20 + (0.034106966108083725)*bt_g0_26;
    bt_l1_20 = bt_l1_20 + (-0.22046585381031036)*bt_g0_27;
    bt_l1_20 = bt_l1_20 + (-0.25860783457756042)*bt_g0_28;
    bt_l1_20 = bt_l1_20 + (-0.10428307950496674)*bt_g0_29;
    bt_l1_20 = bt_l1_20 + (0.12069833278656006)*bt_g0_30;
    bt_l1_20 = bt_l1_20 + (-0.087891891598701477)*bt_g0_31;
    bt_l1_20 = bt_l1_20 + (-0.19902700185775757)*bt_g0_32;
    bt_l1_20 = bt_l1_20 + (0.012257050722837448)*bt_g0_33;
    bt_l1_20 = bt_l1_20 + (-0.031014587730169296)*bt_g0_34;
    bt_l1_20 = bt_l1_20 + (-0.097871221601963043)*bt_g0_35;
    bt_l1_20 = bt_l1_20 + (0.038876641541719437)*bt_g0_36;
    bt_l1_20 = bt_l1_20 + (0.20706920325756073)*bt_g0_37;
    bt_l1_20 = bt_l1_20 + (-0.12256858497858047)*bt_g0_38;
    bt_l1_20 = bt_l1_20 + (-0.19533629715442657)*bt_g0_39;
    bt_l1_20 = bt_l1_20 + (0.035421270877122879)*bt_g0_40;
    bt_l1_20 = bt_l1_20 + (0.079341672360897064)*bt_g0_41;
    bt_l1_20 = bt_l1_20 + (0.20045553147792816)*bt_g0_42;
    bt_l1_20 = bt_l1_20 + (-0.03296864777803421)*bt_g0_43;
    bt_l1_20 = bt_l1_20 + (-0.3146817684173584)*bt_g0_44;
    bt_l1_20 = bt_l1_20 + (-0.054270025342702866)*bt_g0_45;
    bt_l1_20 = bt_l1_20 + (0.016639957204461098)*bt_g0_46;
    bt_l1_20 = bt_l1_20 + (-0.08851226419210434)*bt_g0_47;
    bt_l1_20 = bt_l1_20 + (-0.0026203454472124577)*bt_g0_48;
    bt_l1_20 = bt_l1_20 + (-0.20104148983955383)*bt_g0_49;
    bt_l1_20 = bt_l1_20 + (-0.0066672777757048607)*bt_g0_50;
    bt_l1_20 = bt_l1_20 + (-0.068473353981971741)*bt_g0_51;
    bt_l1_20 = bt_l1_20 + (-0.1209944561123848)*bt_g0_52;
    bt_l1_20 = bt_l1_20 + (-0.087087079882621765)*bt_g0_53;
    bt_l1_20 = bt_l1_20 + (-0.078384116291999817)*bt_g0_54;
    bt_l1_20 = bt_l1_20 + (-0.037274070084095001)*bt_g0_55;
    bt_l1_20 = bt_l1_20 + (-0.0079938825219869614)*bt_g0_56;
    bt_l1_20 = bt_l1_20 + (0.0058940080925822258)*bt_g0_57;
    bt_l1_20 = bt_l1_20 + (-0.058801427483558655)*bt_g0_58;
    bt_l1_20 = bt_l1_20 + (0.12468056380748749)*bt_g0_59;
    bt_l1_20 = bt_l1_20 + (-0.013717592693865299)*bt_g0_60;
    bt_l1_20 = bt_l1_20 + (0.16884198784828186)*bt_g0_61;
    bt_l1_20 = bt_l1_20 + (0.053033310920000076)*bt_g0_62;
    bt_l1_20 = bt_l1_20 + (-0.016447072848677635)*bt_g0_63;
    bt_l1_21 = -0.099729083478450775;
    bt_l1_21 = bt_l1_21 + (0.029736174270510674)*bt_g0_0;
    bt_l1_21 = bt_l1_21 + (0.059446536004543304)*bt_g0_1;
    bt_l1_21 = bt_l1_21 + (0.15847478806972504)*bt_g0_2;
    bt_l1_21 = bt_l1_21 + (-0.03922203928232193)*bt_g0_3;
    bt_l1_21 = bt_l1_21 + (-0.087087757885456085)*bt_g0_4;
    bt_l1_21 = bt_l1_21 + (-0.15436366200447083)*bt_g0_5;
    bt_l1_21 = bt_l1_21 + (0.019915927201509476)*bt_g0_6;
    bt_l1_21 = bt_l1_21 + (-0.070902936160564423)*bt_g0_7;
    bt_l1_21 = bt_l1_21 + (0.045668534934520721)*bt_g0_8;
    bt_l1_21 = bt_l1_21 + (0.01570088230073452)*bt_g0_9;
    bt_l1_21 = bt_l1_21 + (0.019418191164731979)*bt_g0_10;
    bt_l1_21 = bt_l1_21 + (-0.01213233545422554)*bt_g0_11;
    bt_l1_21 = bt_l1_21 + (-0.01129686925560236)*bt_g0_12;
    bt_l1_21 = bt_l1_21 + (0.18274044990539551)*bt_g0_13;
    bt_l1_21 = bt_l1_21 + (0.18428497016429901)*bt_g0_14;
    bt_l1_21 = bt_l1_21 + (-0.19358745217323303)*bt_g0_15;
    bt_l1_21 = bt_l1_21 + (0.039678741246461868)*bt_g0_16;
    bt_l1_21 = bt_l1_21 + (0.057443395256996155)*bt_g0_17;
    bt_l1_21 = bt_l1_21 + (0.14853839576244354)*bt_g0_18;
    bt_l1_21 = bt_l1_21 + (0.044068288058042526)*bt_g0_19;
    bt_l1_21 = bt_l1_21 + (0.004666987806558609)*bt_g0_20;
    bt_l1_21 = bt_l1_21 + (0.062097977846860886)*bt_g0_21;
    bt_l1_21 = bt_l1_21 + (0.1256243884563446)*bt_g0_22;
    bt_l1_21 = bt_l1_21 + (0.16421151161193848)*bt_g0_23;
    bt_l1_21 = bt_l1_21 + (0.32639661431312561)*bt_g0_24;
    bt_l1_21 = bt_l1_21 + (-0.54874837398529053)*bt_g0_25;
    bt_l1_21 = bt_l1_21 + (-0.098291553556919098)*bt_g0_26;
    bt_l1_21 = bt_l1_21 + (-0.41472050547599792)*bt_g0_27;
    bt_l1_21 = bt_l1_21 + (0.22153580188751221)*bt_g0_28;
    bt_l1_21 = bt_l1_21 + (0.064106233417987823)*bt_g0_29;
    bt_l1_21 = bt_l1_21 + (-0.06630948930978775)*bt_g0_30;
    bt_l1_21 = bt_l1_21 + (0.15023967623710632)*bt_g0_31;
    bt_l1_21 = bt_l1_21 + (-0.07779480516910553)*bt_g0_32;
    bt_l1_21 = bt_l1_21 + (0.078462116420269012)*bt_g0_33;
    bt_l1_21 = bt_l1_21 + (0.075641259551048279)*bt_g0_34;
    bt_l1_21 = bt_l1_21 + (0.0030522122979164124)*bt_g0_35;
    bt_l1_21 = bt_l1_21 + (0.0087517835199832916)*bt_g0_36;
    bt_l1_21 = bt_l1_21 + (-0.0026698471046984196)*bt_g0_37;
    bt_l1_21 = bt_l1_21 + (-0.049541637301445007)*bt_g0_38;
    bt_l1_21 = bt_l1_21 + (0.092638589441776276)*bt_g0_39;
    bt_l1_21 = bt_l1_21 + (-0.019578713923692703)*bt_g0_40;
    bt_l1_21 = bt_l1_21 + (-0.0420733243227005)*bt_g0_41;
    bt_l1_21 = bt_l1_21 + (0.012989928014576435)*bt_g0_42;
    bt_l1_21 = bt_l1_21 + (-0.11078345775604248)*bt_g0_43;
    bt_l1_21 = bt_l1_21 + (0.017404546961188316)*bt_g0_44;
    bt_l1_21 = bt_l1_21 + (0.094615966081619263)*bt_g0_45;
    bt_l1_21 = bt_l1_21 + (0.14625026285648346)*bt_g0_46;
    bt_l1_21 = bt_l1_21 + (-0.059701401740312576)*bt_g0_47;
    bt_l1_21 = bt_l1_21 + (0.11913558840751648)*bt_g0_48;
    bt_l1_21 = bt_l1_21 + (-0.034081112593412399)*bt_g0_49;
    bt_l1_21 = bt_l1_21 + (0.050079457461833954)*bt_g0_50;
    bt_l1_21 = bt_l1_21 + (-0.053834989666938782)*bt_g0_51;
    bt_l1_21 = bt_l1_21 + (0.030220363289117813)*bt_g0_52;
    bt_l1_21 = bt_l1_21 + (-0.047825757414102554)*bt_g0_53;
    bt_l1_21 = bt_l1_21 + (0.076593957841396332)*bt_g0_54;
    bt_l1_21 = bt_l1_21 + (0.05771564319729805)*bt_g0_55;
    bt_l1_21 = bt_l1_21 + (0.087109923362731934)*bt_g0_56;
    bt_l1_21 = bt_l1_21 + (-0.027828691527247429)*bt_g0_57;
    bt_l1_21 = bt_l1_21 + (-0.092854291200637817)*bt_g0_58;
    bt_l1_21 = bt_l1_21 + (-0.15991814434528351)*bt_g0_59;
    bt_l1_21 = bt_l1_21 + (-0.018164040520787239)*bt_g0_60;
    bt_l1_21 = bt_l1_21 + (0.13500271737575531)*bt_g0_61;
    bt_l1_21 = bt_l1_21 + (-0.12278081476688385)*bt_g0_62;
    bt_l1_21 = bt_l1_21 + (0.039847042411565781)*bt_g0_63;
    bt_l1_22 = 0.12325837463140488;
    bt_l1_22 = bt_l1_22 + (0.0172561164945364)*bt_g0_0;
    bt_l1_22 = bt_l1_22 + (0.021800242364406586)*bt_g0_1;
    bt_l1_22 = bt_l1_22 + (-0.034738138318061829)*bt_g0_2;
    bt_l1_22 = bt_l1_22 + (0.062455639243125916)*bt_g0_3;
    bt_l1_22 = bt_l1_22 + (-0.053594700992107391)*bt_g0_4;
    bt_l1_22 = bt_l1_22 + (0.15548534691333771)*bt_g0_5;
    bt_l1_22 = bt_l1_22 + (-0.006232753861695528)*bt_g0_6;
    bt_l1_22 = bt_l1_22 + (-0.052635654807090759)*bt_g0_7;
    bt_l1_22 = bt_l1_22 + (-0.17670832574367523)*bt_g0_8;
    bt_l1_22 = bt_l1_22 + (0.061821006238460541)*bt_g0_9;
    bt_l1_22 = bt_l1_22 + (0.069340027868747711)*bt_g0_10;
    bt_l1_22 = bt_l1_22 + (0.020303450524806976)*bt_g0_11;
    bt_l1_22 = bt_l1_22 + (0.092106632888317108)*bt_g0_12;
    bt_l1_22 = bt_l1_22 + (-0.11216393113136292)*bt_g0_13;
    bt_l1_22 = bt_l1_22 + (-0.12669853866100311)*bt_g0_14;
    bt_l1_22 = bt_l1_22 + (0.07203974574804306)*bt_g0_15;
    bt_l1_22 = bt_l1_22 + (-0.1189444363117218)*bt_g0_16;
    bt_l1_22 = bt_l1_22 + (-0.079713597893714905)*bt_g0_17;
    bt_l1_22 = bt_l1_22 + (-0.046344432979822159)*bt_g0_18;
    bt_l1_22 = bt_l1_22 + (0.041821062564849854)*bt_g0_19;
    bt_l1_22 = bt_l1_22 + (-0.16470102965831757)*bt_g0_20;
    bt_l1_22 = bt_l1_22 + (-0.014960820786654949)*bt_g0_21;
    bt_l1_22 = bt_l1_22 + (0.16350041329860687)*bt_g0_22;
    bt_l1_22 = bt_l1_22 + (0.027903215959668159)*bt_g0_23;
    bt_l1_22 = bt_l1_22 + (-0.18175576627254486)*bt_g0_24;
    bt_l1_22 = bt_l1_22 + (-0.12436750531196594)*bt_g0_25;
    bt_l1_22 = bt_l1_22 + (0.098523758351802826)*bt_g0_26;
    bt_l1_22 = bt_l1_22 + (-0.042790237814188004)*bt_g0_27;
    bt_l1_22 = bt_l1_22 + (-0.22783385217189789)*bt_g0_28;
    bt_l1_22 = bt_l1_22 + (0.18452192842960358)*bt_g0_29;
    bt_l1_22 = bt_l1_22 + (0.12672218680381775)*bt_g0_30;
    bt_l1_22 = bt_l1_22 + (-0.12007734924554825)*bt_g0_31;
    bt_l1_22 = bt_l1_22 + (0.13614533841609955)*bt_g0_32;
    bt_l1_22 = bt_l1_22 + (0.17105691134929657)*bt_g0_33;
    bt_l1_22 = bt_l1_22 + (0.061521459370851517)*bt_g0_34;
    bt_l1_22 = bt_l1_22 + (-0.11349063366651535)*bt_g0_35;
    bt_l1_22 = bt_l1_22 + (-0.21379721164703369)*bt_g0_36;
    bt_l1_22 = bt_l1_22 + (-0.11583161354064941)*bt_g0_37;
    bt_l1_22 = bt_l1_22 + (-0.28961640596389771)*bt_g0_38;
    bt_l1_22 = bt_l1_22 + (-0.25564602017402649)*bt_g0_39;
    bt_l1_22 = bt_l1_22 + (-0.020543506368994713)*bt_g0_40;
    bt_l1_22 = bt_l1_22 + (0.10550641268491745)*bt_g0_41;
    bt_l1_22 = bt_l1_22 + (0.032719280570745468)*bt_g0_42;
    bt_l1_22 = bt_l1_22 + (-0.031511470675468445)*bt_g0_43;
    bt_l1_22 = bt_l1_22 + (0.029823945835232735)*bt_g0_44;
    bt_l1_22 = bt_l1_22 + (0.19849398732185364)*bt_g0_45;
    bt_l1_22 = bt_l1_22 + (0.11853280663490295)*bt_g0_46;
    bt_l1_22 = bt_l1_22 + (-0.076814211905002594)*bt_g0_47;
    bt_l1_22 = bt_l1_22 + (0.22563830018043518)*bt_g0_48;
    bt_l1_22 = bt_l1_22 + (-0.15135560929775238)*bt_g0_49;
    bt_l1_22 = bt_l1_22 + (-0.15888959169387817)*bt_g0_50;
    bt_l1_22 = bt_l1_22 + (-0.046532168984413147)*bt_g0_51;
    bt_l1_22 = bt_l1_22 + (-0.085430033504962921)*bt_g0_52;
    bt_l1_22 = bt_l1_22 + (-0.0625029057264328)*bt_g0_53;
    bt_l1_22 = bt_l1_22 + (0.028968982398509979)*bt_g0_54;
    bt_l1_22 = bt_l1_22 + (0.16360218822956085)*bt_g0_55;
    bt_l1_22 = bt_l1_22 + (0.045582544058561325)*bt_g0_56;
    bt_l1_22 = bt_l1_22 + (-0.13850899040699005)*bt_g0_57;
    bt_l1_22 = bt_l1_22 + (-0.27724307775497437)*bt_g0_58;
    bt_l1_22 = bt_l1_22 + (0.18920798599720001)*bt_g0_59;
    bt_l1_22 = bt_l1_22 + (-0.0039899758994579315)*bt_g0_60;
    bt_l1_22 = bt_l1_22 + (-0.050601519644260406)*bt_g0_61;
    bt_l1_22 = bt_l1_22 + (-0.039734497666358948)*bt_g0_62;
    bt_l1_22 = bt_l1_22 + (-0.032419275492429733)*bt_g0_63;
    bt_l1_23 = 0.05428706482052803;
    bt_l1_23 = bt_l1_23 + (0.1481214165687561)*bt_g0_0;
    bt_l1_23 = bt_l1_23 + (0.078544281423091888)*bt_g0_1;
    bt_l1_23 = bt_l1_23 + (0.07887924462556839)*bt_g0_2;
    bt_l1_23 = bt_l1_23 + (0.030143056064844131)*bt_g0_3;
    bt_l1_23 = bt_l1_23 + (0.0016122120432555676)*bt_g0_4;
    bt_l1_23 = bt_l1_23 + (-0.10464917868375778)*bt_g0_5;
    bt_l1_23 = bt_l1_23 + (-0.10460740327835083)*bt_g0_6;
    bt_l1_23 = bt_l1_23 + (-0.1419203132390976)*bt_g0_7;
    bt_l1_23 = bt_l1_23 + (0.16875900328159332)*bt_g0_8;
    bt_l1_23 = bt_l1_23 + (0.052832931280136108)*bt_g0_9;
    bt_l1_23 = bt_l1_23 + (0.0044713173992931843)*bt_g0_10;
    bt_l1_23 = bt_l1_23 + (-0.043054636567831039)*bt_g0_11;
    bt_l1_23 = bt_l1_23 + (-0.11833060532808304)*bt_g0_12;
    bt_l1_23 = bt_l1_23 + (-0.10098423063755035)*bt_g0_13;
    bt_l1_23 = bt_l1_23 + (-0.084559090435504913)*bt_g0_14;
    bt_l1_23 = bt_l1_23 + (0.18749253451824188)*bt_g0_15;
    bt_l1_23 = bt_l1_23 + (-0.21499782800674438)*bt_g0_16;
    bt_l1_23 = bt_l1_23 + (0.0035396853927522898)*bt_g0_17;
    bt_l1_23 = bt_l1_23 + (0.0084215421229600906)*bt_g0_18;
    bt_l1_23 = bt_l1_23 + (-0.12624914944171906)*bt_g0_19;
    bt_l1_23 = bt_l1_23 + (0.11674999445676804)*bt_g0_20;
    bt_l1_23 = bt_l1_23 + (-0.074974671006202698)*bt_g0_21;
    bt_l1_23 = bt_l1_23 + (0.089524775743484497)*bt_g0_22;
    bt_l1_23 = bt_l1_23 + (-0.078578054904937744)*bt_g0_23;
    bt_l1_23 = bt_l1_23 + (-0.43287578225135803)*bt_g0_24;
    bt_l1_23 = bt_l1_23 + (-0.37941312789916992)*bt_g0_25;
    bt_l1_23 = bt_l1_23 + (0.021153697744011879)*bt_g0_26;
    bt_l1_23 = bt_l1_23 + (-0.18581102788448334)*bt_g0_27;
    bt_l1_23 = bt_l1_23 + (-0.18053255975246429)*bt_g0_28;
    bt_l1_23 = bt_l1_23 + (0.019803004339337349)*bt_g0_29;
    bt_l1_23 = bt_l1_23 + (-0.16835370659828186)*bt_g0_30;
    bt_l1_23 = bt_l1_23 + (-0.14789912104606628)*bt_g0_31;
    bt_l1_23 = bt_l1_23 + (-0.45633396506309509)*bt_g0_32;
    bt_l1_23 = bt_l1_23 + (0.083334177732467651)*bt_g0_33;
    bt_l1_23 = bt_l1_23 + (-0.14634960889816284)*bt_g0_34;
    bt_l1_23 = bt_l1_23 + (0.011560040526092052)*bt_g0_35;
    bt_l1_23 = bt_l1_23 + (0.28744828701019287)*bt_g0_36;
    bt_l1_23 = bt_l1_23 + (-0.070955291390419006)*bt_g0_37;
    bt_l1_23 = bt_l1_23 + (-0.12159571796655655)*bt_g0_38;
    bt_l1_23 = bt_l1_23 + (0.097522251307964325)*bt_g0_39;
    bt_l1_23 = bt_l1_23 + (-0.076433852314949036)*bt_g0_40;
    bt_l1_23 = bt_l1_23 + (-0.10667406022548676)*bt_g0_41;
    bt_l1_23 = bt_l1_23 + (0.01540144719183445)*bt_g0_42;
    bt_l1_23 = bt_l1_23 + (-0.021604549139738083)*bt_g0_43;
    bt_l1_23 = bt_l1_23 + (-0.32373815774917603)*bt_g0_44;
    bt_l1_23 = bt_l1_23 + (-0.075216494500637054)*bt_g0_45;
    bt_l1_23 = bt_l1_23 + (-0.127211794257164)*bt_g0_46;
    bt_l1_23 = bt_l1_23 + (0.14850097894668579)*bt_g0_47;
    bt_l1_23 = bt_l1_23 + (-0.088599510490894318)*bt_g0_48;
    bt_l1_23 = bt_l1_23 + (0.18681329488754272)*bt_g0_49;
    bt_l1_23 = bt_l1_23 + (-0.43554943799972534)*bt_g0_50;
    bt_l1_23 = bt_l1_23 + (-0.13802824914455414)*bt_g0_51;
    bt_l1_23 = bt_l1_23 + (-0.19257818162441254)*bt_g0_52;
    bt_l1_23 = bt_l1_23 + (-0.12751904129981995)*bt_g0_53;
    bt_l1_23 = bt_l1_23 + (0.048044934868812561)*bt_g0_54;
    bt_l1_23 = bt_l1_23 + (-0.084705539047718048)*bt_g0_55;
    bt_l1_23 = bt_l1_23 + (-0.070130676031112671)*bt_g0_56;
    bt_l1_23 = bt_l1_23 + (0.15873849391937256)*bt_g0_57;
    bt_l1_23 = bt_l1_23 + (0.18051689863204956)*bt_g0_58;
    bt_l1_23 = bt_l1_23 + (0.13340072333812714)*bt_g0_59;
    bt_l1_23 = bt_l1_23 + (-0.088397100567817688)*bt_g0_60;
    bt_l1_23 = bt_l1_23 + (0.14250756800174713)*bt_g0_61;
    bt_l1_23 = bt_l1_23 + (0.27435413002967834)*bt_g0_62;
    bt_l1_23 = bt_l1_23 + (-0.13931098580360413)*bt_g0_63;
    bt_l1_24 = -0.016583770513534546;
    bt_l1_24 = bt_l1_24 + (-0.067797094583511353)*bt_g0_0;
    bt_l1_24 = bt_l1_24 + (-0.037190794944763184)*bt_g0_1;
    bt_l1_24 = bt_l1_24 + (-0.065305784344673157)*bt_g0_2;
    bt_l1_24 = bt_l1_24 + (0.081461004912853241)*bt_g0_3;
    bt_l1_24 = bt_l1_24 + (-0.021892856806516647)*bt_g0_4;
    bt_l1_24 = bt_l1_24 + (-0.21352668106555939)*bt_g0_5;
    bt_l1_24 = bt_l1_24 + (0.074549302458763123)*bt_g0_6;
    bt_l1_24 = bt_l1_24 + (0.013130382634699345)*bt_g0_7;
    bt_l1_24 = bt_l1_24 + (0.079658962786197662)*bt_g0_8;
    bt_l1_24 = bt_l1_24 + (0.038065638393163681)*bt_g0_9;
    bt_l1_24 = bt_l1_24 + (-0.15640009939670563)*bt_g0_10;
    bt_l1_24 = bt_l1_24 + (-0.1373622864484787)*bt_g0_11;
    bt_l1_24 = bt_l1_24 + (-0.15583330392837524)*bt_g0_12;
    bt_l1_24 = bt_l1_24 + (0.0024147359654307365)*bt_g0_13;
    bt_l1_24 = bt_l1_24 + (0.078387580811977386)*bt_g0_14;
    bt_l1_24 = bt_l1_24 + (-0.0342584028840065)*bt_g0_15;
    bt_l1_24 = bt_l1_24 + (-0.08418688178062439)*bt_g0_16;
    bt_l1_24 = bt_l1_24 + (-0.037123411893844604)*bt_g0_17;
    bt_l1_24 = bt_l1_24 + (-0.04466797411441803)*bt_g0_18;
    bt_l1_24 = bt_l1_24 + (0.11185032874345779)*bt_g0_19;
    bt_l1_24 = bt_l1_24 + (0.18875448405742645)*bt_g0_20;
    bt_l1_24 = bt_l1_24 + (0.0066168871708214283)*bt_g0_21;
    bt_l1_24 = bt_l1_24 + (-0.04843645915389061)*bt_g0_22;
    bt_l1_24 = bt_l1_24 + (-0.077041812241077423)*bt_g0_23;
    bt_l1_24 = bt_l1_24 + (-0.038980681449174881)*bt_g0_24;
    bt_l1_24 = bt_l1_24 + (-0.1052057072520256)*bt_g0_25;
    bt_l1_24 = bt_l1_24 + (0.076656460762023926)*bt_g0_26;
    bt_l1_24 = bt_l1_24 + (0.044946756213903427)*bt_g0_27;
    bt_l1_24 = bt_l1_24 + (0.15902337431907654)*bt_g0_28;
    bt_l1_24 = bt_l1_24 + (-0.091682538390159607)*bt_g0_29;
    bt_l1_24 = bt_l1_24 + (0.083607867360115051)*bt_g0_30;
    bt_l1_24 = bt_l1_24 + (0.039617698639631271)*bt_g0_31;
    bt_l1_24 = bt_l1_24 + (0.096330612897872925)*bt_g0_32;
    bt_l1_24 = bt_l1_24 + (0.067815966904163361)*bt_g0_33;
    bt_l1_24 = bt_l1_24 + (-0.071805365383625031)*bt_g0_34;
    bt_l1_24 = bt_l1_24 + (-0.0043006446212530136)*bt_g0_35;
    bt_l1_24 = bt_l1_24 + (0.2960306704044342)*bt_g0_36;
    bt_l1_24 = bt_l1_24 + (-0.012145237997174263)*bt_g0_37;
    bt_l1_24 = bt_l1_24 + (0.039058193564414978)*bt_g0_38;
    bt_l1_24 = bt_l1_24 + (0.12303677201271057)*bt_g0_39;
    bt_l1_24 = bt_l1_24 + (-0.053976550698280334)*bt_g0_40;
    bt_l1_24 = bt_l1_24 + (-0.095223888754844666)*bt_g0_41;
    bt_l1_24 = bt_l1_24 + (0.014934130012989044)*bt_g0_42;
    bt_l1_24 = bt_l1_24 + (0.10512109100818634)*bt_g0_43;
    bt_l1_24 = bt_l1_24 + (-0.10221165418624878)*bt_g0_44;
    bt_l1_24 = bt_l1_24 + (0.01213183905929327)*bt_g0_45;
    bt_l1_24 = bt_l1_24 + (0.041519448161125183)*bt_g0_46;
    bt_l1_24 = bt_l1_24 + (0.051951192319393158)*bt_g0_47;
    bt_l1_24 = bt_l1_24 + (-0.064489349722862244)*bt_g0_48;
    bt_l1_24 = bt_l1_24 + (0.13986136019229889)*bt_g0_49;
    bt_l1_24 = bt_l1_24 + (-0.09561648964881897)*bt_g0_50;
    bt_l1_24 = bt_l1_24 + (-0.15890270471572876)*bt_g0_51;
    bt_l1_24 = bt_l1_24 + (-0.011161777190864086)*bt_g0_52;
    bt_l1_24 = bt_l1_24 + (-0.046819821000099182)*bt_g0_53;
    bt_l1_24 = bt_l1_24 + (0.148959681391716)*bt_g0_54;
    bt_l1_24 = bt_l1_24 + (0.014755849726498127)*bt_g0_55;
    bt_l1_24 = bt_l1_24 + (0.011427303776144981)*bt_g0_56;
    bt_l1_24 = bt_l1_24 + (0.06098160520195961)*bt_g0_57;
    bt_l1_24 = bt_l1_24 + (0.084024637937545776)*bt_g0_58;
    bt_l1_24 = bt_l1_24 + (-0.028248291462659836)*bt_g0_59;
    bt_l1_24 = bt_l1_24 + (-0.13911862671375275)*bt_g0_60;
    bt_l1_24 = bt_l1_24 + (0.1664716899394989)*bt_g0_61;
    bt_l1_24 = bt_l1_24 + (0.15154074132442474)*bt_g0_62;
    bt_l1_24 = bt_l1_24 + (-0.15796875953674316)*bt_g0_63;
    bt_l1_25 = -0.0614202581346035;
    bt_l1_25 = bt_l1_25 + (0.027366187423467636)*bt_g0_0;
    bt_l1_25 = bt_l1_25 + (-0.23184593021869659)*bt_g0_1;
    bt_l1_25 = bt_l1_25 + (0.22716973721981049)*bt_g0_2;
    bt_l1_25 = bt_l1_25 + (-0.057128649204969406)*bt_g0_3;
    bt_l1_25 = bt_l1_25 + (-0.064565792679786682)*bt_g0_4;
    bt_l1_25 = bt_l1_25 + (0.20794600248336792)*bt_g0_5;
    bt_l1_25 = bt_l1_25 + (-0.014055429026484489)*bt_g0_6;
    bt_l1_25 = bt_l1_25 + (-0.039595313370227814)*bt_g0_7;
    bt_l1_25 = bt_l1_25 + (0.14512963593006134)*bt_g0_8;
    bt_l1_25 = bt_l1_25 + (0.09117581695318222)*bt_g0_9;
    bt_l1_25 = bt_l1_25 + (-0.012203813530504704)*bt_g0_10;
    bt_l1_25 = bt_l1_25 + (-0.12897898256778717)*bt_g0_11;
    bt_l1_25 = bt_l1_25 + (0.28019383549690247)*bt_g0_12;
    bt_l1_25 = bt_l1_25 + (0.044047612696886063)*bt_g0_13;
    bt_l1_25 = bt_l1_25 + (0.26195958256721497)*bt_g0_14;
    bt_l1_25 = bt_l1_25 + (0.32162982225418091)*bt_g0_15;
    bt_l1_25 = bt_l1_25 + (0.2739487886428833)*bt_g0_16;
    bt_l1_25 = bt_l1_25 + (0.13627423346042633)*bt_g0_17;
    bt_l1_25 = bt_l1_25 + (-0.15240626037120819)*bt_g0_18;
    bt_l1_25 = bt_l1_25 + (-0.043317858129739761)*bt_g0_19;
    bt_l1_25 = bt_l1_25 + (0.085460558533668518)*bt_g0_20;
    bt_l1_25 = bt_l1_25 + (-0.092794835567474365)*bt_g0_21;
    bt_l1_25 = bt_l1_25 + (-0.21363762021064758)*bt_g0_22;
    bt_l1_25 = bt_l1_25 + (0.32729056477546692)*bt_g0_23;
    bt_l1_25 = bt_l1_25 + (0.3504960834980011)*bt_g0_24;
    bt_l1_25 = bt_l1_25 + (0.067445032298564911)*bt_g0_25;
    bt_l1_25 = bt_l1_25 + (-0.14242909848690033)*bt_g0_26;
    bt_l1_25 = bt_l1_25 + (-0.17901092767715454)*bt_g0_27;
    bt_l1_25 = bt_l1_25 + (0.2006000429391861)*bt_g0_28;
    bt_l1_25 = bt_l1_25 + (0.063999287784099579)*bt_g0_29;
    bt_l1_25 = bt_l1_25 + (-0.14291723072528839)*bt_g0_30;
    bt_l1_25 = bt_l1_25 + (0.015931103378534317)*bt_g0_31;
    bt_l1_25 = bt_l1_25 + (-0.045548871159553528)*bt_g0_32;
    bt_l1_25 = bt_l1_25 + (-0.10041416436433792)*bt_g0_33;
    bt_l1_25 = bt_l1_25 + (-0.12253507971763611)*bt_g0_34;
    bt_l1_25 = bt_l1_25 + (0.18106465041637421)*bt_g0_35;
    bt_l1_25 = bt_l1_25 + (0.36358961462974548)*bt_g0_36;
    bt_l1_25 = bt_l1_25 + (0.24086064100265503)*bt_g0_37;
    bt_l1_25 = bt_l1_25 + (0.31967738270759583)*bt_g0_38;
    bt_l1_25 = bt_l1_25 + (0.014660353772342205)*bt_g0_39;
    bt_l1_25 = bt_l1_25 + (-0.079079464077949524)*bt_g0_40;
    bt_l1_25 = bt_l1_25 + (-0.1014157310128212)*bt_g0_41;
    bt_l1_25 = bt_l1_25 + (0.079713031649589539)*bt_g0_42;
    bt_l1_25 = bt_l1_25 + (0.013799780048429966)*bt_g0_43;
    bt_l1_25 = bt_l1_25 + (0.15277336537837982)*bt_g0_44;
    bt_l1_25 = bt_l1_25 + (-0.25858584046363831)*bt_g0_45;
    bt_l1_25 = bt_l1_25 + (-0.11422087997198105)*bt_g0_46;
    bt_l1_25 = bt_l1_25 + (-0.083005368709564209)*bt_g0_47;
    bt_l1_25 = bt_l1_25 + (-0.13552115857601166)*bt_g0_48;
    bt_l1_25 = bt_l1_25 + (0.11651092022657394)*bt_g0_49;
    bt_l1_25 = bt_l1_25 + (0.035579442977905273)*bt_g0_50;
    bt_l1_25 = bt_l1_25 + (0.16017940640449524)*bt_g0_51;
    bt_l1_25 = bt_l1_25 + (0.23459258675575256)*bt_g0_52;
    bt_l1_25 = bt_l1_25 + (-0.012041704729199409)*bt_g0_53;
    bt_l1_25 = bt_l1_25 + (0.028709808364510536)*bt_g0_54;
    bt_l1_25 = bt_l1_25 + (0.069155536592006683)*bt_g0_55;
    bt_l1_25 = bt_l1_25 + (0.047040298581123352)*bt_g0_56;
    bt_l1_25 = bt_l1_25 + (0.24074250459671021)*bt_g0_57;
    bt_l1_25 = bt_l1_25 + (0.16577638685703278)*bt_g0_58;
    bt_l1_25 = bt_l1_25 + (-0.018884595483541489)*bt_g0_59;
    bt_l1_25 = bt_l1_25 + (-0.2386782318353653)*bt_g0_60;
    bt_l1_25 = bt_l1_25 + (0.075418286025524139)*bt_g0_61;
    bt_l1_25 = bt_l1_25 + (0.34167248010635376)*bt_g0_62;
    bt_l1_25 = bt_l1_25 + (0.21211346983909607)*bt_g0_63;
    bt_l1_26 = 0.074751831591129303;
    bt_l1_26 = bt_l1_26 + (0.032902069389820099)*bt_g0_0;
    bt_l1_26 = bt_l1_26 + (0.17053595185279846)*bt_g0_1;
    bt_l1_26 = bt_l1_26 + (-0.098971068859100342)*bt_g0_2;
    bt_l1_26 = bt_l1_26 + (0.14753374457359314)*bt_g0_3;
    bt_l1_26 = bt_l1_26 + (0.13828012347221375)*bt_g0_4;
    bt_l1_26 = bt_l1_26 + (-0.0067934165708720684)*bt_g0_5;
    bt_l1_26 = bt_l1_26 + (0.1648535430431366)*bt_g0_6;
    bt_l1_26 = bt_l1_26 + (0.056270934641361237)*bt_g0_7;
    bt_l1_26 = bt_l1_26 + (-0.050628840923309326)*bt_g0_8;
    bt_l1_26 = bt_l1_26 + (0.073674142360687256)*bt_g0_9;
    bt_l1_26 = bt_l1_26 + (0.0078201713040471077)*bt_g0_10;
    bt_l1_26 = bt_l1_26 + (0.10691598057746887)*bt_g0_11;
    bt_l1_26 = bt_l1_26 + (-0.11766909062862396)*bt_g0_12;
    bt_l1_26 = bt_l1_26 + (-0.10168683528900146)*bt_g0_13;
    bt_l1_26 = bt_l1_26 + (0.0057458626106381416)*bt_g0_14;
    bt_l1_26 = bt_l1_26 + (-0.16902172565460205)*bt_g0_15;
    bt_l1_26 = bt_l1_26 + (0.012331176549196243)*bt_g0_16;
    bt_l1_26 = bt_l1_26 + (-0.06179334968328476)*bt_g0_17;
    bt_l1_26 = bt_l1_26 + (-0.064359068870544434)*bt_g0_18;
    bt_l1_26 = bt_l1_26 + (0.10252939164638519)*bt_g0_19;
    bt_l1_26 = bt_l1_26 + (0.13172721862792969)*bt_g0_20;
    bt_l1_26 = bt_l1_26 + (0.14643818140029907)*bt_g0_21;
    bt_l1_26 = bt_l1_26 + (0.18696630001068115)*bt_g0_22;
    bt_l1_26 = bt_l1_26 + (0.13254286348819733)*bt_g0_23;
    bt_l1_26 = bt_l1_26 + (-0.0069229160435497761)*bt_g0_24;
    bt_l1_26 = bt_l1_26 + (-0.066385656595230103)*bt_g0_25;
    bt_l1_26 = bt_l1_26 + (-0.082077689468860626)*bt_g0_26;
    bt_l1_26 = bt_l1_26 + (-0.018238846212625504)*bt_g0_27;
    bt_l1_26 = bt_l1_26 + (-0.14040634036064148)*bt_g0_28;
    bt_l1_26 = bt_l1_26 + (-0.087916240096092224)*bt_g0_29;
    bt_l1_26 = bt_l1_26 + (-0.052191279828548431)*bt_g0_30;
    bt_l1_26 = bt_l1_26 + (0.076461687684059143)*bt_g0_31;
    bt_l1_26 = bt_l1_26 + (0.23522494733333588)*bt_g0_32;
    bt_l1_26 = bt_l1_26 + (0.099927470088005066)*bt_g0_33;
    bt_l1_26 = bt_l1_26 + (-0.0022693122737109661)*bt_g0_34;
    bt_l1_26 = bt_l1_26 + (-0.054098278284072876)*bt_g0_35;
    bt_l1_26 = bt_l1_26 + (-0.1141526997089386)*bt_g0_36;
    bt_l1_26 = bt_l1_26 + (-0.07458033412694931)*bt_g0_37;
    bt_l1_26 = bt_l1_26 + (-0.017827043309807777)*bt_g0_38;
    bt_l1_26 = bt_l1_26 + (-0.05402698740363121)*bt_g0_39;
    bt_l1_26 = bt_l1_26 + (-0.0087342336773872375)*bt_g0_40;
    bt_l1_26 = bt_l1_26 + (-0.13234412670135498)*bt_g0_41;
    bt_l1_26 = bt_l1_26 + (-0.0057298247702419758)*bt_g0_42;
    bt_l1_26 = bt_l1_26 + (-0.055749289691448212)*bt_g0_43;
    bt_l1_26 = bt_l1_26 + (0.024665189906954765)*bt_g0_44;
    bt_l1_26 = bt_l1_26 + (-0.049611471593379974)*bt_g0_45;
    bt_l1_26 = bt_l1_26 + (-0.04753933846950531)*bt_g0_46;
    bt_l1_26 = bt_l1_26 + (0.018001902848482132)*bt_g0_47;
    bt_l1_26 = bt_l1_26 + (0.0029936276841908693)*bt_g0_48;
    bt_l1_26 = bt_l1_26 + (-0.18671137094497681)*bt_g0_49;
    bt_l1_26 = bt_l1_26 + (-0.061696272343397141)*bt_g0_50;
    bt_l1_26 = bt_l1_26 + (-0.069986112415790558)*bt_g0_51;
    bt_l1_26 = bt_l1_26 + (-0.055177360773086548)*bt_g0_52;
    bt_l1_26 = bt_l1_26 + (0.093308299779891968)*bt_g0_53;
    bt_l1_26 = bt_l1_26 + (0.2022244781255722)*bt_g0_54;
    bt_l1_26 = bt_l1_26 + (-0.1306188553571701)*bt_g0_55;
    bt_l1_26 = bt_l1_26 + (0.0048324554227292538)*bt_g0_56;
    bt_l1_26 = bt_l1_26 + (0.031762614846229553)*bt_g0_57;
    bt_l1_26 = bt_l1_26 + (-0.13681970536708832)*bt_g0_58;
    bt_l1_26 = bt_l1_26 + (0.031447019428014755)*bt_g0_59;
    bt_l1_26 = bt_l1_26 + (-0.1023847833275795)*bt_g0_60;
    bt_l1_26 = bt_l1_26 + (-0.032764185220003128)*bt_g0_61;
    bt_l1_26 = bt_l1_26 + (-0.13792231678962708)*bt_g0_62;
    bt_l1_26 = bt_l1_26 + (-0.06278190016746521)*bt_g0_63;
    bt_l1_27 = 0.14089541137218475;
    bt_l1_27 = bt_l1_27 + (-0.082120515406131744)*bt_g0_0;
    bt_l1_27 = bt_l1_27 + (-0.10367125272750854)*bt_g0_1;
    bt_l1_27 = bt_l1_27 + (-0.048166122287511826)*bt_g0_2;
    bt_l1_27 = bt_l1_27 + (0.0020790600683540106)*bt_g0_3;
    bt_l1_27 = bt_l1_27 + (-0.15194474160671234)*bt_g0_4;
    bt_l1_27 = bt_l1_27 + (-0.075554423034191132)*bt_g0_5;
    bt_l1_27 = bt_l1_27 + (-0.016967421397566795)*bt_g0_6;
    bt_l1_27 = bt_l1_27 + (-0.10055862367153168)*bt_g0_7;
    bt_l1_27 = bt_l1_27 + (0.24476300179958344)*bt_g0_8;
    bt_l1_27 = bt_l1_27 + (-0.049765542149543762)*bt_g0_9;
    bt_l1_27 = bt_l1_27 + (0.04429091140627861)*bt_g0_10;
    bt_l1_27 = bt_l1_27 + (-0.18919387459754944)*bt_g0_11;
    bt_l1_27 = bt_l1_27 + (0.012527028098702431)*bt_g0_12;
    bt_l1_27 = bt_l1_27 + (-0.037683967500925064)*bt_g0_13;
    bt_l1_27 = bt_l1_27 + (-0.017838509753346443)*bt_g0_14;
    bt_l1_27 = bt_l1_27 + (-0.11507683992385864)*bt_g0_15;
    bt_l1_27 = bt_l1_27 + (-0.14253152906894684)*bt_g0_16;
    bt_l1_27 = bt_l1_27 + (-0.044299885630607605)*bt_g0_17;
    bt_l1_27 = bt_l1_27 + (0.060639318078756332)*bt_g0_18;
    bt_l1_27 = bt_l1_27 + (0.020391279831528664)*bt_g0_19;
    bt_l1_27 = bt_l1_27 + (0.15112586319446564)*bt_g0_20;
    bt_l1_27 = bt_l1_27 + (0.014270319603383541)*bt_g0_21;
    bt_l1_27 = bt_l1_27 + (-0.019456809386610985)*bt_g0_22;
    bt_l1_27 = bt_l1_27 + (0.023231847211718559)*bt_g0_23;
    bt_l1_27 = bt_l1_27 + (-0.0040185502730309963)*bt_g0_24;
    bt_l1_27 = bt_l1_27 + (0.097668260335922241)*bt_g0_25;
    bt_l1_27 = bt_l1_27 + (0.16475382447242737)*bt_g0_26;
    bt_l1_27 = bt_l1_27 + (-0.10488481074571609)*bt_g0_27;
    bt_l1_27 = bt_l1_27 + (0.32432237267494202)*bt_g0_28;
    bt_l1_27 = bt_l1_27 + (-0.06739535927772522)*bt_g0_29;
    bt_l1_27 = bt_l1_27 + (0.016790404915809631)*bt_g0_30;
    bt_l1_27 = bt_l1_27 + (-0.074971228837966919)*bt_g0_31;
    bt_l1_27 = bt_l1_27 + (-0.11387723684310913)*bt_g0_32;
    bt_l1_27 = bt_l1_27 + (0.05221523717045784)*bt_g0_33;
    bt_l1_27 = bt_l1_27 + (0.0020277623552829027)*bt_g0_34;
    bt_l1_27 = bt_l1_27 + (0.14311312139034271)*bt_g0_35;
    bt_l1_27 = bt_l1_27 + (0.16907970607280731)*bt_g0_36;
    bt_l1_27 = bt_l1_27 + (0.24280820786952972)*bt_g0_37;
    bt_l1_27 = bt_l1_27 + (-0.017387770116329193)*bt_g0_38;
    bt_l1_27 = bt_l1_27 + (0.15292516350746155)*bt_g0_39;
    bt_l1_27 = bt_l1_27 + (0.039516858756542206)*bt_g0_40;
    bt_l1_27 = bt_l1_27 + (-0.14143939316272736)*bt_g0_41;
    bt_l1_27 = bt_l1_27 + (0.12679773569107056)*bt_g0_42;
    bt_l1_27 = bt_l1_27 + (-0.091866880655288696)*bt_g0_43;
    bt_l1_27 = bt_l1_27 + (-0.010285551659762859)*bt_g0_44;
    bt_l1_27 = bt_l1_27 + (-0.095370247960090637)*bt_g0_45;
    bt_l1_27 = bt_l1_27 + (-0.042163196951150894)*bt_g0_46;
    bt_l1_27 = bt_l1_27 + (-0.093214578926563263)*bt_g0_47;
    bt_l1_27 = bt_l1_27 + (0.034174542874097824)*bt_g0_48;
    bt_l1_27 = bt_l1_27 + (0.22060154378414154)*bt_g0_49;
    bt_l1_27 = bt_l1_27 + (-0.034641005098819733)*bt_g0_50;
    bt_l1_27 = bt_l1_27 + (-0.12919965386390686)*bt_g0_51;
    bt_l1_27 = bt_l1_27 + (0.045532803982496262)*bt_g0_52;
    bt_l1_27 = bt_l1_27 + (-0.010547914542257786)*bt_g0_53;
    bt_l1_27 = bt_l1_27 + (0.017750786617398262)*bt_g0_54;
    bt_l1_27 = bt_l1_27 + (-0.062998339533805847)*bt_g0_55;
    bt_l1_27 = bt_l1_27 + (0.11553359776735306)*bt_g0_56;
    bt_l1_27 = bt_l1_27 + (-0.1389196515083313)*bt_g0_57;
    bt_l1_27 = bt_l1_27 + (0.24621133506298065)*bt_g0_58;
    bt_l1_27 = bt_l1_27 + (0.14260539412498474)*bt_g0_59;
    bt_l1_27 = bt_l1_27 + (0.05478857085108757)*bt_g0_60;
    bt_l1_27 = bt_l1_27 + (0.19815047085285187)*bt_g0_61;
    bt_l1_27 = bt_l1_27 + (0.041784957051277161)*bt_g0_62;
    bt_l1_27 = bt_l1_27 + (0.0064029316417872906)*bt_g0_63;
    bt_l1_28 = 0.039104238152503967;
    bt_l1_28 = bt_l1_28 + (-0.056234456598758698)*bt_g0_0;
    bt_l1_28 = bt_l1_28 + (-0.0029402470681816339)*bt_g0_1;
    bt_l1_28 = bt_l1_28 + (-0.001984539907425642)*bt_g0_2;
    bt_l1_28 = bt_l1_28 + (0.17695197463035583)*bt_g0_3;
    bt_l1_28 = bt_l1_28 + (0.064361244440078735)*bt_g0_4;
    bt_l1_28 = bt_l1_28 + (-0.32263025641441345)*bt_g0_5;
    bt_l1_28 = bt_l1_28 + (0.13417449593544006)*bt_g0_6;
    bt_l1_28 = bt_l1_28 + (-0.072810746729373932)*bt_g0_7;
    bt_l1_28 = bt_l1_28 + (-0.051244556903839111)*bt_g0_8;
    bt_l1_28 = bt_l1_28 + (-0.067215874791145325)*bt_g0_9;
    bt_l1_28 = bt_l1_28 + (0.045395128428936005)*bt_g0_10;
    bt_l1_28 = bt_l1_28 + (0.13225428760051727)*bt_g0_11;
    bt_l1_28 = bt_l1_28 + (-0.11337500810623169)*bt_g0_12;
    bt_l1_28 = bt_l1_28 + (-0.072137035429477692)*bt_g0_13;
    bt_l1_28 = bt_l1_28 + (0.086491644382476807)*bt_g0_14;
    bt_l1_28 = bt_l1_28 + (-0.11171160638332367)*bt_g0_15;
    bt_l1_28 = bt_l1_28 + (-0.18674136698246002)*bt_g0_16;
    bt_l1_28 = bt_l1_28 + (-0.093615449965000153)*bt_g0_17;
    bt_l1_28 = bt_l1_28 + (0.049547880887985229)*bt_g0_18;
    bt_l1_28 = bt_l1_28 + (-0.059793412685394287)*bt_g0_19;
    bt_l1_28 = bt_l1_28 + (0.25600349903106689)*bt_g0_20;
    bt_l1_28 = bt_l1_28 + (0.16453510522842407)*bt_g0_21;
    bt_l1_28 = bt_l1_28 + (-0.024843169376254082)*bt_g0_22;
    bt_l1_28 = bt_l1_28 + (0.2200578898191452)*bt_g0_23;
    bt_l1_28 = bt_l1_28 + (0.015698220580816269)*bt_g0_24;
    bt_l1_28 = bt_l1_28 + (0.15247732400894165)*bt_g0_25;
    bt_l1_28 = bt_l1_28 + (-0.061736304312944412)*bt_g0_26;
    bt_l1_28 = bt_l1_28 + (-0.18389043211936951)*bt_g0_27;
    bt_l1_28 = bt_l1_28 + (0.10283711552619934)*bt_g0_28;
    bt_l1_28 = bt_l1_28 + (-0.12595559656620026)*bt_g0_29;
    bt_l1_28 = bt_l1_28 + (-0.020646132528781891)*bt_g0_30;
    bt_l1_28 = bt_l1_28 + (-0.057536382228136063)*bt_g0_31;
    bt_l1_28 = bt_l1_28 + (-0.083807818591594696)*bt_g0_32;
    bt_l1_28 = bt_l1_28 + (0.097333982586860657)*bt_g0_33;
    bt_l1_28 = bt_l1_28 + (-0.0047853230498731136)*bt_g0_34;
    bt_l1_28 = bt_l1_28 + (0.14375355839729309)*bt_g0_35;
    bt_l1_28 = bt_l1_28 + (0.039538603276014328)*bt_g0_36;
    bt_l1_28 = bt_l1_28 + (-0.11251452565193176)*bt_g0_37;
    bt_l1_28 = bt_l1_28 + (-0.21243429183959961)*bt_g0_38;
    bt_l1_28 = bt_l1_28 + (0.26992619037628174)*bt_g0_39;
    bt_l1_28 = bt_l1_28 + (0.032155163586139679)*bt_g0_40;
    bt_l1_28 = bt_l1_28 + (-0.11674866080284119)*bt_g0_41;
    bt_l1_28 = bt_l1_28 + (0.14223223924636841)*bt_g0_42;
    bt_l1_28 = bt_l1_28 + (-0.16584610939025879)*bt_g0_43;
    bt_l1_28 = bt_l1_28 + (-0.11651027947664261)*bt_g0_44;
    bt_l1_28 = bt_l1_28 + (0.09472203254699707)*bt_g0_45;
    bt_l1_28 = bt_l1_28 + (0.028269829228520393)*bt_g0_46;
    bt_l1_28 = bt_l1_28 + (-0.14273658394813538)*bt_g0_47;
    bt_l1_28 = bt_l1_28 + (-0.098625652492046356)*bt_g0_48;
    bt_l1_28 = bt_l1_28 + (0.22165547311306)*bt_g0_49;
    bt_l1_28 = bt_l1_28 + (-0.045026514679193497)*bt_g0_50;
    bt_l1_28 = bt_l1_28 + (-0.13178116083145142)*bt_g0_51;
    bt_l1_28 = bt_l1_28 + (-0.18721483647823334)*bt_g0_52;
    bt_l1_28 = bt_l1_28 + (-0.0019514909945428371)*bt_g0_53;
    bt_l1_28 = bt_l1_28 + (0.13798651099205017)*bt_g0_54;
    bt_l1_28 = bt_l1_28 + (-0.13538353145122528)*bt_g0_55;
    bt_l1_28 = bt_l1_28 + (0.14518938958644867)*bt_g0_56;
    bt_l1_28 = bt_l1_28 + (0.055297825485467911)*bt_g0_57;
    bt_l1_28 = bt_l1_28 + (-0.19490568339824677)*bt_g0_58;
    bt_l1_28 = bt_l1_28 + (-0.022871822118759155)*bt_g0_59;
    bt_l1_28 = bt_l1_28 + (0.11179547756910324)*bt_g0_60;
    bt_l1_28 = bt_l1_28 + (0.11468672007322311)*bt_g0_61;
    bt_l1_28 = bt_l1_28 + (0.15871728956699371)*bt_g0_62;
    bt_l1_28 = bt_l1_28 + (-0.0045818723738193512)*bt_g0_63;
    bt_l1_29 = -0.089988067746162415;
    bt_l1_29 = bt_l1_29 + (-0.011474038474261761)*bt_g0_0;
    bt_l1_29 = bt_l1_29 + (-0.06416737288236618)*bt_g0_1;
    bt_l1_29 = bt_l1_29 + (-0.10420174896717072)*bt_g0_2;
    bt_l1_29 = bt_l1_29 + (-0.041861843317747116)*bt_g0_3;
    bt_l1_29 = bt_l1_29 + (-0.037518534809350967)*bt_g0_4;
    bt_l1_29 = bt_l1_29 + (-0.36693888902664185)*bt_g0_5;
    bt_l1_29 = bt_l1_29 + (-0.041149593889713287)*bt_g0_6;
    bt_l1_29 = bt_l1_29 + (-0.022191910073161125)*bt_g0_7;
    bt_l1_29 = bt_l1_29 + (-0.14643265306949615)*bt_g0_8;
    bt_l1_29 = bt_l1_29 + (0.10887116938829422)*bt_g0_9;
    bt_l1_29 = bt_l1_29 + (-0.10102623701095581)*bt_g0_10;
    bt_l1_29 = bt_l1_29 + (0.13916496932506561)*bt_g0_11;
    bt_l1_29 = bt_l1_29 + (-0.07931295782327652)*bt_g0_12;
    bt_l1_29 = bt_l1_29 + (0.029716802760958672)*bt_g0_13;
    bt_l1_29 = bt_l1_29 + (-0.11169782280921936)*bt_g0_14;
    bt_l1_29 = bt_l1_29 + (-0.082257196307182312)*bt_g0_15;
    bt_l1_29 = bt_l1_29 + (-0.22041401267051697)*bt_g0_16;
    bt_l1_29 = bt_l1_29 + (-0.027794253081083298)*bt_g0_17;
    bt_l1_29 = bt_l1_29 + (0.13262525200843811)*bt_g0_18;
    bt_l1_29 = bt_l1_29 + (0.067961320281028748)*bt_g0_19;
    bt_l1_29 = bt_l1_29 + (0.039300370961427689)*bt_g0_20;
    bt_l1_29 = bt_l1_29 + (-0.013447442092001438)*bt_g0_21;
    bt_l1_29 = bt_l1_29 + (-0.053948771208524704)*bt_g0_22;
    bt_l1_29 = bt_l1_29 + (0.14586889743804932)*bt_g0_23;
    bt_l1_29 = bt_l1_29 + (0.17473189532756805)*bt_g0_24;
    bt_l1_29 = bt_l1_29 + (-0.093983285129070282)*bt_g0_25;
    bt_l1_29 = bt_l1_29 + (0.031487293541431427)*bt_g0_26;
    bt_l1_29 = bt_l1_29 + (-0.16722406446933746)*bt_g0_27;
    bt_l1_29 = bt_l1_29 + (0.053248919546604156)*bt_g0_28;
    bt_l1_29 = bt_l1_29 + (-0.06216127797961235)*bt_g0_29;
    bt_l1_29 = bt_l1_29 + (0.013325285166501999)*bt_g0_30;
    bt_l1_29 = bt_l1_29 + (0.1783905029296875)*bt_g0_31;
    bt_l1_29 = bt_l1_29 + (-0.19794712960720062)*bt_g0_32;
    bt_l1_29 = bt_l1_29 + (-0.00010933709563687444)*bt_g0_33;
    bt_l1_29 = bt_l1_29 + (-0.028234193101525307)*bt_g0_34;
    bt_l1_29 = bt_l1_29 + (0.075979292392730713)*bt_g0_35;
    bt_l1_29 = bt_l1_29 + (0.015613873489201069)*bt_g0_36;
    bt_l1_29 = bt_l1_29 + (0.14932484924793243)*bt_g0_37;
    bt_l1_29 = bt_l1_29 + (-0.064853958785533905)*bt_g0_38;
    bt_l1_29 = bt_l1_29 + (-0.16944071650505066)*bt_g0_39;
    bt_l1_29 = bt_l1_29 + (-0.069295510649681091)*bt_g0_40;
    bt_l1_29 = bt_l1_29 + (-0.10321076214313507)*bt_g0_41;
    bt_l1_29 = bt_l1_29 + (-0.0014855865156278014)*bt_g0_42;
    bt_l1_29 = bt_l1_29 + (0.040237288922071457)*bt_g0_43;
    bt_l1_29 = bt_l1_29 + (0.1099967285990715)*bt_g0_44;
    bt_l1_29 = bt_l1_29 + (0.0016804790357127786)*bt_g0_45;
    bt_l1_29 = bt_l1_29 + (0.057182684540748596)*bt_g0_46;
    bt_l1_29 = bt_l1_29 + (-0.10148075222969055)*bt_g0_47;
    bt_l1_29 = bt_l1_29 + (0.074339844286441803)*bt_g0_48;
    bt_l1_29 = bt_l1_29 + (0.030853210017085075)*bt_g0_49;
    bt_l1_29 = bt_l1_29 + (0.14152427017688751)*bt_g0_50;
    bt_l1_29 = bt_l1_29 + (0.061333421617746353)*bt_g0_51;
    bt_l1_29 = bt_l1_29 + (0.070533245801925659)*bt_g0_52;
    bt_l1_29 = bt_l1_29 + (-0.0062665357254445553)*bt_g0_53;
    bt_l1_29 = bt_l1_29 + (0.14908811450004578)*bt_g0_54;
    bt_l1_29 = bt_l1_29 + (-0.14452286064624786)*bt_g0_55;
    bt_l1_29 = bt_l1_29 + (0.23734369874000549)*bt_g0_56;
    bt_l1_29 = bt_l1_29 + (-0.13014315068721771)*bt_g0_57;
    bt_l1_29 = bt_l1_29 + (-0.073690660297870636)*bt_g0_58;
    bt_l1_29 = bt_l1_29 + (-0.077321797609329224)*bt_g0_59;
    bt_l1_29 = bt_l1_29 + (-0.038156956434249878)*bt_g0_60;
    bt_l1_29 = bt_l1_29 + (0.046196233481168747)*bt_g0_61;
    bt_l1_29 = bt_l1_29 + (-0.052788127213716507)*bt_g0_62;
    bt_l1_29 = bt_l1_29 + (-0.0054063075222074986)*bt_g0_63;
    bt_l1_30 = 0.08480052649974823;
    bt_l1_30 = bt_l1_30 + (0.095250420272350311)*bt_g0_0;
    bt_l1_30 = bt_l1_30 + (-0.30543673038482666)*bt_g0_1;
    bt_l1_30 = bt_l1_30 + (0.030884562060236931)*bt_g0_2;
    bt_l1_30 = bt_l1_30 + (-0.042182832956314087)*bt_g0_3;
    bt_l1_30 = bt_l1_30 + (-0.10662189871072769)*bt_g0_4;
    bt_l1_30 = bt_l1_30 + (0.052318774163722992)*bt_g0_5;
    bt_l1_30 = bt_l1_30 + (-0.031008915975689888)*bt_g0_6;
    bt_l1_30 = bt_l1_30 + (-0.1147352010011673)*bt_g0_7;
    bt_l1_30 = bt_l1_30 + (0.19015492498874664)*bt_g0_8;
    bt_l1_30 = bt_l1_30 + (0.052620697766542435)*bt_g0_9;
    bt_l1_30 = bt_l1_30 + (-0.0048173144459724426)*bt_g0_10;
    bt_l1_30 = bt_l1_30 + (-0.13715817034244537)*bt_g0_11;
    bt_l1_30 = bt_l1_30 + (0.11951234191656113)*bt_g0_12;
    bt_l1_30 = bt_l1_30 + (0.052106607705354691)*bt_g0_13;
    bt_l1_30 = bt_l1_30 + (0.22888588905334473)*bt_g0_14;
    bt_l1_30 = bt_l1_30 + (0.16820764541625977)*bt_g0_15;
    bt_l1_30 = bt_l1_30 + (-0.094426631927490234)*bt_g0_16;
    bt_l1_30 = bt_l1_30 + (-0.013649353757500648)*bt_g0_17;
    bt_l1_30 = bt_l1_30 + (-0.090487480163574219)*bt_g0_18;
    bt_l1_30 = bt_l1_30 + (-0.035056840628385544)*bt_g0_19;
    bt_l1_30 = bt_l1_30 + (0.1453804224729538)*bt_g0_20;
    bt_l1_30 = bt_l1_30 + (0.11341810971498489)*bt_g0_21;
    bt_l1_30 = bt_l1_30 + (-0.036535516381263733)*bt_g0_22;
    bt_l1_30 = bt_l1_30 + (0.29235163331031799)*bt_g0_23;
    bt_l1_30 = bt_l1_30 + (0.56141805648803711)*bt_g0_24;
    bt_l1_30 = bt_l1_30 + (0.17935174703598022)*bt_g0_25;
    bt_l1_30 = bt_l1_30 + (-0.22649550437927246)*bt_g0_26;
    bt_l1_30 = bt_l1_30 + (0.17422871291637421)*bt_g0_27;
    bt_l1_30 = bt_l1_30 + (0.54337656497955322)*bt_g0_28;
    bt_l1_30 = bt_l1_30 + (0.087124228477478027)*bt_g0_29;
    bt_l1_30 = bt_l1_30 + (-0.06889621913433075)*bt_g0_30;
    bt_l1_30 = bt_l1_30 + (-0.033408176153898239)*bt_g0_31;
    bt_l1_30 = bt_l1_30 + (0.34861859679222107)*bt_g0_32;
    bt_l1_30 = bt_l1_30 + (-0.18166939914226532)*bt_g0_33;
    bt_l1_30 = bt_l1_30 + (0.048245206475257874)*bt_g0_34;
    bt_l1_30 = bt_l1_30 + (0.1912369430065155)*bt_g0_35;
    bt_l1_30 = bt_l1_30 + (0.026614965870976448)*bt_g0_36;
    bt_l1_30 = bt_l1_30 + (-0.14568233489990234)*bt_g0_37;
    bt_l1_30 = bt_l1_30 + (-0.15861892700195312)*bt_g0_38;
    bt_l1_30 = bt_l1_30 + (0.20789158344268799)*bt_g0_39;
    bt_l1_30 = bt_l1_30 + (0.14299915730953217)*bt_g0_40;
    bt_l1_30 = bt_l1_30 + (0.015713728964328766)*bt_g0_41;
    bt_l1_30 = bt_l1_30 + (-0.039645079523324966)*bt_g0_42;
    bt_l1_30 = bt_l1_30 + (0.06887248158454895)*bt_g0_43;
    bt_l1_30 = bt_l1_30 + (0.28905358910560608)*bt_g0_44;
    bt_l1_30 = bt_l1_30 + (-0.20312738418579102)*bt_g0_45;
    bt_l1_30 = bt_l1_30 + (-0.044310640543699265)*bt_g0_46;
    bt_l1_30 = bt_l1_30 + (0.079065918922424316)*bt_g0_47;
    bt_l1_30 = bt_l1_30 + (-0.024603279307484627)*bt_g0_48;
    bt_l1_30 = bt_l1_30 + (0.14044170081615448)*bt_g0_49;
    bt_l1_30 = bt_l1_30 + (-0.19971925020217896)*bt_g0_50;
    bt_l1_30 = bt_l1_30 + (0.28892382979393005)*bt_g0_51;
    bt_l1_30 = bt_l1_30 + (0.11475646495819092)*bt_g0_52;
    bt_l1_30 = bt_l1_30 + (-0.14768873155117035)*bt_g0_53;
    bt_l1_30 = bt_l1_30 + (0.10411122441291809)*bt_g0_54;
    bt_l1_30 = bt_l1_30 + (0.11274066567420959)*bt_g0_55;
    bt_l1_30 = bt_l1_30 + (-0.047442842274904251)*bt_g0_56;
    bt_l1_30 = bt_l1_30 + (0.090260840952396393)*bt_g0_57;
    bt_l1_30 = bt_l1_30 + (-0.05120573565363884)*bt_g0_58;
    bt_l1_30 = bt_l1_30 + (-0.30382019281387329)*bt_g0_59;
    bt_l1_30 = bt_l1_30 + (-0.35602986812591553)*bt_g0_60;
    bt_l1_30 = bt_l1_30 + (-0.0085197426378726959)*bt_g0_61;
    bt_l1_30 = bt_l1_30 + (0.23330299556255341)*bt_g0_62;
    bt_l1_30 = bt_l1_30 + (0.051552396267652512)*bt_g0_63;
    bt_l1_31 = 0.08047831803560257;
    bt_l1_31 = bt_l1_31 + (0.0016211405163630843)*bt_g0_0;
    bt_l1_31 = bt_l1_31 + (-0.036980658769607544)*bt_g0_1;
    bt_l1_31 = bt_l1_31 + (-0.17722846567630768)*bt_g0_2;
    bt_l1_31 = bt_l1_31 + (0.13268813490867615)*bt_g0_3;
    bt_l1_31 = bt_l1_31 + (0.046631969511508942)*bt_g0_4;
    bt_l1_31 = bt_l1_31 + (0.23911112546920776)*bt_g0_5;
    bt_l1_31 = bt_l1_31 + (-0.057265795767307281)*bt_g0_6;
    bt_l1_31 = bt_l1_31 + (0.17325863242149353)*bt_g0_7;
    bt_l1_31 = bt_l1_31 + (-0.21252967417240143)*bt_g0_8;
    bt_l1_31 = bt_l1_31 + (0.0061743580736219883)*bt_g0_9;
    bt_l1_31 = bt_l1_31 + (0.010817129164934158)*bt_g0_10;
    bt_l1_31 = bt_l1_31 + (0.1893022358417511)*bt_g0_11;
    bt_l1_31 = bt_l1_31 + (0.010930266231298447)*bt_g0_12;
    bt_l1_31 = bt_l1_31 + (-0.04959564283490181)*bt_g0_13;
    bt_l1_31 = bt_l1_31 + (-0.11253606528043747)*bt_g0_14;
    bt_l1_31 = bt_l1_31 + (-0.11332017183303833)*bt_g0_15;
    bt_l1_31 = bt_l1_31 + (0.15816217660903931)*bt_g0_16;
    bt_l1_31 = bt_l1_31 + (0.07114710658788681)*bt_g0_17;
    bt_l1_31 = bt_l1_31 + (0.077358797192573547)*bt_g0_18;
    bt_l1_31 = bt_l1_31 + (0.14960914850234985)*bt_g0_19;
    bt_l1_31 = bt_l1_31 + (-0.082627207040786743)*bt_g0_20;
    bt_l1_31 = bt_l1_31 + (0.076954714953899384)*bt_g0_21;
    bt_l1_31 = bt_l1_31 + (0.034025780856609344)*bt_g0_22;
    bt_l1_31 = bt_l1_31 + (-0.31054282188415527)*bt_g0_23;
    bt_l1_31 = bt_l1_31 + (0.27534356713294983)*bt_g0_24;
    bt_l1_31 = bt_l1_31 + (0.06202872097492218)*bt_g0_25;
    bt_l1_31 = bt_l1_31 + (-0.21776764094829559)*bt_g0_26;
    bt_l1_31 = bt_l1_31 + (0.21138036251068115)*bt_g0_27;
    bt_l1_31 = bt_l1_31 + (-0.18445560336112976)*bt_g0_28;
    bt_l1_31 = bt_l1_31 + (-0.14806434512138367)*bt_g0_29;
    bt_l1_31 = bt_l1_31 + (0.15846092998981476)*bt_g0_30;
    bt_l1_31 = bt_l1_31 + (0.12786464393138885)*bt_g0_31;
    bt_l1_31 = bt_l1_31 + (0.10038486868143082)*bt_g0_32;
    bt_l1_31 = bt_l1_31 + (-0.069532901048660278)*bt_g0_33;
    bt_l1_31 = bt_l1_31 + (0.029631711542606354)*bt_g0_34;
    bt_l1_31 = bt_l1_31 + (-0.042703114449977875)*bt_g0_35;
    bt_l1_31 = bt_l1_31 + (-0.19839741289615631)*bt_g0_36;
    bt_l1_31 = bt_l1_31 + (-0.059120919555425644)*bt_g0_37;
    bt_l1_31 = bt_l1_31 + (0.086587719619274139)*bt_g0_38;
    bt_l1_31 = bt_l1_31 + (-0.1425635814666748)*bt_g0_39;
    bt_l1_31 = bt_l1_31 + (-0.00077963771764189005)*bt_g0_40;
    bt_l1_31 = bt_l1_31 + (0.022607993334531784)*bt_g0_41;
    bt_l1_31 = bt_l1_31 + (-0.071246974170207977)*bt_g0_42;
    bt_l1_31 = bt_l1_31 + (-0.15818126499652863)*bt_g0_43;
    bt_l1_31 = bt_l1_31 + (0.058221101760864258)*bt_g0_44;
    bt_l1_31 = bt_l1_31 + (0.13187988102436066)*bt_g0_45;
    bt_l1_31 = bt_l1_31 + (-0.03691406175494194)*bt_g0_46;
    bt_l1_31 = bt_l1_31 + (-0.1414797455072403)*bt_g0_47;
    bt_l1_31 = bt_l1_31 + (0.037802897393703461)*bt_g0_48;
    bt_l1_31 = bt_l1_31 + (-0.13611258566379547)*bt_g0_49;
    bt_l1_31 = bt_l1_31 + (0.27740892767906189)*bt_g0_50;
    bt_l1_31 = bt_l1_31 + (-0.12784700095653534)*bt_g0_51;
    bt_l1_31 = bt_l1_31 + (0.034966316074132919)*bt_g0_52;
    bt_l1_31 = bt_l1_31 + (0.038155738264322281)*bt_g0_53;
    bt_l1_31 = bt_l1_31 + (0.25118649005889893)*bt_g0_54;
    bt_l1_31 = bt_l1_31 + (-0.15916010737419128)*bt_g0_55;
    bt_l1_31 = bt_l1_31 + (0.19412998855113983)*bt_g0_56;
    bt_l1_31 = bt_l1_31 + (-0.23028236627578735)*bt_g0_57;
    bt_l1_31 = bt_l1_31 + (0.10481786727905273)*bt_g0_58;
    bt_l1_31 = bt_l1_31 + (0.028065422549843788)*bt_g0_59;
    bt_l1_31 = bt_l1_31 + (0.029710451140999794)*bt_g0_60;
    bt_l1_31 = bt_l1_31 + (-0.12172951549291611)*bt_g0_61;
    bt_l1_31 = bt_l1_31 + (-0.21303641796112061)*bt_g0_62;
    bt_l1_31 = bt_l1_31 + (-0.095896489918231964)*bt_g0_63;
    bt_l1_32 = 0.0071515846066176891;
    bt_l1_32 = bt_l1_32 + (0.072183459997177124)*bt_g0_0;
    bt_l1_32 = bt_l1_32 + (0.059730846434831619)*bt_g0_1;
    bt_l1_32 = bt_l1_32 + (-0.030468471348285675)*bt_g0_2;
    bt_l1_32 = bt_l1_32 + (0.051489926874637604)*bt_g0_3;
    bt_l1_32 = bt_l1_32 + (0.085928380489349365)*bt_g0_4;
    bt_l1_32 = bt_l1_32 + (-0.42473816871643066)*bt_g0_5;
    bt_l1_32 = bt_l1_32 + (-0.03644469752907753)*bt_g0_6;
    bt_l1_32 = bt_l1_32 + (0.064334318041801453)*bt_g0_7;
    bt_l1_32 = bt_l1_32 + (-0.23083603382110596)*bt_g0_8;
    bt_l1_32 = bt_l1_32 + (0.019758537411689758)*bt_g0_9;
    bt_l1_32 = bt_l1_32 + (-0.081253334879875183)*bt_g0_10;
    bt_l1_32 = bt_l1_32 + (-0.0061819069087505341)*bt_g0_11;
    bt_l1_32 = bt_l1_32 + (0.0016577893402427435)*bt_g0_12;
    bt_l1_32 = bt_l1_32 + (0.082419909536838531)*bt_g0_13;
    bt_l1_32 = bt_l1_32 + (-0.08538074791431427)*bt_g0_14;
    bt_l1_32 = bt_l1_32 + (-0.14457882940769196)*bt_g0_15;
    bt_l1_32 = bt_l1_32 + (-0.23700706660747528)*bt_g0_16;
    bt_l1_32 = bt_l1_32 + (0.041423548012971878)*bt_g0_17;
    bt_l1_32 = bt_l1_32 + (0.13676483929157257)*bt_g0_18;
    bt_l1_32 = bt_l1_32 + (0.19688162207603455)*bt_g0_19;
    bt_l1_32 = bt_l1_32 + (-0.14660568535327911)*bt_g0_20;
    bt_l1_32 = bt_l1_32 + (-0.069433607161045074)*bt_g0_21;
    bt_l1_32 = bt_l1_32 + (0.025282410904765129)*bt_g0_22;
    bt_l1_32 = bt_l1_32 + (-0.25257173180580139)*bt_g0_23;
    bt_l1_32 = bt_l1_32 + (0.32842683792114258)*bt_g0_24;
    bt_l1_32 = bt_l1_32 + (-0.15257368981838226)*bt_g0_25;
    bt_l1_32 = bt_l1_32 + (0.022961186245083809)*bt_g0_26;
    bt_l1_32 = bt_l1_32 + (0.043472554534673691)*bt_g0_27;
    bt_l1_32 = bt_l1_32 + (0.12576006352901459)*bt_g0_28;
    bt_l1_32 = bt_l1_32 + (0.22504369914531708)*bt_g0_29;
    bt_l1_32 = bt_l1_32 + (0.1113266721367836)*bt_g0_30;
    bt_l1_32 = bt_l1_32 + (0.13452091813087463)*bt_g0_31;
    bt_l1_32 = bt_l1_32 + (-0.01803726889193058)*bt_g0_32;
    bt_l1_32 = bt_l1_32 + (0.10878872126340866)*bt_g0_33;
    bt_l1_32 = bt_l1_32 + (0.14490523934364319)*bt_g0_34;
    bt_l1_32 = bt_l1_32 + (-0.067235156893730164)*bt_g0_35;
    bt_l1_32 = bt_l1_32 + (-0.17670635879039764)*bt_g0_36;
    bt_l1_32 = bt_l1_32 + (-0.14174309372901917)*bt_g0_37;
    bt_l1_32 = bt_l1_32 + (-0.16428114473819733)*bt_g0_38;
    bt_l1_32 = bt_l1_32 + (-0.015733107924461365)*bt_g0_39;
    bt_l1_32 = bt_l1_32 + (0.11107015609741211)*bt_g0_40;
    bt_l1_32 = bt_l1_32 + (0.054101355373859406)*bt_g0_41;
    bt_l1_32 = bt_l1_32 + (-0.27190133929252625)*bt_g0_42;
    bt_l1_32 = bt_l1_32 + (0.028469661250710487)*bt_g0_43;
    bt_l1_32 = bt_l1_32 + (-0.16194000840187073)*bt_g0_44;
    bt_l1_32 = bt_l1_32 + (0.049741636961698532)*bt_g0_45;
    bt_l1_32 = bt_l1_32 + (0.14560593664646149)*bt_g0_46;
    bt_l1_32 = bt_l1_32 + (0.092053376138210297)*bt_g0_47;
    bt_l1_32 = bt_l1_32 + (0.011191380210220814)*bt_g0_48;
    bt_l1_32 = bt_l1_32 + (-0.11323216557502747)*bt_g0_49;
    bt_l1_32 = bt_l1_32 + (0.12605814635753632)*bt_g0_50;
    bt_l1_32 = bt_l1_32 + (-0.15811069309711456)*bt_g0_51;
    bt_l1_32 = bt_l1_32 + (-0.0095479302108287811)*bt_g0_52;
    bt_l1_32 = bt_l1_32 + (0.049677081406116486)*bt_g0_53;
    bt_l1_32 = bt_l1_32 + (-0.15164992213249207)*bt_g0_54;
    bt_l1_32 = bt_l1_32 + (-0.069403231143951416)*bt_g0_55;
    bt_l1_32 = bt_l1_32 + (0.027032719925045967)*bt_g0_56;
    bt_l1_32 = bt_l1_32 + (0.060548312962055206)*bt_g0_57;
    bt_l1_32 = bt_l1_32 + (-0.084198459982872009)*bt_g0_58;
    bt_l1_32 = bt_l1_32 + (-0.071488149464130402)*bt_g0_59;
    bt_l1_32 = bt_l1_32 + (0.094544112682342529)*bt_g0_60;
    bt_l1_32 = bt_l1_32 + (-0.34565025568008423)*bt_g0_61;
    bt_l1_32 = bt_l1_32 + (-0.45840111374855042)*bt_g0_62;
    bt_l1_32 = bt_l1_32 + (-0.088214389979839325)*bt_g0_63;
    bt_l1_33 = 0.060251720249652863;
    bt_l1_33 = bt_l1_33 + (-0.021640464663505554)*bt_g0_0;
    bt_l1_33 = bt_l1_33 + (-0.027778929099440575)*bt_g0_1;
    bt_l1_33 = bt_l1_33 + (0.051725797355175018)*bt_g0_2;
    bt_l1_33 = bt_l1_33 + (-0.050512317568063736)*bt_g0_3;
    bt_l1_33 = bt_l1_33 + (0.01036728173494339)*bt_g0_4;
    bt_l1_33 = bt_l1_33 + (0.41126552224159241)*bt_g0_5;
    bt_l1_33 = bt_l1_33 + (0.0038510535378009081)*bt_g0_6;
    bt_l1_33 = bt_l1_33 + (-0.051661111414432526)*bt_g0_7;
    bt_l1_33 = bt_l1_33 + (0.024290537461638451)*bt_g0_8;
    bt_l1_33 = bt_l1_33 + (-0.052088767290115356)*bt_g0_9;
    bt_l1_33 = bt_l1_33 + (0.10906784236431122)*bt_g0_10;
    bt_l1_33 = bt_l1_33 + (0.0011117117246612906)*bt_g0_11;
    bt_l1_33 = bt_l1_33 + (0.16322517395019531)*bt_g0_12;
    bt_l1_33 = bt_l1_33 + (-0.036029260605573654)*bt_g0_13;
    bt_l1_33 = bt_l1_33 + (-0.16267327964305878)*bt_g0_14;
    bt_l1_33 = bt_l1_33 + (0.022167665883898735)*bt_g0_15;
    bt_l1_33 = bt_l1_33 + (0.27888929843902588)*bt_g0_16;
    bt_l1_33 = bt_l1_33 + (0.035616401582956314)*bt_g0_17;
    bt_l1_33 = bt_l1_33 + (0.10756874084472656)*bt_g0_18;
    bt_l1_33 = bt_l1_33 + (0.049281861633062363)*bt_g0_19;
    bt_l1_33 = bt_l1_33 + (-0.022789200767874718)*bt_g0_20;
    bt_l1_33 = bt_l1_33 + (-0.0042875730432569981)*bt_g0_21;
    bt_l1_33 = bt_l1_33 + (-0.0046109231188893318)*bt_g0_22;
    bt_l1_33 = bt_l1_33 + (-0.34820005297660828)*bt_g0_23;
    bt_l1_33 = bt_l1_33 + (-0.17460164427757263)*bt_g0_24;
    bt_l1_33 = bt_l1_33 + (-0.12946313619613647)*bt_g0_25;
    bt_l1_33 = bt_l1_33 + (-0.043481834232807159)*bt_g0_26;
    bt_l1_33 = bt_l1_33 + (0.039808988571166992)*bt_g0_27;
    bt_l1_33 = bt_l1_33 + (-0.11822700500488281)*bt_g0_28;
    bt_l1_33 = bt_l1_33 + (0.044446356594562531)*bt_g0_29;
    bt_l1_33 = bt_l1_33 + (-0.0069454158656299114)*bt_g0_30;
    bt_l1_33 = bt_l1_33 + (0.042448263615369797)*bt_g0_31;
    bt_l1_33 = bt_l1_33 + (0.087703287601470947)*bt_g0_32;
    bt_l1_33 = bt_l1_33 + (0.072511754930019379)*bt_g0_33;
    bt_l1_33 = bt_l1_33 + (0.017025914043188095)*bt_g0_34;
    bt_l1_33 = bt_l1_33 + (-0.065854564309120178)*bt_g0_35;
    bt_l1_33 = bt_l1_33 + (0.10759114474058151)*bt_g0_36;
    bt_l1_33 = bt_l1_33 + (-0.044125225394964218)*bt_g0_37;
    bt_l1_33 = bt_l1_33 + (0.27735385298728943)*bt_g0_38;
    bt_l1_33 = bt_l1_33 + (-0.20176729559898376)*bt_g0_39;
    bt_l1_33 = bt_l1_33 + (-0.075687378644943237)*bt_g0_40;
    bt_l1_33 = bt_l1_33 + (-0.11091679334640503)*bt_g0_41;
    bt_l1_33 = bt_l1_33 + (-0.035324223339557648)*bt_g0_42;
    bt_l1_33 = bt_l1_33 + (-0.15975354611873627)*bt_g0_43;
    bt_l1_33 = bt_l1_33 + (0.43408417701721191)*bt_g0_44;
    bt_l1_33 = bt_l1_33 + (-0.11297407746315002)*bt_g0_45;
    bt_l1_33 = bt_l1_33 + (-0.01216286513954401)*bt_g0_46;
    bt_l1_33 = bt_l1_33 + (-0.064308337867259979)*bt_g0_47;
    bt_l1_33 = bt_l1_33 + (-0.1363709568977356)*bt_g0_48;
    bt_l1_33 = bt_l1_33 + (-0.071096725761890411)*bt_g0_49;
    bt_l1_33 = bt_l1_33 + (0.049896731972694397)*bt_g0_50;
    bt_l1_33 = bt_l1_33 + (-0.24882371723651886)*bt_g0_51;
    bt_l1_33 = bt_l1_33 + (0.13066928088665009)*bt_g0_52;
    bt_l1_33 = bt_l1_33 + (-0.056084278970956802)*bt_g0_53;
    bt_l1_33 = bt_l1_33 + (-0.0096425479277968407)*bt_g0_54;
    bt_l1_33 = bt_l1_33 + (-0.053659383207559586)*bt_g0_55;
    bt_l1_33 = bt_l1_33 + (0.092395402491092682)*bt_g0_56;
    bt_l1_33 = bt_l1_33 + (-0.11739802360534668)*bt_g0_57;
    bt_l1_33 = bt_l1_33 + (0.18099123239517212)*bt_g0_58;
    bt_l1_33 = bt_l1_33 + (-0.15194933116436005)*bt_g0_59;
    bt_l1_33 = bt_l1_33 + (-0.081900820136070251)*bt_g0_60;
    bt_l1_33 = bt_l1_33 + (-0.079528026282787323)*bt_g0_61;
    bt_l1_33 = bt_l1_33 + (-0.24379576742649078)*bt_g0_62;
    bt_l1_33 = bt_l1_33 + (0.09888332337141037)*bt_g0_63;
    bt_l1_34 = 0.029838345944881439;
    bt_l1_34 = bt_l1_34 + (-0.0066060079261660576)*bt_g0_0;
    bt_l1_34 = bt_l1_34 + (-0.093373358249664307)*bt_g0_1;
    bt_l1_34 = bt_l1_34 + (0.072681941092014313)*bt_g0_2;
    bt_l1_34 = bt_l1_34 + (-0.12947267293930054)*bt_g0_3;
    bt_l1_34 = bt_l1_34 + (-0.037503931671380997)*bt_g0_4;
    bt_l1_34 = bt_l1_34 + (0.084596484899520874)*bt_g0_5;
    bt_l1_34 = bt_l1_34 + (-0.0086191631853580475)*bt_g0_6;
    bt_l1_34 = bt_l1_34 + (0.2548103928565979)*bt_g0_7;
    bt_l1_34 = bt_l1_34 + (-0.067465543746948242)*bt_g0_8;
    bt_l1_34 = bt_l1_34 + (-0.11227866262197495)*bt_g0_9;
    bt_l1_34 = bt_l1_34 + (-0.12811650335788727)*bt_g0_10;
    bt_l1_34 = bt_l1_34 + (-0.06979968398809433)*bt_g0_11;
    bt_l1_34 = bt_l1_34 + (0.1322663426399231)*bt_g0_12;
    bt_l1_34 = bt_l1_34 + (0.027158984914422035)*bt_g0_13;
    bt_l1_34 = bt_l1_34 + (-0.0083261439576745033)*bt_g0_14;
    bt_l1_34 = bt_l1_34 + (-0.11630063503980637)*bt_g0_15;
    bt_l1_34 = bt_l1_34 + (-0.034088902175426483)*bt_g0_16;
    bt_l1_34 = bt_l1_34 + (0.11470931768417358)*bt_g0_17;
    bt_l1_34 = bt_l1_34 + (0.11266414821147919)*bt_g0_18;
    bt_l1_34 = bt_l1_34 + (-0.010510924272239208)*bt_g0_19;
    bt_l1_34 = bt_l1_34 + (0.076928295195102692)*bt_g0_20;
    bt_l1_34 = bt_l1_34 + (-0.047115109860897064)*bt_g0_21;
    bt_l1_34 = bt_l1_34 + (-0.10511668771505356)*bt_g0_22;
    bt_l1_34 = bt_l1_34 + (0.12042716145515442)*bt_g0_23;
    bt_l1_34 = bt_l1_34 + (0.48728004097938538)*bt_g0_24;
    bt_l1_34 = bt_l1_34 + (0.47267964482307434)*bt_g0_25;
    bt_l1_34 = bt_l1_34 + (-0.11324357241392136)*bt_g0_26;
    bt_l1_34 = bt_l1_34 + (0.1633816659450531)*bt_g0_27;
    bt_l1_34 = bt_l1_34 + (0.37602809071540833)*bt_g0_28;
    bt_l1_34 = bt_l1_34 + (0.10168422013521194)*bt_g0_29;
    bt_l1_34 = bt_l1_34 + (0.0086725158616900444)*bt_g0_30;
    bt_l1_34 = bt_l1_34 + (0.17671903967857361)*bt_g0_31;
    bt_l1_34 = bt_l1_34 + (0.17910106480121613)*bt_g0_32;
    bt_l1_34 = bt_l1_34 + (-0.11256781220436096)*bt_g0_33;
    bt_l1_34 = bt_l1_34 + (0.10099495202302933)*bt_g0_34;
    bt_l1_34 = bt_l1_34 + (0.062164649367332458)*bt_g0_35;
    bt_l1_34 = bt_l1_34 + (-0.10654845833778381)*bt_g0_36;
    bt_l1_34 = bt_l1_34 + (0.131620854139328)*bt_g0_37;
    bt_l1_34 = bt_l1_34 + (0.15636961162090302)*bt_g0_38;
    bt_l1_34 = bt_l1_34 + (0.29734581708908081)*bt_g0_39;
    bt_l1_34 = bt_l1_34 + (0.12398334592580795)*bt_g0_40;
    bt_l1_34 = bt_l1_34 + (0.11437946557998657)*bt_g0_41;
    bt_l1_34 = bt_l1_34 + (0.049952801316976547)*bt_g0_42;
    bt_l1_34 = bt_l1_34 + (-0.0055413744412362576)*bt_g0_43;
    bt_l1_34 = bt_l1_34 + (0.060191135853528976)*bt_g0_44;
    bt_l1_34 = bt_l1_34 + (-0.095636598765850067)*bt_g0_45;
    bt_l1_34 = bt_l1_34 + (-0.093439072370529175)*bt_g0_46;
    bt_l1_34 = bt_l1_34 + (0.022072644904255867)*bt_g0_47;
    bt_l1_34 = bt_l1_34 + (-0.11407884955406189)*bt_g0_48;
    bt_l1_34 = bt_l1_34 + (0.072433389723300934)*bt_g0_49;
    bt_l1_34 = bt_l1_34 + (-0.069339439272880554)*bt_g0_50;
    bt_l1_34 = bt_l1_34 + (-0.0052635953761637211)*bt_g0_51;
    bt_l1_34 = bt_l1_34 + (-0.060993023216724396)*bt_g0_52;
    bt_l1_34 = bt_l1_34 + (0.038532480597496033)*bt_g0_53;
    bt_l1_34 = bt_l1_34 + (0.080415010452270508)*bt_g0_54;
    bt_l1_34 = bt_l1_34 + (0.034243937581777573)*bt_g0_55;
    bt_l1_34 = bt_l1_34 + (-0.052437279373407364)*bt_g0_56;
    bt_l1_34 = bt_l1_34 + (0.030097914859652519)*bt_g0_57;
    bt_l1_34 = bt_l1_34 + (0.025225166231393814)*bt_g0_58;
    bt_l1_34 = bt_l1_34 + (-0.17442356050014496)*bt_g0_59;
    bt_l1_34 = bt_l1_34 + (0.0091163292527198792)*bt_g0_60;
    bt_l1_34 = bt_l1_34 + (0.31941625475883484)*bt_g0_61;
    bt_l1_34 = bt_l1_34 + (-0.20217639207839966)*bt_g0_62;
    bt_l1_34 = bt_l1_34 + (0.19647668302059174)*bt_g0_63;
    bt_l1_35 = 0.10114506632089615;
    bt_l1_35 = bt_l1_35 + (0.022305740043520927)*bt_g0_0;
    bt_l1_35 = bt_l1_35 + (-0.027062293142080307)*bt_g0_1;
    bt_l1_35 = bt_l1_35 + (0.028463587164878845)*bt_g0_2;
    bt_l1_35 = bt_l1_35 + (-0.08548639714717865)*bt_g0_3;
    bt_l1_35 = bt_l1_35 + (-0.06406828761100769)*bt_g0_4;
    bt_l1_35 = bt_l1_35 + (-0.0027773776091635227)*bt_g0_5;
    bt_l1_35 = bt_l1_35 + (0.083896361291408539)*bt_g0_6;
    bt_l1_35 = bt_l1_35 + (-0.03636462613940239)*bt_g0_7;
    bt_l1_35 = bt_l1_35 + (-0.080124035477638245)*bt_g0_8;
    bt_l1_35 = bt_l1_35 + (-0.12929040193557739)*bt_g0_9;
    bt_l1_35 = bt_l1_35 + (-0.022204447537660599)*bt_g0_10;
    bt_l1_35 = bt_l1_35 + (-0.11758074909448624)*bt_g0_11;
    bt_l1_35 = bt_l1_35 + (0.006907374132424593)*bt_g0_12;
    bt_l1_35 = bt_l1_35 + (-0.1036059558391571)*bt_g0_13;
    bt_l1_35 = bt_l1_35 + (-0.058504216372966766)*bt_g0_14;
    bt_l1_35 = bt_l1_35 + (0.087100870907306671)*bt_g0_15;
    bt_l1_35 = bt_l1_35 + (-0.11714192479848862)*bt_g0_16;
    bt_l1_35 = bt_l1_35 + (-0.1783200204372406)*bt_g0_17;
    bt_l1_35 = bt_l1_35 + (0.10856226831674576)*bt_g0_18;
    bt_l1_35 = bt_l1_35 + (0.017081519588828087)*bt_g0_19;
    bt_l1_35 = bt_l1_35 + (0.097054466605186462)*bt_g0_20;
    bt_l1_35 = bt_l1_35 + (0.090536691248416901)*bt_g0_21;
    bt_l1_35 = bt_l1_35 + (0.14384444057941437)*bt_g0_22;
    bt_l1_35 = bt_l1_35 + (-0.10061933845281601)*bt_g0_23;
    bt_l1_35 = bt_l1_35 + (-0.44841894507408142)*bt_g0_24;
    bt_l1_35 = bt_l1_35 + (-0.13268174231052399)*bt_g0_25;
    bt_l1_35 = bt_l1_35 + (0.18443720042705536)*bt_g0_26;
    bt_l1_35 = bt_l1_35 + (-0.013905688188970089)*bt_g0_27;
    bt_l1_35 = bt_l1_35 + (0.054820224642753601)*bt_g0_28;
    bt_l1_35 = bt_l1_35 + (0.042280744761228561)*bt_g0_29;
    bt_l1_35 = bt_l1_35 + (-0.10837193578481674)*bt_g0_30;
    bt_l1_35 = bt_l1_35 + (0.032149661332368851)*bt_g0_31;
    bt_l1_35 = bt_l1_35 + (-0.015736348927021027)*bt_g0_32;
    bt_l1_35 = bt_l1_35 + (-0.0051728291437029839)*bt_g0_33;
    bt_l1_35 = bt_l1_35 + (-0.00012834920198656619)*bt_g0_34;
    bt_l1_35 = bt_l1_35 + (0.23154042661190033)*bt_g0_35;
    bt_l1_35 = bt_l1_35 + (-0.063631191849708557)*bt_g0_36;
    bt_l1_35 = bt_l1_35 + (-0.055593334138393402)*bt_g0_37;
    bt_l1_35 = bt_l1_35 + (-0.22222527861595154)*bt_g0_38;
    bt_l1_35 = bt_l1_35 + (0.10337304323911667)*bt_g0_39;
    bt_l1_35 = bt_l1_35 + (-0.049464039504528046)*bt_g0_40;
    bt_l1_35 = bt_l1_35 + (0.010861769318580627)*bt_g0_41;
    bt_l1_35 = bt_l1_35 + (0.17215321958065033)*bt_g0_42;
    bt_l1_35 = bt_l1_35 + (-0.012685433961451054)*bt_g0_43;
    bt_l1_35 = bt_l1_35 + (-0.017540911212563515)*bt_g0_44;
    bt_l1_35 = bt_l1_35 + (-0.031908214092254639)*bt_g0_45;
    bt_l1_35 = bt_l1_35 + (0.12229873985052109)*bt_g0_46;
    bt_l1_35 = bt_l1_35 + (0.041412830352783203)*bt_g0_47;
    bt_l1_35 = bt_l1_35 + (0.15341421961784363)*bt_g0_48;
    bt_l1_35 = bt_l1_35 + (0.06588069349527359)*bt_g0_49;
    bt_l1_35 = bt_l1_35 + (-0.014955048449337482)*bt_g0_50;
    bt_l1_35 = bt_l1_35 + (-0.055210001766681671)*bt_g0_51;
    bt_l1_35 = bt_l1_35 + (-0.066983982920646667)*bt_g0_52;
    bt_l1_35 = bt_l1_35 + (0.013823986053466797)*bt_g0_53;
    bt_l1_35 = bt_l1_35 + (0.034001119434833527)*bt_g0_54;
    bt_l1_35 = bt_l1_35 + (0.094126291573047638)*bt_g0_55;
    bt_l1_35 = bt_l1_35 + (-0.031676840037107468)*bt_g0_56;
    bt_l1_35 = bt_l1_35 + (0.072817370295524597)*bt_g0_57;
    bt_l1_35 = bt_l1_35 + (-0.14691641926765442)*bt_g0_58;
    bt_l1_35 = bt_l1_35 + (0.19449108839035034)*bt_g0_59;
    bt_l1_35 = bt_l1_35 + (0.12024258822202682)*bt_g0_60;
    bt_l1_35 = bt_l1_35 + (0.19421444833278656)*bt_g0_61;
    bt_l1_35 = bt_l1_35 + (-0.096147775650024414)*bt_g0_62;
    bt_l1_35 = bt_l1_35 + (-0.059213895350694656)*bt_g0_63;
    bt_l1_36 = 0.038807712495326996;
    bt_l1_36 = bt_l1_36 + (-0.005408142227679491)*bt_g0_0;
    bt_l1_36 = bt_l1_36 + (0.029039127752184868)*bt_g0_1;
    bt_l1_36 = bt_l1_36 + (0.067938439548015594)*bt_g0_2;
    bt_l1_36 = bt_l1_36 + (0.028530428186058998)*bt_g0_3;
    bt_l1_36 = bt_l1_36 + (0.15849283337593079)*bt_g0_4;
    bt_l1_36 = bt_l1_36 + (-0.66265451908111572)*bt_g0_5;
    bt_l1_36 = bt_l1_36 + (0.0018624324584379792)*bt_g0_6;
    bt_l1_36 = bt_l1_36 + (-0.097319915890693665)*bt_g0_7;
    bt_l1_36 = bt_l1_36 + (-0.097770705819129944)*bt_g0_8;
    bt_l1_36 = bt_l1_36 + (-0.13112562894821167)*bt_g0_9;
    bt_l1_36 = bt_l1_36 + (0.020677559077739716)*bt_g0_10;
    bt_l1_36 = bt_l1_36 + (-0.069786645472049713)*bt_g0_11;
    bt_l1_36 = bt_l1_36 + (-0.088847249746322632)*bt_g0_12;
    bt_l1_36 = bt_l1_36 + (0.17575956881046295)*bt_g0_13;
    bt_l1_36 = bt_l1_36 + (-0.0076550832018256187)*bt_g0_14;
    bt_l1_36 = bt_l1_36 + (-0.50652092695236206)*bt_g0_15;
    bt_l1_36 = bt_l1_36 + (-0.56351333856582642)*bt_g0_16;
    bt_l1_36 = bt_l1_36 + (-0.03752044215798378)*bt_g0_17;
    bt_l1_36 = bt_l1_36 + (0.082200102508068085)*bt_g0_18;
    bt_l1_36 = bt_l1_36 + (0.088012129068374634)*bt_g0_19;
    bt_l1_36 = bt_l1_36 + (-0.09868408739566803)*bt_g0_20;
    bt_l1_36 = bt_l1_36 + (-0.060300722718238831)*bt_g0_21;
    bt_l1_36 = bt_l1_36 + (0.019178116694092751)*bt_g0_22;
    bt_l1_36 = bt_l1_36 + (0.09247320145368576)*bt_g0_23;
    bt_l1_36 = bt_l1_36 + (-0.00024955047410912812)*bt_g0_24;
    bt_l1_36 = bt_l1_36 + (0.25112521648406982)*bt_g0_25;
    bt_l1_36 = bt_l1_36 + (-0.1367279440164566)*bt_g0_26;
    bt_l1_36 = bt_l1_36 + (-0.02912893146276474)*bt_g0_27;
    bt_l1_36 = bt_l1_36 + (-0.11573874950408936)*bt_g0_28;
    bt_l1_36 = bt_l1_36 + (0.140125572681427)*bt_g0_29;
    bt_l1_36 = bt_l1_36 + (0.11397684365510941)*bt_g0_30;
    bt_l1_36 = bt_l1_36 + (0.10912298411130905)*bt_g0_31;
    bt_l1_36 = bt_l1_36 + (0.002863375237211585)*bt_g0_32;
    bt_l1_36 = bt_l1_36 + (-0.056256994605064392)*bt_g0_33;
    bt_l1_36 = bt_l1_36 + (0.076849699020385742)*bt_g0_34;
    bt_l1_36 = bt_l1_36 + (-0.033270996063947678)*bt_g0_35;
    bt_l1_36 = bt_l1_36 + (-0.16043850779533386)*bt_g0_36;
    bt_l1_36 = bt_l1_36 + (0.041483879089355469)*bt_g0_37;
    bt_l1_36 = bt_l1_36 + (-0.29251283407211304)*bt_g0_38;
    bt_l1_36 = bt_l1_36 + (0.063143663108348846)*bt_g0_39;
    bt_l1_36 = bt_l1_36 + (0.078287556767463684)*bt_g0_40;
    bt_l1_36 = bt_l1_36 + (0.1825157105922699)*bt_g0_41;
    bt_l1_36 = bt_l1_36 + (-0.15332488715648651)*bt_g0_42;
    bt_l1_36 = bt_l1_36 + (0.12992563843727112)*bt_g0_43;
    bt_l1_36 = bt_l1_36 + (0.098112925887107849)*bt_g0_44;
    bt_l1_36 = bt_l1_36 + (0.075747862458229065)*bt_g0_45;
    bt_l1_36 = bt_l1_36 + (0.13786749541759491)*bt_g0_46;
    bt_l1_36 = bt_l1_36 + (0.12069476395845413)*bt_g0_47;
    bt_l1_36 = bt_l1_36 + (0.024395331740379333)*bt_g0_48;
    bt_l1_36 = bt_l1_36 + (-0.012362140230834484)*bt_g0_49;
    bt_l1_36 = bt_l1_36 + (-0.18462015688419342)*bt_g0_50;
    bt_l1_36 = bt_l1_36 + (-0.017180435359477997)*bt_g0_51;
    bt_l1_36 = bt_l1_36 + (-0.058385666459798813)*bt_g0_52;
    bt_l1_36 = bt_l1_36 + (0.12161386758089066)*bt_g0_53;
    bt_l1_36 = bt_l1_36 + (0.019561082124710083)*bt_g0_54;
    bt_l1_36 = bt_l1_36 + (-0.021095335483551025)*bt_g0_55;
    bt_l1_36 = bt_l1_36 + (-0.042720429599285126)*bt_g0_56;
    bt_l1_36 = bt_l1_36 + (0.14176087081432343)*bt_g0_57;
    bt_l1_36 = bt_l1_36 + (-0.20680136978626251)*bt_g0_58;
    bt_l1_36 = bt_l1_36 + (0.001767233363352716)*bt_g0_59;
    bt_l1_36 = bt_l1_36 + (0.013162858784198761)*bt_g0_60;
    bt_l1_36 = bt_l1_36 + (-0.12462538480758667)*bt_g0_61;
    bt_l1_36 = bt_l1_36 + (-0.55644685029983521)*bt_g0_62;
    bt_l1_36 = bt_l1_36 + (0.10282943397760391)*bt_g0_63;
    bt_l1_37 = 0.018538935109972954;
    bt_l1_37 = bt_l1_37 + (-0.055642448365688324)*bt_g0_0;
    bt_l1_37 = bt_l1_37 + (-0.059930365532636642)*bt_g0_1;
    bt_l1_37 = bt_l1_37 + (0.043621551245450974)*bt_g0_2;
    bt_l1_37 = bt_l1_37 + (-0.11250746250152588)*bt_g0_3;
    bt_l1_37 = bt_l1_37 + (0.0021478969138115644)*bt_g0_4;
    bt_l1_37 = bt_l1_37 + (0.27253758907318115)*bt_g0_5;
    bt_l1_37 = bt_l1_37 + (-0.14424382150173187)*bt_g0_6;
    bt_l1_37 = bt_l1_37 + (0.033352389931678772)*bt_g0_7;
    bt_l1_37 = bt_l1_37 + (0.12654110789299011)*bt_g0_8;
    bt_l1_37 = bt_l1_37 + (0.025567667558789253)*bt_g0_9;
    bt_l1_37 = bt_l1_37 + (0.23965801298618317)*bt_g0_10;
    bt_l1_37 = bt_l1_37 + (0.053240392357110977)*bt_g0_11;
    bt_l1_37 = bt_l1_37 + (0.071264088153839111)*bt_g0_12;
    bt_l1_37 = bt_l1_37 + (-0.073814660310745239)*bt_g0_13;
    bt_l1_37 = bt_l1_37 + (-0.068832792341709137)*bt_g0_14;
    bt_l1_37 = bt_l1_37 + (0.36468297243118286)*bt_g0_15;
    bt_l1_37 = bt_l1_37 + (0.23430198431015015)*bt_g0_16;
    bt_l1_37 = bt_l1_37 + (0.00094805430853739381)*bt_g0_17;
    bt_l1_37 = bt_l1_37 + (-0.021849630400538445)*bt_g0_18;
    bt_l1_37 = bt_l1_37 + (0.068136975169181824)*bt_g0_19;
    bt_l1_37 = bt_l1_37 + (0.085492394864559174)*bt_g0_20;
    bt_l1_37 = bt_l1_37 + (0.056267488747835159)*bt_g0_21;
    bt_l1_37 = bt_l1_37 + (-0.23466183245182037)*bt_g0_22;
    bt_l1_37 = bt_l1_37 + (0.0053049135021865368)*bt_g0_23;
    bt_l1_37 = bt_l1_37 + (0.15072959661483765)*bt_g0_24;
    bt_l1_37 = bt_l1_37 + (-0.30095085501670837)*bt_g0_25;
    bt_l1_37 = bt_l1_37 + (0.077738337218761444)*bt_g0_26;
    bt_l1_37 = bt_l1_37 + (0.1713162362575531)*bt_g0_27;
    bt_l1_37 = bt_l1_37 + (-0.090302079916000366)*bt_g0_28;
    bt_l1_37 = bt_l1_37 + (-0.19280509650707245)*bt_g0_29;
    bt_l1_37 = bt_l1_37 + (0.017738658934831619)*bt_g0_30;
    bt_l1_37 = bt_l1_37 + (-0.064694672822952271)*bt_g0_31;
    bt_l1_37 = bt_l1_37 + (-0.25030392408370972)*bt_g0_32;
    bt_l1_37 = bt_l1_37 + (-0.28644102811813354)*bt_g0_33;
    bt_l1_37 = bt_l1_37 + (0.007280874066054821)*bt_g0_34;
    bt_l1_37 = bt_l1_37 + (0.11823433637619019)*bt_g0_35;
    bt_l1_37 = bt_l1_37 + (0.17444467544555664)*bt_g0_36;
    bt_l1_37 = bt_l1_37 + (0.16937343776226044)*bt_g0_37;
    bt_l1_37 = bt_l1_37 + (0.23300457000732422)*bt_g0_38;
    bt_l1_37 = bt_l1_37 + (0.090903393924236298)*bt_g0_39;
    bt_l1_37 = bt_l1_37 + (-0.25649634003639221)*bt_g0_40;
    bt_l1_37 = bt_l1_37 + (-0.073289357125759125)*bt_g0_41;
    bt_l1_37 = bt_l1_37 + (-0.04923572763800621)*bt_g0_42;
    bt_l1_37 = bt_l1_37 + (-0.1199701800942421)*bt_g0_43;
    bt_l1_37 = bt_l1_37 + (-0.1009838804602623)*bt_g0_44;
    bt_l1_37 = bt_l1_37 + (-0.023922296240925789)*bt_g0_45;
    bt_l1_37 = bt_l1_37 + (-0.17293794453144073)*bt_g0_46;
    bt_l1_37 = bt_l1_37 + (0.034909460693597794)*bt_g0_47;
    bt_l1_37 = bt_l1_37 + (-0.30868488550186157)*bt_g0_48;
    bt_l1_37 = bt_l1_37 + (0.086006790399551392)*bt_g0_49;
    bt_l1_37 = bt_l1_37 + (0.040727473795413971)*bt_g0_50;
    bt_l1_37 = bt_l1_37 + (-0.089691445231437683)*bt_g0_51;
    bt_l1_37 = bt_l1_37 + (0.0073424838483333588)*bt_g0_52;
    bt_l1_37 = bt_l1_37 + (-0.032070986926555634)*bt_g0_53;
    bt_l1_37 = bt_l1_37 + (0.14288167655467987)*bt_g0_54;
    bt_l1_37 = bt_l1_37 + (-0.14521743357181549)*bt_g0_55;
    bt_l1_37 = bt_l1_37 + (-0.134693443775177)*bt_g0_56;
    bt_l1_37 = bt_l1_37 + (0.014882314018905163)*bt_g0_57;
    bt_l1_37 = bt_l1_37 + (-0.0073788240551948547)*bt_g0_58;
    bt_l1_37 = bt_l1_37 + (0.11311037838459015)*bt_g0_59;
    bt_l1_37 = bt_l1_37 + (0.0097826039418578148)*bt_g0_60;
    bt_l1_37 = bt_l1_37 + (0.11165311932563782)*bt_g0_61;
    bt_l1_37 = bt_l1_37 + (0.22784702479839325)*bt_g0_62;
    bt_l1_37 = bt_l1_37 + (-0.027672711759805679)*bt_g0_63;
    bt_l1_38 = -0.04849519208073616;
    bt_l1_38 = bt_l1_38 + (0.045296188443899155)*bt_g0_0;
    bt_l1_38 = bt_l1_38 + (0.081020593643188477)*bt_g0_1;
    bt_l1_38 = bt_l1_38 + (0.14840832352638245)*bt_g0_2;
    bt_l1_38 = bt_l1_38 + (-0.0012687301496043801)*bt_g0_3;
    bt_l1_38 = bt_l1_38 + (0.083570659160614014)*bt_g0_4;
    bt_l1_38 = bt_l1_38 + (-0.080430202186107635)*bt_g0_5;
    bt_l1_38 = bt_l1_38 + (-0.1261277049779892)*bt_g0_6;
    bt_l1_38 = bt_l1_38 + (-0.17261071503162384)*bt_g0_7;
    bt_l1_38 = bt_l1_38 + (0.061649240553379059)*bt_g0_8;
    bt_l1_38 = bt_l1_38 + (0.03500032052397728)*bt_g0_9;
    bt_l1_38 = bt_l1_38 + (-0.088635779917240143)*bt_g0_10;
    bt_l1_38 = bt_l1_38 + (-0.088259495794773102)*bt_g0_11;
    bt_l1_38 = bt_l1_38 + (0.035280521959066391)*bt_g0_12;
    bt_l1_38 = bt_l1_38 + (0.074522584676742554)*bt_g0_13;
    bt_l1_38 = bt_l1_38 + (-0.05560099333524704)*bt_g0_14;
    bt_l1_38 = bt_l1_38 + (-0.2185513824224472)*bt_g0_15;
    bt_l1_38 = bt_l1_38 + (-0.051779501140117645)*bt_g0_16;
    bt_l1_38 = bt_l1_38 + (0.074408121407032013)*bt_g0_17;
    bt_l1_38 = bt_l1_38 + (0.088706545531749725)*bt_g0_18;
    bt_l1_38 = bt_l1_38 + (0.11659465730190277)*bt_g0_19;
    bt_l1_38 = bt_l1_38 + (-0.038178499788045883)*bt_g0_20;
    bt_l1_38 = bt_l1_38 + (-0.042264539748430252)*bt_g0_21;
    bt_l1_38 = bt_l1_38 + (0.030239658430218697)*bt_g0_22;
    bt_l1_38 = bt_l1_38 + (-0.17187349498271942)*bt_g0_23;
    bt_l1_38 = bt_l1_38 + (0.13983376324176788)*bt_g0_24;
    bt_l1_38 = bt_l1_38 + (-0.53049486875534058)*bt_g0_25;
    bt_l1_38 = bt_l1_38 + (-0.15557342767715454)*bt_g0_26;
    bt_l1_38 = bt_l1_38 + (-0.11517713963985443)*bt_g0_27;
    bt_l1_38 = bt_l1_38 + (0.33121272921562195)*bt_g0_28;
    bt_l1_38 = bt_l1_38 + (-0.022952251136302948)*bt_g0_29;
    bt_l1_38 = bt_l1_38 + (0.020188702270388603)*bt_g0_30;
    bt_l1_38 = bt_l1_38 + (0.028189748525619507)*bt_g0_31;
    bt_l1_38 = bt_l1_38 + (0.14249736070632935)*bt_g0_32;
    bt_l1_38 = bt_l1_38 + (-0.093292929232120514)*bt_g0_33;
    bt_l1_38 = bt_l1_38 + (0.14450278878211975)*bt_g0_34;
    bt_l1_38 = bt_l1_38 + (0.17545123398303986)*bt_g0_35;
    bt_l1_38 = bt_l1_38 + (-0.1460435688495636)*bt_g0_36;
    bt_l1_38 = bt_l1_38 + (-0.10707582533359528)*bt_g0_37;
    bt_l1_38 = bt_l1_38 + (-0.022078057751059532)*bt_g0_38;
    bt_l1_38 = bt_l1_38 + (0.12239004671573639)*bt_g0_39;
    bt_l1_38 = bt_l1_38 + (0.091124430298805237)*bt_g0_40;
    bt_l1_38 = bt_l1_38 + (-0.027200587093830109)*bt_g0_41;
    bt_l1_38 = bt_l1_38 + (0.02023078128695488)*bt_g0_42;
    bt_l1_38 = bt_l1_38 + (0.0073774009943008423)*bt_g0_43;
    bt_l1_38 = bt_l1_38 + (0.10100396722555161)*bt_g0_44;
    bt_l1_38 = bt_l1_38 + (-0.014972615987062454)*bt_g0_45;
    bt_l1_38 = bt_l1_38 + (0.099161110818386078)*bt_g0_46;
    bt_l1_38 = bt_l1_38 + (0.13639688491821289)*bt_g0_47;
    bt_l1_38 = bt_l1_38 + (0.037817221134901047)*bt_g0_48;
    bt_l1_38 = bt_l1_38 + (0.15113931894302368)*bt_g0_49;
    bt_l1_38 = bt_l1_38 + (-0.16012114286422729)*bt_g0_50;
    bt_l1_38 = bt_l1_38 + (0.053262654691934586)*bt_g0_51;
    bt_l1_38 = bt_l1_38 + (-0.13259556889533997)*bt_g0_52;
    bt_l1_38 = bt_l1_38 + (0.094157382845878601)*bt_g0_53;
    bt_l1_38 = bt_l1_38 + (-0.1591501384973526)*bt_g0_54;
    bt_l1_38 = bt_l1_38 + (0.10692007094621658)*bt_g0_55;
    bt_l1_38 = bt_l1_38 + (0.0016158001963049173)*bt_g0_56;
    bt_l1_38 = bt_l1_38 + (-0.024884931743144989)*bt_g0_57;
    bt_l1_38 = bt_l1_38 + (0.054030444473028183)*bt_g0_58;
    bt_l1_38 = bt_l1_38 + (0.0030265660025179386)*bt_g0_59;
    bt_l1_38 = bt_l1_38 + (0.058049637824296951)*bt_g0_60;
    bt_l1_38 = bt_l1_38 + (0.027859508991241455)*bt_g0_61;
    bt_l1_38 = bt_l1_38 + (-0.26314601302146912)*bt_g0_62;
    bt_l1_38 = bt_l1_38 + (-0.064202748239040375)*bt_g0_63;
    bt_l1_39 = -0.036691963672637939;
    bt_l1_39 = bt_l1_39 + (0.15498088300228119)*bt_g0_0;
    bt_l1_39 = bt_l1_39 + (0.045005243271589279)*bt_g0_1;
    bt_l1_39 = bt_l1_39 + (0.0070181307382881641)*bt_g0_2;
    bt_l1_39 = bt_l1_39 + (0.031127806752920151)*bt_g0_3;
    bt_l1_39 = bt_l1_39 + (0.11615751683712006)*bt_g0_4;
    bt_l1_39 = bt_l1_39 + (-0.37408825755119324)*bt_g0_5;
    bt_l1_39 = bt_l1_39 + (-0.10252149403095245)*bt_g0_6;
    bt_l1_39 = bt_l1_39 + (-0.025579610839486122)*bt_g0_7;
    bt_l1_39 = bt_l1_39 + (0.0040246164426207542)*bt_g0_8;
    bt_l1_39 = bt_l1_39 + (-0.0041095991618931293)*bt_g0_9;
    bt_l1_39 = bt_l1_39 + (-0.093101963400840759)*bt_g0_10;
    bt_l1_39 = bt_l1_39 + (-0.0029614085797220469)*bt_g0_11;
    bt_l1_39 = bt_l1_39 + (-0.090441450476646423)*bt_g0_12;
    bt_l1_39 = bt_l1_39 + (-0.036933377385139465)*bt_g0_13;
    bt_l1_39 = bt_l1_39 + (-0.016898196190595627)*bt_g0_14;
    bt_l1_39 = bt_l1_39 + (-0.27522173523902893)*bt_g0_15;
    bt_l1_39 = bt_l1_39 + (-0.1257098913192749)*bt_g0_16;
    bt_l1_39 = bt_l1_39 + (-0.049365196377038956)*bt_g0_17;
    bt_l1_39 = bt_l1_39 + (0.085934102535247803)*bt_g0_18;
    bt_l1_39 = bt_l1_39 + (0.12577369809150696)*bt_g0_19;
    bt_l1_39 = bt_l1_39 + (0.069880470633506775)*bt_g0_20;
    bt_l1_39 = bt_l1_39 + (0.020844463258981705)*bt_g0_21;
    bt_l1_39 = bt_l1_39 + (-0.095891289412975311)*bt_g0_22;
    bt_l1_39 = bt_l1_39 + (0.096237748861312866)*bt_g0_23;
    bt_l1_39 = bt_l1_39 + (0.14797849953174591)*bt_g0_24;
    bt_l1_39 = bt_l1_39 + (-0.087605901062488556)*bt_g0_25;
    bt_l1_39 = bt_l1_39 + (-0.13897520303726196)*bt_g0_26;
    bt_l1_39 = bt_l1_39 + (-0.044925332069396973)*bt_g0_27;
    bt_l1_39 = bt_l1_39 + (0.20271956920623779)*bt_g0_28;
    bt_l1_39 = bt_l1_39 + (0.10184628516435623)*bt_g0_29;
    bt_l1_39 = bt_l1_39 + (0.14706236124038696)*bt_g0_30;
    bt_l1_39 = bt_l1_39 + (0.11272569745779037)*bt_g0_31;
    bt_l1_39 = bt_l1_39 + (0.10630642622709274)*bt_g0_32;
    bt_l1_39 = bt_l1_39 + (0.0039782822132110596)*bt_g0_33;
    bt_l1_39 = bt_l1_39 + (-0.082577534019947052)*bt_g0_34;
    bt_l1_39 = bt_l1_39 + (0.0017224778421223164)*bt_g0_35;
    bt_l1_39 = bt_l1_39 + (-0.078452862799167633)*bt_g0_36;
    bt_l1_39 = bt_l1_39 + (0.00064271624432876706)*bt_g0_37;
    bt_l1_39 = bt_l1_39 + (-0.21951942145824432)*bt_g0_38;
    bt_l1_39 = bt_l1_39 + (0.029930004850029945)*bt_g0_39;
    bt_l1_39 = bt_l1_39 + (-0.029728686437010765)*bt_g0_40;
    bt_l1_39 = bt_l1_39 + (0.13043436408042908)*bt_g0_41;
    bt_l1_39 = bt_l1_39 + (0.006368094589561224)*bt_g0_42;
    bt_l1_39 = bt_l1_39 + (0.076882347464561462)*bt_g0_43;
    bt_l1_39 = bt_l1_39 + (0.068558812141418457)*bt_g0_44;
    bt_l1_39 = bt_l1_39 + (0.16203579306602478)*bt_g0_45;
    bt_l1_39 = bt_l1_39 + (0.081952393054962158)*bt_g0_46;
    bt_l1_39 = bt_l1_39 + (0.040037345141172409)*bt_g0_47;
    bt_l1_39 = bt_l1_39 + (0.0014778615441173315)*bt_g0_48;
    bt_l1_39 = bt_l1_39 + (-0.06660325825214386)*bt_g0_49;
    bt_l1_39 = bt_l1_39 + (-0.11214029043912888)*bt_g0_50;
    bt_l1_39 = bt_l1_39 + (0.039915721863508224)*bt_g0_51;
    bt_l1_39 = bt_l1_39 + (0.068381242454051971)*bt_g0_52;
    bt_l1_39 = bt_l1_39 + (0.0061029819771647453)*bt_g0_53;
    bt_l1_39 = bt_l1_39 + (0.0057442509569227695)*bt_g0_54;
    bt_l1_39 = bt_l1_39 + (0.15633414685726166)*bt_g0_55;
    bt_l1_39 = bt_l1_39 + (-0.026677943766117096)*bt_g0_56;
    bt_l1_39 = bt_l1_39 + (0.045672673732042313)*bt_g0_57;
    bt_l1_39 = bt_l1_39 + (-0.18833671510219574)*bt_g0_58;
    bt_l1_39 = bt_l1_39 + (0.024956954643130302)*bt_g0_59;
    bt_l1_39 = bt_l1_39 + (-0.017761630937457085)*bt_g0_60;
    bt_l1_39 = bt_l1_39 + (-0.1620500236749649)*bt_g0_61;
    bt_l1_39 = bt_l1_39 + (-0.31038951873779297)*bt_g0_62;
    bt_l1_39 = bt_l1_39 + (0.03675229474902153)*bt_g0_63;
    bt_l1_40 = -0.0030674724839627743;
    bt_l1_40 = bt_l1_40 + (-0.046686094254255295)*bt_g0_0;
    bt_l1_40 = bt_l1_40 + (0.012303557246923447)*bt_g0_1;
    bt_l1_40 = bt_l1_40 + (0.026159396395087242)*bt_g0_2;
    bt_l1_40 = bt_l1_40 + (0.087444037199020386)*bt_g0_3;
    bt_l1_40 = bt_l1_40 + (0.024929150938987732)*bt_g0_4;
    bt_l1_40 = bt_l1_40 + (-0.17034976184368134)*bt_g0_5;
    bt_l1_40 = bt_l1_40 + (0.048206806182861328)*bt_g0_6;
    bt_l1_40 = bt_l1_40 + (-0.10981472581624985)*bt_g0_7;
    bt_l1_40 = bt_l1_40 + (0.19125401973724365)*bt_g0_8;
    bt_l1_40 = bt_l1_40 + (0.09274987131357193)*bt_g0_9;
    bt_l1_40 = bt_l1_40 + (-0.094260275363922119)*bt_g0_10;
    bt_l1_40 = bt_l1_40 + (0.16176259517669678)*bt_g0_11;
    bt_l1_40 = bt_l1_40 + (-0.089716993272304535)*bt_g0_12;
    bt_l1_40 = bt_l1_40 + (-0.0028435338754206896)*bt_g0_13;
    bt_l1_40 = bt_l1_40 + (-0.016631688922643661)*bt_g0_14;
    bt_l1_40 = bt_l1_40 + (-0.16202919185161591)*bt_g0_15;
    bt_l1_40 = bt_l1_40 + (-0.083014972507953644)*bt_g0_16;
    bt_l1_40 = bt_l1_40 + (0.095801472663879395)*bt_g0_17;
    bt_l1_40 = bt_l1_40 + (0.14541782438755035)*bt_g0_18;
    bt_l1_40 = bt_l1_40 + (-0.03376166895031929)*bt_g0_19;
    bt_l1_40 = bt_l1_40 + (-0.17599424719810486)*bt_g0_20;
    bt_l1_40 = bt_l1_40 + (-0.012318995781242847)*bt_g0_21;
    bt_l1_40 = bt_l1_40 + (0.097811676561832428)*bt_g0_22;
    bt_l1_40 = bt_l1_40 + (0.12622693181037903)*bt_g0_23;
    bt_l1_40 = bt_l1_40 + (0.080953069031238556)*bt_g0_24;
    bt_l1_40 = bt_l1_40 + (-0.18481080234050751)*bt_g0_25;
    bt_l1_40 = bt_l1_40 + (-0.11026389896869659)*bt_g0_26;
    bt_l1_40 = bt_l1_40 + (-0.10767374932765961)*bt_g0_27;
    bt_l1_40 = bt_l1_40 + (-0.40910395979881287)*bt_g0_28;
    bt_l1_40 = bt_l1_40 + (-0.068154968321323395)*bt_g0_29;
    bt_l1_40 = bt_l1_40 + (0.08565734326839447)*bt_g0_30;
    bt_l1_40 = bt_l1_40 + (-0.027681769803166389)*bt_g0_31;
    bt_l1_40 = bt_l1_40 + (-0.31607255339622498)*bt_g0_32;
    bt_l1_40 = bt_l1_40 + (-0.1222783550620079)*bt_g0_33;
    bt_l1_40 = bt_l1_40 + (-0.053257912397384644)*bt_g0_34;
    bt_l1_40 = bt_l1_40 + (0.020962439477443695)*bt_g0_35;
    bt_l1_40 = bt_l1_40 + (0.14314240217208862)*bt_g0_36;
    bt_l1_40 = bt_l1_40 + (0.23476439714431763)*bt_g0_37;
    bt_l1_40 = bt_l1_40 + (0.091049790382385254)*bt_g0_38;
    bt_l1_40 = bt_l1_40 + (-0.24495235085487366)*bt_g0_39;
    bt_l1_40 = bt_l1_40 + (0.10472223162651062)*bt_g0_40;
    bt_l1_40 = bt_l1_40 + (-0.0010937822517007589)*bt_g0_41;
    bt_l1_40 = bt_l1_40 + (0.12748768925666809)*bt_g0_42;
    bt_l1_40 = bt_l1_40 + (-0.057248897850513458)*bt_g0_43;
    bt_l1_40 = bt_l1_40 + (0.042237155139446259)*bt_g0_44;
    bt_l1_40 = bt_l1_40 + (-0.07346971333026886)*bt_g0_45;
    bt_l1_40 = bt_l1_40 + (-0.067107796669006348)*bt_g0_46;
    bt_l1_40 = bt_l1_40 + (-0.074287675321102142)*bt_g0_47;
    bt_l1_40 = bt_l1_40 + (0.012375097721815109)*bt_g0_48;
    bt_l1_40 = bt_l1_40 + (-0.00081576954107731581)*bt_g0_49;
    bt_l1_40 = bt_l1_40 + (0.15650175511837006)*bt_g0_50;
    bt_l1_40 = bt_l1_40 + (-0.097912877798080444)*bt_g0_51;
    bt_l1_40 = bt_l1_40 + (0.091442368924617767)*bt_g0_52;
    bt_l1_40 = bt_l1_40 + (-0.068952098488807678)*bt_g0_53;
    bt_l1_40 = bt_l1_40 + (-0.098732486367225647)*bt_g0_54;
    bt_l1_40 = bt_l1_40 + (0.0086373221129179001)*bt_g0_55;
    bt_l1_40 = bt_l1_40 + (-0.0089106010273098946)*bt_g0_56;
    bt_l1_40 = bt_l1_40 + (0.16484643518924713)*bt_g0_57;
    bt_l1_40 = bt_l1_40 + (-0.051408637315034866)*bt_g0_58;
    bt_l1_40 = bt_l1_40 + (0.10722299665212631)*bt_g0_59;
    bt_l1_40 = bt_l1_40 + (-0.12714673578739166)*bt_g0_60;
    bt_l1_40 = bt_l1_40 + (0.12752431631088257)*bt_g0_61;
    bt_l1_40 = bt_l1_40 + (-0.095519937574863434)*bt_g0_62;
    bt_l1_40 = bt_l1_40 + (-0.040144111961126328)*bt_g0_63;
    bt_l1_41 = -0.081503294408321381;
    bt_l1_41 = bt_l1_41 + (-0.038089092820882797)*bt_g0_0;
    bt_l1_41 = bt_l1_41 + (-0.2087445855140686)*bt_g0_1;
    bt_l1_41 = bt_l1_41 + (-0.018715538084506989)*bt_g0_2;
    bt_l1_41 = bt_l1_41 + (-0.042494814842939377)*bt_g0_3;
    bt_l1_41 = bt_l1_41 + (-0.0026472129393368959)*bt_g0_4;
    bt_l1_41 = bt_l1_41 + (0.35128629207611084)*bt_g0_5;
    bt_l1_41 = bt_l1_41 + (0.0016900432528927922)*bt_g0_6;
    bt_l1_41 = bt_l1_41 + (0.65566271543502808)*bt_g0_7;
    bt_l1_41 = bt_l1_41 + (0.072198420763015747)*bt_g0_8;
    bt_l1_41 = bt_l1_41 + (-0.092468351125717163)*bt_g0_9;
    bt_l1_41 = bt_l1_41 + (-0.085141532123088837)*bt_g0_10;
    bt_l1_41 = bt_l1_41 + (0.14861413836479187)*bt_g0_11;
    bt_l1_41 = bt_l1_41 + (0.11991403996944427)*bt_g0_12;
    bt_l1_41 = bt_l1_41 + (-0.087948650121688843)*bt_g0_13;
    bt_l1_41 = bt_l1_41 + (0.21011060476303101)*bt_g0_14;
    bt_l1_41 = bt_l1_41 + (0.30028480291366577)*bt_g0_15;
    bt_l1_41 = bt_l1_41 + (0.24794290959835052)*bt_g0_16;
    bt_l1_41 = bt_l1_41 + (-0.036183521151542664)*bt_g0_17;
    bt_l1_41 = bt_l1_41 + (-0.29399135708808899)*bt_g0_18;
    bt_l1_41 = bt_l1_41 + (0.060911413282155991)*bt_g0_19;
    bt_l1_41 = bt_l1_41 + (0.0013624586863443255)*bt_g0_20;
    bt_l1_41 = bt_l1_41 + (-0.055767577141523361)*bt_g0_21;
    bt_l1_41 = bt_l1_41 + (-0.15940408408641815)*bt_g0_22;
    bt_l1_41 = bt_l1_41 + (0.23011557757854462)*bt_g0_23;
    bt_l1_41 = bt_l1_41 + (0.17619530856609344)*bt_g0_24;
    bt_l1_41 = bt_l1_41 + (-0.36275538802146912)*bt_g0_25;
    bt_l1_41 = bt_l1_41 + (-0.035711631178855896)*bt_g0_26;
    bt_l1_41 = bt_l1_41 + (0.52440023422241211)*bt_g0_27;
    bt_l1_41 = bt_l1_41 + (-0.051664222031831741)*bt_g0_28;
    bt_l1_41 = bt_l1_41 + (-0.12808780372142792)*bt_g0_29;
    bt_l1_41 = bt_l1_41 + (-0.025578685104846954)*bt_g0_30;
    bt_l1_41 = bt_l1_41 + (-0.15913508832454681)*bt_g0_31;
    bt_l1_41 = bt_l1_41 + (0.7405814528465271)*bt_g0_32;
    bt_l1_41 = bt_l1_41 + (-0.12068945914506912)*bt_g0_33;
    bt_l1_41 = bt_l1_41 + (-0.13793030381202698)*bt_g0_34;
    bt_l1_41 = bt_l1_41 + (-0.059513837099075317)*bt_g0_35;
    bt_l1_41 = bt_l1_41 + (-0.027043856680393219)*bt_g0_36;
    bt_l1_41 = bt_l1_41 + (0.2852540910243988)*bt_g0_37;
    bt_l1_41 = bt_l1_41 + (0.17085060477256775)*bt_g0_38;
    bt_l1_41 = bt_l1_41 + (-0.11703340709209442)*bt_g0_39;
    bt_l1_41 = bt_l1_41 + (0.030504131689667702)*bt_g0_40;
    bt_l1_41 = bt_l1_41 + (0.0089141642674803734)*bt_g0_41;
    bt_l1_41 = bt_l1_41 + (-0.049970634281635284)*bt_g0_42;
    bt_l1_41 = bt_l1_41 + (-0.01715453714132309)*bt_g0_43;
    bt_l1_41 = bt_l1_41 + (0.28764888644218445)*bt_g0_44;
    bt_l1_41 = bt_l1_41 + (-0.14587345719337463)*bt_g0_45;
    bt_l1_41 = bt_l1_41 + (-0.018000228330492973)*bt_g0_46;
    bt_l1_41 = bt_l1_41 + (0.03088553249835968)*bt_g0_47;
    bt_l1_41 = bt_l1_41 + (-0.11247283220291138)*bt_g0_48;
    bt_l1_41 = bt_l1_41 + (-0.0055532264523208141)*bt_g0_49;
    bt_l1_41 = bt_l1_41 + (0.096208095550537109)*bt_g0_50;
    bt_l1_41 = bt_l1_41 + (0.18034613132476807)*bt_g0_51;
    bt_l1_41 = bt_l1_41 + (0.21358476579189301)*bt_g0_52;
    bt_l1_41 = bt_l1_41 + (-0.099099524319171906)*bt_g0_53;
    bt_l1_41 = bt_l1_41 + (-0.11588749289512634)*bt_g0_54;
    bt_l1_41 = bt_l1_41 + (0.17373265326023102)*bt_g0_55;
    bt_l1_41 = bt_l1_41 + (0.1269451379776001)*bt_g0_56;
    bt_l1_41 = bt_l1_41 + (0.15131446719169617)*bt_g0_57;
    bt_l1_41 = bt_l1_41 + (0.18876555562019348)*bt_g0_58;
    bt_l1_41 = bt_l1_41 + (-0.060434132814407349)*bt_g0_59;
    bt_l1_41 = bt_l1_41 + (-0.090191066265106201)*bt_g0_60;
    bt_l1_41 = bt_l1_41 + (0.035714134573936462)*bt_g0_61;
    bt_l1_41 = bt_l1_41 + (0.0011477161897346377)*bt_g0_62;
    bt_l1_41 = bt_l1_41 + (0.10184013843536377)*bt_g0_63;
    bt_l1_42 = -0.06412043422460556;
    bt_l1_42 = bt_l1_42 + (0.071924097836017609)*bt_g0_0;
    bt_l1_42 = bt_l1_42 + (-0.028274858370423317)*bt_g0_1;
    bt_l1_42 = bt_l1_42 + (0.088867790997028351)*bt_g0_2;
    bt_l1_42 = bt_l1_42 + (-0.11132869124412537)*bt_g0_3;
    bt_l1_42 = bt_l1_42 + (-0.070031732320785522)*bt_g0_4;
    bt_l1_42 = bt_l1_42 + (0.095604576170444489)*bt_g0_5;
    bt_l1_42 = bt_l1_42 + (0.01025355514138937)*bt_g0_6;
    bt_l1_42 = bt_l1_42 + (0.0024483385495841503)*bt_g0_7;
    bt_l1_42 = bt_l1_42 + (-0.16078552603721619)*bt_g0_8;
    bt_l1_42 = bt_l1_42 + (-0.16231347620487213)*bt_g0_9;
    bt_l1_42 = bt_l1_42 + (0.10933559387922287)*bt_g0_10;
    bt_l1_42 = bt_l1_42 + (-0.0082585876807570457)*bt_g0_11;
    bt_l1_42 = bt_l1_42 + (-0.0061991680413484573)*bt_g0_12;
    bt_l1_42 = bt_l1_42 + (0.11455012857913971)*bt_g0_13;
    bt_l1_42 = bt_l1_42 + (0.058213308453559875)*bt_g0_14;
    bt_l1_42 = bt_l1_42 + (-0.26738926768302917)*bt_g0_15;
    bt_l1_42 = bt_l1_42 + (0.04931950569152832)*bt_g0_16;
    bt_l1_42 = bt_l1_42 + (-0.076239772140979767)*bt_g0_17;
    bt_l1_42 = bt_l1_42 + (-0.0072433403693139553)*bt_g0_18;
    bt_l1_42 = bt_l1_42 + (-0.040048271417617798)*bt_g0_19;
    bt_l1_42 = bt_l1_42 + (-0.036605704575777054)*bt_g0_20;
    bt_l1_42 = bt_l1_42 + (-0.014927038922905922)*bt_g0_21;
    bt_l1_42 = bt_l1_42 + (-0.11001632362604141)*bt_g0_22;
    bt_l1_42 = bt_l1_42 + (0.11355409771203995)*bt_g0_23;
    bt_l1_42 = bt_l1_42 + (0.076522201299667358)*bt_g0_24;
    bt_l1_42 = bt_l1_42 + (0.09120381623506546)*bt_g0_25;
    bt_l1_42 = bt_l1_42 + (-0.1270807683467865)*bt_g0_26;
    bt_l1_42 = bt_l1_42 + (0.13386832177639008)*bt_g0_27;
    bt_l1_42 = bt_l1_42 + (-0.047320060431957245)*bt_g0_28;
    bt_l1_42 = bt_l1_42 + (0.043146718293428421)*bt_g0_29;
    bt_l1_42 = bt_l1_42 + (0.08615247905254364)*bt_g0_30;
    bt_l1_42 = bt_l1_42 + (0.030193252488970757)*bt_g0_31;
    bt_l1_42 = bt_l1_42 + (0.11136342585086823)*bt_g0_32;
    bt_l1_42 = bt_l1_42 + (-0.15939418971538544)*bt_g0_33;
    bt_l1_42 = bt_l1_42 + (-0.09291452169418335)*bt_g0_34;
    bt_l1_42 = bt_l1_42 + (0.076369836926460266)*bt_g0_35;
    bt_l1_42 = bt_l1_42 + (-0.24521885812282562)*bt_g0_36;
    bt_l1_42 = bt_l1_42 + (-0.021040074527263641)*bt_g0_37;
    bt_l1_42 = bt_l1_42 + (-0.13195830583572388)*bt_g0_38;
    bt_l1_42 = bt_l1_42 + (0.017127547413110733)*bt_g0_39;
    bt_l1_42 = bt_l1_42 + (0.13557158410549164)*bt_g0_40;
    bt_l1_42 = bt_l1_42 + (-0.10069173574447632)*bt_g0_41;
    bt_l1_42 = bt_l1_42 + (-0.20924940705299377)*bt_g0_42;
    bt_l1_42 = bt_l1_42 + (-0.0071273050270974636)*bt_g0_43;
    bt_l1_42 = bt_l1_42 + (0.16345848143100739)*bt_g0_44;
    bt_l1_42 = bt_l1_42 + (0.071785405278205872)*bt_g0_45;
    bt_l1_42 = bt_l1_42 + (0.00049615890020504594)*bt_g0_46;
    bt_l1_42 = bt_l1_42 + (0.071105159819126129)*bt_g0_47;
    bt_l1_42 = bt_l1_42 + (0.14462384581565857)*bt_g0_48;
    bt_l1_42 = bt_l1_42 + (0.24642601609230042)*bt_g0_49;
    bt_l1_42 = bt_l1_42 + (-0.044749919325113297)*bt_g0_50;
    bt_l1_42 = bt_l1_42 + (0.011719276197254658)*bt_g0_51;
    bt_l1_42 = bt_l1_42 + (0.11520598828792572)*bt_g0_52;
    bt_l1_42 = bt_l1_42 + (0.067440792918205261)*bt_g0_53;
    bt_l1_42 = bt_l1_42 + (0.1137281134724617)*bt_g0_54;
    bt_l1_42 = bt_l1_42 + (0.15167984366416931)*bt_g0_55;
    bt_l1_42 = bt_l1_42 + (0.020899098366498947)*bt_g0_56;
    bt_l1_42 = bt_l1_42 + (0.084630273282527924)*bt_g0_57;
    bt_l1_42 = bt_l1_42 + (-0.32084697484970093)*bt_g0_58;
    bt_l1_42 = bt_l1_42 + (-0.21385185420513153)*bt_g0_59;
    bt_l1_42 = bt_l1_42 + (-0.068880774080753326)*bt_g0_60;
    bt_l1_42 = bt_l1_42 + (-0.001536789583042264)*bt_g0_61;
    bt_l1_42 = bt_l1_42 + (-0.37410736083984375)*bt_g0_62;
    bt_l1_42 = bt_l1_42 + (0.080039806663990021)*bt_g0_63;
    bt_l1_43 = 0.03774397075176239;
    bt_l1_43 = bt_l1_43 + (-0.084948576986789703)*bt_g0_0;
    bt_l1_43 = bt_l1_43 + (-0.12399633228778839)*bt_g0_1;
    bt_l1_43 = bt_l1_43 + (0.13658466935157776)*bt_g0_2;
    bt_l1_43 = bt_l1_43 + (0.031141351908445358)*bt_g0_3;
    bt_l1_43 = bt_l1_43 + (-0.18806229531764984)*bt_g0_4;
    bt_l1_43 = bt_l1_43 + (-0.12974578142166138)*bt_g0_5;
    bt_l1_43 = bt_l1_43 + (0.044080287218093872)*bt_g0_6;
    bt_l1_43 = bt_l1_43 + (0.1115812212228775)*bt_g0_7;
    bt_l1_43 = bt_l1_43 + (0.067429110407829285)*bt_g0_8;
    bt_l1_43 = bt_l1_43 + (-0.03555786982178688)*bt_g0_9;
    bt_l1_43 = bt_l1_43 + (-0.10110607743263245)*bt_g0_10;
    bt_l1_43 = bt_l1_43 + (-0.088870644569396973)*bt_g0_11;
    bt_l1_43 = bt_l1_43 + (-0.0030079006683081388)*bt_g0_12;
    bt_l1_43 = bt_l1_43 + (0.11497006565332413)*bt_g0_13;
    bt_l1_43 = bt_l1_43 + (-0.065567977726459503)*bt_g0_14;
    bt_l1_43 = bt_l1_43 + (0.080759428441524506)*bt_g0_15;
    bt_l1_43 = bt_l1_43 + (-0.056708604097366333)*bt_g0_16;
    bt_l1_43 = bt_l1_43 + (0.1224823072552681)*bt_g0_17;
    bt_l1_43 = bt_l1_43 + (-0.0095109473913908005)*bt_g0_18;
    bt_l1_43 = bt_l1_43 + (-0.065436936914920807)*bt_g0_19;
    bt_l1_43 = bt_l1_43 + (0.27602735161781311)*bt_g0_20;
    bt_l1_43 = bt_l1_43 + (0.074335671961307526)*bt_g0_21;
    bt_l1_43 = bt_l1_43 + (0.012446966953575611)*bt_g0_22;
    bt_l1_43 = bt_l1_43 + (-0.0019342310260981321)*bt_g0_23;
    bt_l1_43 = bt_l1_43 + (0.25005632638931274)*bt_g0_24;
    bt_l1_43 = bt_l1_43 + (0.15867488086223602)*bt_g0_25;
    bt_l1_43 = bt_l1_43 + (-0.0441591776907444)*bt_g0_26;
    bt_l1_43 = bt_l1_43 + (0.051639016717672348)*bt_g0_27;
    bt_l1_43 = bt_l1_43 + (0.32826969027519226)*bt_g0_28;
    bt_l1_43 = bt_l1_43 + (-0.0052977362647652626)*bt_g0_29;
    bt_l1_43 = bt_l1_43 + (-0.13322217762470245)*bt_g0_30;
    bt_l1_43 = bt_l1_43 + (0.075463384389877319)*bt_g0_31;
    bt_l1_43 = bt_l1_43 + (0.10388723015785217)*bt_g0_32;
    bt_l1_43 = bt_l1_43 + (-0.098777554929256439)*bt_g0_33;
    bt_l1_43 = bt_l1_43 + (-0.04198877140879631)*bt_g0_34;
    bt_l1_43 = bt_l1_43 + (0.070386290550231934)*bt_g0_35;
    bt_l1_43 = bt_l1_43 + (0.067730247974395752)*bt_g0_36;
    bt_l1_43 = bt_l1_43 + (0.22459676861763)*bt_g0_37;
    bt_l1_43 = bt_l1_43 + (0.036448277533054352)*bt_g0_38;
    bt_l1_43 = bt_l1_43 + (0.62359297275543213)*bt_g0_39;
    bt_l1_43 = bt_l1_43 + (-0.18244940042495728)*bt_g0_40;
    bt_l1_43 = bt_l1_43 + (-0.031343515962362289)*bt_g0_41;
    bt_l1_43 = bt_l1_43 + (0.063004344701766968)*bt_g0_42;
    bt_l1_43 = bt_l1_43 + (0.10590066015720367)*bt_g0_43;
    bt_l1_43 = bt_l1_43 + (0.023119546473026276)*bt_g0_44;
    bt_l1_43 = bt_l1_43 + (-0.10362484306097031)*bt_g0_45;
    bt_l1_43 = bt_l1_43 + (-0.13447807729244232)*bt_g0_46;
    bt_l1_43 = bt_l1_43 + (0.12865892052650452)*bt_g0_47;
    bt_l1_43 = bt_l1_43 + (-0.015742730349302292)*bt_g0_48;
    bt_l1_43 = bt_l1_43 + (0.014679513871669769)*bt_g0_49;
    bt_l1_43 = bt_l1_43 + (-0.18598996102809906)*bt_g0_50;
    bt_l1_43 = bt_l1_43 + (0.10571587830781937)*bt_g0_51;
    bt_l1_43 = bt_l1_43 + (-0.015266894362866879)*bt_g0_52;
    bt_l1_43 = bt_l1_43 + (-0.054356660693883896)*bt_g0_53;
    bt_l1_43 = bt_l1_43 + (0.054728779941797256)*bt_g0_54;
    bt_l1_43 = bt_l1_43 + (-0.044481027871370316)*bt_g0_55;
    bt_l1_43 = bt_l1_43 + (-0.06427406519651413)*bt_g0_56;
    bt_l1_43 = bt_l1_43 + (0.04206419363617897)*bt_g0_57;
    bt_l1_43 = bt_l1_43 + (0.15267771482467651)*bt_g0_58;
    bt_l1_43 = bt_l1_43 + (-0.020117314532399178)*bt_g0_59;
    bt_l1_43 = bt_l1_43 + (-0.09242655336856842)*bt_g0_60;
    bt_l1_43 = bt_l1_43 + (0.082443073391914368)*bt_g0_61;
    bt_l1_43 = bt_l1_43 + (0.061388634145259857)*bt_g0_62;
    bt_l1_43 = bt_l1_43 + (-0.062632575631141663)*bt_g0_63;
    bt_l1_44 = 0.093634657561779022;
    bt_l1_44 = bt_l1_44 + (-0.08607444167137146)*bt_g0_0;
    bt_l1_44 = bt_l1_44 + (-0.24499417841434479)*bt_g0_1;
    bt_l1_44 = bt_l1_44 + (-0.032861419022083282)*bt_g0_2;
    bt_l1_44 = bt_l1_44 + (0.040947213768959045)*bt_g0_3;
    bt_l1_44 = bt_l1_44 + (0.10058107972145081)*bt_g0_4;
    bt_l1_44 = bt_l1_44 + (-0.046752195805311203)*bt_g0_5;
    bt_l1_44 = bt_l1_44 + (-0.22618290781974792)*bt_g0_6;
    bt_l1_44 = bt_l1_44 + (0.10162114351987839)*bt_g0_7;
    bt_l1_44 = bt_l1_44 + (0.092919476330280304)*bt_g0_8;
    bt_l1_44 = bt_l1_44 + (-0.0060330838896334171)*bt_g0_9;
    bt_l1_44 = bt_l1_44 + (0.028050482273101807)*bt_g0_10;
    bt_l1_44 = bt_l1_44 + (0.074589632451534271)*bt_g0_11;
    bt_l1_44 = bt_l1_44 + (-0.1045500636100769)*bt_g0_12;
    bt_l1_44 = bt_l1_44 + (0.052563238888978958)*bt_g0_13;
    bt_l1_44 = bt_l1_44 + (0.087865948677062988)*bt_g0_14;
    bt_l1_44 = bt_l1_44 + (0.27669849991798401)*bt_g0_15;
    bt_l1_44 = bt_l1_44 + (0.10451549291610718)*bt_g0_16;
    bt_l1_44 = bt_l1_44 + (0.11637745052576065)*bt_g0_17;
    bt_l1_44 = bt_l1_44 + (0.056968674063682556)*bt_g0_18;
    bt_l1_44 = bt_l1_44 + (-0.092355050146579742)*bt_g0_19;
    bt_l1_44 = bt_l1_44 + (0.12537845969200134)*bt_g0_20;
    bt_l1_44 = bt_l1_44 + (0.004102678969502449)*bt_g0_21;
    bt_l1_44 = bt_l1_44 + (-0.25329881906509399)*bt_g0_22;
    bt_l1_44 = bt_l1_44 + (0.037439022213220596)*bt_g0_23;
    bt_l1_44 = bt_l1_44 + (0.27390748262405396)*bt_g0_24;
    bt_l1_44 = bt_l1_44 + (-0.13638855516910553)*bt_g0_25;
    bt_l1_44 = bt_l1_44 + (0.14443740248680115)*bt_g0_26;
    bt_l1_44 = bt_l1_44 + (0.023298054933547974)*bt_g0_27;
    bt_l1_44 = bt_l1_44 + (0.35591694712638855)*bt_g0_28;
    bt_l1_44 = bt_l1_44 + (-0.10971450060606003)*bt_g0_29;
    bt_l1_44 = bt_l1_44 + (0.027806302532553673)*bt_g0_30;
    bt_l1_44 = bt_l1_44 + (0.095572382211685181)*bt_g0_31;
    bt_l1_44 = bt_l1_44 + (0.030429892241954803)*bt_g0_32;
    bt_l1_44 = bt_l1_44 + (-0.30340752005577087)*bt_g0_33;
    bt_l1_44 = bt_l1_44 + (0.03108779713511467)*bt_g0_34;
    bt_l1_44 = bt_l1_44 + (0.17261230945587158)*bt_g0_35;
    bt_l1_44 = bt_l1_44 + (0.20696982741355896)*bt_g0_36;
    bt_l1_44 = bt_l1_44 + (0.24853417277336121)*bt_g0_37;
    bt_l1_44 = bt_l1_44 + (0.075362063944339752)*bt_g0_38;
    bt_l1_44 = bt_l1_44 + (0.067530877888202667)*bt_g0_39;
    bt_l1_44 = bt_l1_44 + (-0.18033622205257416)*bt_g0_40;
    bt_l1_44 = bt_l1_44 + (0.10169400274753571)*bt_g0_41;
    bt_l1_44 = bt_l1_44 + (0.024060957133769989)*bt_g0_42;
    bt_l1_44 = bt_l1_44 + (0.055498562753200531)*bt_g0_43;
    bt_l1_44 = bt_l1_44 + (-0.38508075475692749)*bt_g0_44;
    bt_l1_44 = bt_l1_44 + (-0.1643594354391098)*bt_g0_45;
    bt_l1_44 = bt_l1_44 + (-0.14524520933628082)*bt_g0_46;
    bt_l1_44 = bt_l1_44 + (0.065941989421844482)*bt_g0_47;
    bt_l1_44 = bt_l1_44 + (-0.26508229970932007)*bt_g0_48;
    bt_l1_44 = bt_l1_44 + (0.22228449583053589)*bt_g0_49;
    bt_l1_44 = bt_l1_44 + (-0.073100954294204712)*bt_g0_50;
    bt_l1_44 = bt_l1_44 + (-0.1044619232416153)*bt_g0_51;
    bt_l1_44 = bt_l1_44 + (-0.17960342764854431)*bt_g0_52;
    bt_l1_44 = bt_l1_44 + (-0.035480037331581116)*bt_g0_53;
    bt_l1_44 = bt_l1_44 + (-0.065351396799087524)*bt_g0_54;
    bt_l1_44 = bt_l1_44 + (-0.14436061680316925)*bt_g0_55;
    bt_l1_44 = bt_l1_44 + (-0.10143862664699554)*bt_g0_56;
    bt_l1_44 = bt_l1_44 + (-0.030607922002673149)*bt_g0_57;
    bt_l1_44 = bt_l1_44 + (0.17543438076972961)*bt_g0_58;
    bt_l1_44 = bt_l1_44 + (0.029296441003680229)*bt_g0_59;
    bt_l1_44 = bt_l1_44 + (-0.042686212807893753)*bt_g0_60;
    bt_l1_44 = bt_l1_44 + (0.2488631010055542)*bt_g0_61;
    bt_l1_44 = bt_l1_44 + (0.28898641467094421)*bt_g0_62;
    bt_l1_44 = bt_l1_44 + (-0.024091679602861404)*bt_g0_63;
    bt_l1_45 = 0.046010173857212067;
    bt_l1_45 = bt_l1_45 + (0.03951679915189743)*bt_g0_0;
    bt_l1_45 = bt_l1_45 + (-0.047331236302852631)*bt_g0_1;
    bt_l1_45 = bt_l1_45 + (-0.074249535799026489)*bt_g0_2;
    bt_l1_45 = bt_l1_45 + (0.03306521475315094)*bt_g0_3;
    bt_l1_45 = bt_l1_45 + (0.097132444381713867)*bt_g0_4;
    bt_l1_45 = bt_l1_45 + (0.087647676467895508)*bt_g0_5;
    bt_l1_45 = bt_l1_45 + (-0.083059348165988922)*bt_g0_6;
    bt_l1_45 = bt_l1_45 + (-0.10732502490282059)*bt_g0_7;
    bt_l1_45 = bt_l1_45 + (0.018177904188632965)*bt_g0_8;
    bt_l1_45 = bt_l1_45 + (0.098881244659423828)*bt_g0_9;
    bt_l1_45 = bt_l1_45 + (0.081810198724269867)*bt_g0_10;
    bt_l1_45 = bt_l1_45 + (-0.03265877440571785)*bt_g0_11;
    bt_l1_45 = bt_l1_45 + (0.092142373323440552)*bt_g0_12;
    bt_l1_45 = bt_l1_45 + (-0.061719752848148346)*bt_g0_13;
    bt_l1_45 = bt_l1_45 + (0.10204526036977768)*bt_g0_14;
    bt_l1_45 = bt_l1_45 + (-0.090791068971157074)*bt_g0_15;
    bt_l1_45 = bt_l1_45 + (0.082265585660934448)*bt_g0_16;
    bt_l1_45 = bt_l1_45 + (0.003636291716247797)*bt_g0_17;
    bt_l1_45 = bt_l1_45 + (0.15121215581893921)*bt_g0_18;
    bt_l1_45 = bt_l1_45 + (0.050929270684719086)*bt_g0_19;
    bt_l1_45 = bt_l1_45 + (0.036950249224901199)*bt_g0_20;
    bt_l1_45 = bt_l1_45 + (0.03893006220459938)*bt_g0_21;
    bt_l1_45 = bt_l1_45 + (-0.053148649632930756)*bt_g0_22;
    bt_l1_45 = bt_l1_45 + (-0.17068709433078766)*bt_g0_23;
    bt_l1_45 = bt_l1_45 + (-0.11373548209667206)*bt_g0_24;
    bt_l1_45 = bt_l1_45 + (-0.026601558551192284)*bt_g0_25;
    bt_l1_45 = bt_l1_45 + (0.017077403143048286)*bt_g0_26;
    bt_l1_45 = bt_l1_45 + (-0.043100927025079727)*bt_g0_27;
    bt_l1_45 = bt_l1_45 + (-0.04021114856004715)*bt_g0_28;
    bt_l1_45 = bt_l1_45 + (0.014943510293960571)*bt_g0_29;
    bt_l1_45 = bt_l1_45 + (0.14804749190807343)*bt_g0_30;
    bt_l1_45 = bt_l1_45 + (0.11145292967557907)*bt_g0_31;
    bt_l1_45 = bt_l1_45 + (-0.091322697699069977)*bt_g0_32;
    bt_l1_45 = bt_l1_45 + (-0.064700670540332794)*bt_g0_33;
    bt_l1_45 = bt_l1_45 + (0.026473533362150192)*bt_g0_34;
    bt_l1_45 = bt_l1_45 + (-0.10715700685977936)*bt_g0_35;
    bt_l1_45 = bt_l1_45 + (-0.1739010363817215)*bt_g0_36;
    bt_l1_45 = bt_l1_45 + (-0.081854306161403656)*bt_g0_37;
    bt_l1_45 = bt_l1_45 + (0.073179833590984344)*bt_g0_38;
    bt_l1_45 = bt_l1_45 + (-0.029850708320736885)*bt_g0_39;
    bt_l1_45 = bt_l1_45 + (0.040976256132125854)*bt_g0_40;
    bt_l1_45 = bt_l1_45 + (-0.029599135741591454)*bt_g0_41;
    bt_l1_45 = bt_l1_45 + (0.023256551474332809)*bt_g0_42;
    bt_l1_45 = bt_l1_45 + (-0.076749458909034729)*bt_g0_43;
    bt_l1_45 = bt_l1_45 + (-0.13640610873699188)*bt_g0_44;
    bt_l1_45 = bt_l1_45 + (0.13716757297515869)*bt_g0_45;
    bt_l1_45 = bt_l1_45 + (0.12731084227561951)*bt_g0_46;
    bt_l1_45 = bt_l1_45 + (0.10762922465801239)*bt_g0_47;
    bt_l1_45 = bt_l1_45 + (0.011593351140618324)*bt_g0_48;
    bt_l1_45 = bt_l1_45 + (0.021663563326001167)*bt_g0_49;
    bt_l1_45 = bt_l1_45 + (0.023607151582837105)*bt_g0_50;
    bt_l1_45 = bt_l1_45 + (-0.040552660822868347)*bt_g0_51;
    bt_l1_45 = bt_l1_45 + (0.10760492831468582)*bt_g0_52;
    bt_l1_45 = bt_l1_45 + (0.13682496547698975)*bt_g0_53;
    bt_l1_45 = bt_l1_45 + (0.14209902286529541)*bt_g0_54;
    bt_l1_45 = bt_l1_45 + (0.11371420323848724)*bt_g0_55;
    bt_l1_45 = bt_l1_45 + (0.14658525586128235)*bt_g0_56;
    bt_l1_45 = bt_l1_45 + (7.6585609349422157e-05)*bt_g0_57;
    bt_l1_45 = bt_l1_45 + (0.010540909133851528)*bt_g0_58;
    bt_l1_45 = bt_l1_45 + (0.024166164919734001)*bt_g0_59;
    bt_l1_45 = bt_l1_45 + (-0.060120191425085068)*bt_g0_60;
    bt_l1_45 = bt_l1_45 + (-0.18991832435131073)*bt_g0_61;
    bt_l1_45 = bt_l1_45 + (-0.059636116027832031)*bt_g0_62;
    bt_l1_45 = bt_l1_45 + (-0.11252808570861816)*bt_g0_63;
    bt_l1_46 = -0.043546199798583984;
    bt_l1_46 = bt_l1_46 + (0.14686886966228485)*bt_g0_0;
    bt_l1_46 = bt_l1_46 + (-0.046130646020174026)*bt_g0_1;
    bt_l1_46 = bt_l1_46 + (0.089379042387008667)*bt_g0_2;
    bt_l1_46 = bt_l1_46 + (-0.0064332662150263786)*bt_g0_3;
    bt_l1_46 = bt_l1_46 + (0.1231752336025238)*bt_g0_4;
    bt_l1_46 = bt_l1_46 + (0.1118241548538208)*bt_g0_5;
    bt_l1_46 = bt_l1_46 + (0.031218340620398521)*bt_g0_6;
    bt_l1_46 = bt_l1_46 + (0.013257221318781376)*bt_g0_7;
    bt_l1_46 = bt_l1_46 + (-0.24409730732440948)*bt_g0_8;
    bt_l1_46 = bt_l1_46 + (-0.063488498330116272)*bt_g0_9;
    bt_l1_46 = bt_l1_46 + (-0.098793253302574158)*bt_g0_10;
    bt_l1_46 = bt_l1_46 + (0.094581857323646545)*bt_g0_11;
    bt_l1_46 = bt_l1_46 + (-0.050613183528184891)*bt_g0_12;
    bt_l1_46 = bt_l1_46 + (-0.12940265238285065)*bt_g0_13;
    bt_l1_46 = bt_l1_46 + (-0.17750430107116699)*bt_g0_14;
    bt_l1_46 = bt_l1_46 + (-0.20504561066627502)*bt_g0_15;
    bt_l1_46 = bt_l1_46 + (0.026457881554961205)*bt_g0_16;
    bt_l1_46 = bt_l1_46 + (-0.10382847487926483)*bt_g0_17;
    bt_l1_46 = bt_l1_46 + (0.022995078936219215)*bt_g0_18;
    bt_l1_46 = bt_l1_46 + (-0.1045721024274826)*bt_g0_19;
    bt_l1_46 = bt_l1_46 + (-0.063125275075435638)*bt_g0_20;
    bt_l1_46 = bt_l1_46 + (0.057405266910791397)*bt_g0_21;
    bt_l1_46 = bt_l1_46 + (-0.015706397593021393)*bt_g0_22;
    bt_l1_46 = bt_l1_46 + (-0.11816601455211639)*bt_g0_23;
    bt_l1_46 = bt_l1_46 + (0.13845734298229218)*bt_g0_24;
    bt_l1_46 = bt_l1_46 + (0.10517597198486328)*bt_g0_25;
    bt_l1_46 = bt_l1_46 + (-0.013576749712228775)*bt_g0_26;
    bt_l1_46 = bt_l1_46 + (0.11635912954807281)*bt_g0_27;
    bt_l1_46 = bt_l1_46 + (0.082220874726772308)*bt_g0_28;
    bt_l1_46 = bt_l1_46 + (0.026438849046826363)*bt_g0_29;
    bt_l1_46 = bt_l1_46 + (0.033243615180253983)*bt_g0_30;
    bt_l1_46 = bt_l1_46 + (0.093801051378250122)*bt_g0_31;
    bt_l1_46 = bt_l1_46 + (0.10802531987428665)*bt_g0_32;
    bt_l1_46 = bt_l1_46 + (0.10023786127567291)*bt_g0_33;
    bt_l1_46 = bt_l1_46 + (0.10402591526508331)*bt_g0_34;
    bt_l1_46 = bt_l1_46 + (-0.17738880217075348)*bt_g0_35;
    bt_l1_46 = bt_l1_46 + (-0.119660384953022)*bt_g0_36;
    bt_l1_46 = bt_l1_46 + (-0.16362980008125305)*bt_g0_37;
    bt_l1_46 = bt_l1_46 + (-0.023276699706912041)*bt_g0_38;
    bt_l1_46 = bt_l1_46 + (0.0062859253957867622)*bt_g0_39;
    bt_l1_46 = bt_l1_46 + (0.10684221237897873)*bt_g0_40;
    bt_l1_46 = bt_l1_46 + (0.13203002512454987)*bt_g0_41;
    bt_l1_46 = bt_l1_46 + (-0.093712575733661652)*bt_g0_42;
    bt_l1_46 = bt_l1_46 + (-0.038837164640426636)*bt_g0_43;
    bt_l1_46 = bt_l1_46 + (-0.074394837021827698)*bt_g0_44;
    bt_l1_46 = bt_l1_46 + (0.084733769297599792)*bt_g0_45;
    bt_l1_46 = bt_l1_46 + (0.16653883457183838)*bt_g0_46;
    bt_l1_46 = bt_l1_46 + (0.082024559378623962)*bt_g0_47;
    bt_l1_46 = bt_l1_46 + (-0.070270970463752747)*bt_g0_48;
    bt_l1_46 = bt_l1_46 + (-0.11461830884218216)*bt_g0_49;
    bt_l1_46 = bt_l1_46 + (-0.043769177049398422)*bt_g0_50;
    bt_l1_46 = bt_l1_46 + (0.022325534373521805)*bt_g0_51;
    bt_l1_46 = bt_l1_46 + (-0.084292709827423096)*bt_g0_52;
    bt_l1_46 = bt_l1_46 + (0.042150188237428665)*bt_g0_53;
    bt_l1_46 = bt_l1_46 + (0.085477143526077271)*bt_g0_54;
    bt_l1_46 = bt_l1_46 + (0.12521201372146606)*bt_g0_55;
    bt_l1_46 = bt_l1_46 + (0.068183243274688721)*bt_g0_56;
    bt_l1_46 = bt_l1_46 + (-0.11888822168111801)*bt_g0_57;
    bt_l1_46 = bt_l1_46 + (-0.084173671901226044)*bt_g0_58;
    bt_l1_46 = bt_l1_46 + (-0.016357695683836937)*bt_g0_59;
    bt_l1_46 = bt_l1_46 + (0.071485675871372223)*bt_g0_60;
    bt_l1_46 = bt_l1_46 + (-0.18218077719211578)*bt_g0_61;
    bt_l1_46 = bt_l1_46 + (-0.2076849490404129)*bt_g0_62;
    bt_l1_46 = bt_l1_46 + (0.065744005143642426)*bt_g0_63;
    bt_l1_47 = 0.092939071357250214;
    bt_l1_47 = bt_l1_47 + (-0.054447643458843231)*bt_g0_0;
    bt_l1_47 = bt_l1_47 + (-0.052890874445438385)*bt_g0_1;
    bt_l1_47 = bt_l1_47 + (0.018157558515667915)*bt_g0_2;
    bt_l1_47 = bt_l1_47 + (-0.03302372619509697)*bt_g0_3;
    bt_l1_47 = bt_l1_47 + (-0.080538354814052582)*bt_g0_4;
    bt_l1_47 = bt_l1_47 + (-0.10942282527685165)*bt_g0_5;
    bt_l1_47 = bt_l1_47 + (-0.16759364306926727)*bt_g0_6;
    bt_l1_47 = bt_l1_47 + (-0.19684392213821411)*bt_g0_7;
    bt_l1_47 = bt_l1_47 + (0.1715361475944519)*bt_g0_8;
    bt_l1_47 = bt_l1_47 + (0.071491599082946777)*bt_g0_9;
    bt_l1_47 = bt_l1_47 + (-0.1320546418428421)*bt_g0_10;
    bt_l1_47 = bt_l1_47 + (0.111089788377285)*bt_g0_11;
    bt_l1_47 = bt_l1_47 + (0.00028759753331542015)*bt_g0_12;
    bt_l1_47 = bt_l1_47 + (-0.013686351478099823)*bt_g0_13;
    bt_l1_47 = bt_l1_47 + (-0.076515376567840576)*bt_g0_14;
    bt_l1_47 = bt_l1_47 + (-0.027271995320916176)*bt_g0_15;
    bt_l1_47 = bt_l1_47 + (-0.036291800439357758)*bt_g0_16;
    bt_l1_47 = bt_l1_47 + (0.065527424216270447)*bt_g0_17;
    bt_l1_47 = bt_l1_47 + (-5.2719158702529967e-05)*bt_g0_18;
    bt_l1_47 = bt_l1_47 + (0.11471583694219589)*bt_g0_19;
    bt_l1_47 = bt_l1_47 + (-0.12515003979206085)*bt_g0_20;
    bt_l1_47 = bt_l1_47 + (-0.071257449686527252)*bt_g0_21;
    bt_l1_47 = bt_l1_47 + (-0.0092762848362326622)*bt_g0_22;
    bt_l1_47 = bt_l1_47 + (0.087586291134357452)*bt_g0_23;
    bt_l1_47 = bt_l1_47 + (0.43559432029724121)*bt_g0_24;
    bt_l1_47 = bt_l1_47 + (0.075083523988723755)*bt_g0_25;
    bt_l1_47 = bt_l1_47 + (-0.038557995110750198)*bt_g0_26;
    bt_l1_47 = bt_l1_47 + (-0.22106920182704926)*bt_g0_27;
    bt_l1_47 = bt_l1_47 + (0.29541513323783875)*bt_g0_28;
    bt_l1_47 = bt_l1_47 + (0.014611244201660156)*bt_g0_29;
    bt_l1_47 = bt_l1_47 + (0.065882720053195953)*bt_g0_30;
    bt_l1_47 = bt_l1_47 + (0.060226228088140488)*bt_g0_31;
    bt_l1_47 = bt_l1_47 + (-0.074395567178726196)*bt_g0_32;
    bt_l1_47 = bt_l1_47 + (-0.16587604582309723)*bt_g0_33;
    bt_l1_47 = bt_l1_47 + (0.063721470534801483)*bt_g0_34;
    bt_l1_47 = bt_l1_47 + (0.033700954169034958)*bt_g0_35;
    bt_l1_47 = bt_l1_47 + (0.13865689933300018)*bt_g0_36;
    bt_l1_47 = bt_l1_47 + (0.015662031248211861)*bt_g0_37;
    bt_l1_47 = bt_l1_47 + (0.044757839292287827)*bt_g0_38;
    bt_l1_47 = bt_l1_47 + (0.089562125504016876)*bt_g0_39;
    bt_l1_47 = bt_l1_47 + (-0.049536474049091339)*bt_g0_40;
    bt_l1_47 = bt_l1_47 + (0.10625987499952316)*bt_g0_41;
    bt_l1_47 = bt_l1_47 + (-0.04525294154882431)*bt_g0_42;
    bt_l1_47 = bt_l1_47 + (0.15140953660011292)*bt_g0_43;
    bt_l1_47 = bt_l1_47 + (-0.019820714369416237)*bt_g0_44;
    bt_l1_47 = bt_l1_47 + (-0.03942471370100975)*bt_g0_45;
    bt_l1_47 = bt_l1_47 + (0.029346713796257973)*bt_g0_46;
    bt_l1_47 = bt_l1_47 + (0.072730123996734619)*bt_g0_47;
    bt_l1_47 = bt_l1_47 + (0.12312083691358566)*bt_g0_48;
    bt_l1_47 = bt_l1_47 + (-0.13436594605445862)*bt_g0_49;
    bt_l1_47 = bt_l1_47 + (0.030096113681793213)*bt_g0_50;
    bt_l1_47 = bt_l1_47 + (-0.082004964351654053)*bt_g0_51;
    bt_l1_47 = bt_l1_47 + (-0.0682949498295784)*bt_g0_52;
    bt_l1_47 = bt_l1_47 + (0.13010220229625702)*bt_g0_53;
    bt_l1_47 = bt_l1_47 + (-0.043485227972269058)*bt_g0_54;
    bt_l1_47 = bt_l1_47 + (0.13008064031600952)*bt_g0_55;
    bt_l1_47 = bt_l1_47 + (0.092174135148525238)*bt_g0_56;
    bt_l1_47 = bt_l1_47 + (0.0027852796483784914)*bt_g0_57;
    bt_l1_47 = bt_l1_47 + (0.11812464147806168)*bt_g0_58;
    bt_l1_47 = bt_l1_47 + (-0.2111717015504837)*bt_g0_59;
    bt_l1_47 = bt_l1_47 + (-0.071153424680233002)*bt_g0_60;
    bt_l1_47 = bt_l1_47 + (0.10144347697496414)*bt_g0_61;
    bt_l1_47 = bt_l1_47 + (0.1931927353143692)*bt_g0_62;
    bt_l1_47 = bt_l1_47 + (0.048555366694927216)*bt_g0_63;
    bt_l1_48 = 0.090012498199939728;
    bt_l1_48 = bt_l1_48 + (0.044168788939714432)*bt_g0_0;
    bt_l1_48 = bt_l1_48 + (-0.15244874358177185)*bt_g0_1;
    bt_l1_48 = bt_l1_48 + (0.0017771569546312094)*bt_g0_2;
    bt_l1_48 = bt_l1_48 + (0.014965806156396866)*bt_g0_3;
    bt_l1_48 = bt_l1_48 + (0.017974225804209709)*bt_g0_4;
    bt_l1_48 = bt_l1_48 + (-0.02490411140024662)*bt_g0_5;
    bt_l1_48 = bt_l1_48 + (-0.071421526372432709)*bt_g0_6;
    bt_l1_48 = bt_l1_48 + (0.068117894232273102)*bt_g0_7;
    bt_l1_48 = bt_l1_48 + (0.13465259969234467)*bt_g0_8;
    bt_l1_48 = bt_l1_48 + (-0.021211696788668633)*bt_g0_9;
    bt_l1_48 = bt_l1_48 + (-0.16191858053207397)*bt_g0_10;
    bt_l1_48 = bt_l1_48 + (0.032486859709024429)*bt_g0_11;
    bt_l1_48 = bt_l1_48 + (0.069692827761173248)*bt_g0_12;
    bt_l1_48 = bt_l1_48 + (0.043297607451677322)*bt_g0_13;
    bt_l1_48 = bt_l1_48 + (0.038508225232362747)*bt_g0_14;
    bt_l1_48 = bt_l1_48 + (0.073786020278930664)*bt_g0_15;
    bt_l1_48 = bt_l1_48 + (0.038850829005241394)*bt_g0_16;
    bt_l1_48 = bt_l1_48 + (-0.021617505699396133)*bt_g0_17;
    bt_l1_48 = bt_l1_48 + (0.027165966108441353)*bt_g0_18;
    bt_l1_48 = bt_l1_48 + (-0.08784155547618866)*bt_g0_19;
    bt_l1_48 = bt_l1_48 + (0.029495468363165855)*bt_g0_20;
    bt_l1_48 = bt_l1_48 + (0.035193644464015961)*bt_g0_21;
    bt_l1_48 = bt_l1_48 + (-0.055852800607681274)*bt_g0_22;
    bt_l1_48 = bt_l1_48 + (0.14158448576927185)*bt_g0_23;
    bt_l1_48 = bt_l1_48 + (0.32719835638999939)*bt_g0_24;
    bt_l1_48 = bt_l1_48 + (0.21092154085636139)*bt_g0_25;
    bt_l1_48 = bt_l1_48 + (-0.17077557742595673)*bt_g0_26;
    bt_l1_48 = bt_l1_48 + (-0.057829782366752625)*bt_g0_27;
    bt_l1_48 = bt_l1_48 + (0.33148998022079468)*bt_g0_28;
    bt_l1_48 = bt_l1_48 + (0.032504633069038391)*bt_g0_29;
    bt_l1_48 = bt_l1_48 + (-0.0058310818858444691)*bt_g0_30;
    bt_l1_48 = bt_l1_48 + (0.096431046724319458)*bt_g0_31;
    bt_l1_48 = bt_l1_48 + (0.18473415076732635)*bt_g0_32;
    bt_l1_48 = bt_l1_48 + (-0.21223339438438416)*bt_g0_33;
    bt_l1_48 = bt_l1_48 + (-0.030146138742566109)*bt_g0_34;
    bt_l1_48 = bt_l1_48 + (0.066469267010688782)*bt_g0_35;
    bt_l1_48 = bt_l1_48 + (0.092055581510066986)*bt_g0_36;
    bt_l1_48 = bt_l1_48 + (0.12403552979230881)*bt_g0_37;
    bt_l1_48 = bt_l1_48 + (0.052875474095344543)*bt_g0_38;
    bt_l1_48 = bt_l1_48 + (-0.023205718025565147)*bt_g0_39;
    bt_l1_48 = bt_l1_48 + (-0.023877577856183052)*bt_g0_40;
    bt_l1_48 = bt_l1_48 + (-0.10354501008987427)*bt_g0_41;
    bt_l1_48 = bt_l1_48 + (-0.013777249492704868)*bt_g0_42;
    bt_l1_48 = bt_l1_48 + (-0.074151575565338135)*bt_g0_43;
    bt_l1_48 = bt_l1_48 + (0.1896635890007019)*bt_g0_44;
    bt_l1_48 = bt_l1_48 + (0.023680694401264191)*bt_g0_45;
    bt_l1_48 = bt_l1_48 + (-0.10033291578292847)*bt_g0_46;
    bt_l1_48 = bt_l1_48 + (-0.075344175100326538)*bt_g0_47;
    bt_l1_48 = bt_l1_48 + (-0.14670893549919128)*bt_g0_48;
    bt_l1_48 = bt_l1_48 + (-0.030068602412939072)*bt_g0_49;
    bt_l1_48 = bt_l1_48 + (-0.071649104356765747)*bt_g0_50;
    bt_l1_48 = bt_l1_48 + (0.081770025193691254)*bt_g0_51;
    bt_l1_48 = bt_l1_48 + (0.053709082305431366)*bt_g0_52;
    bt_l1_48 = bt_l1_48 + (-0.0017002597451210022)*bt_g0_53;
    bt_l1_48 = bt_l1_48 + (0.12659208476543427)*bt_g0_54;
    bt_l1_48 = bt_l1_48 + (0.10075490921735764)*bt_g0_55;
    bt_l1_48 = bt_l1_48 + (-0.077552191913127899)*bt_g0_56;
    bt_l1_48 = bt_l1_48 + (0.018128378316760063)*bt_g0_57;
    bt_l1_48 = bt_l1_48 + (0.051004935055971146)*bt_g0_58;
    bt_l1_48 = bt_l1_48 + (-0.11935191601514816)*bt_g0_59;
    bt_l1_48 = bt_l1_48 + (-0.1334267258644104)*bt_g0_60;
    bt_l1_48 = bt_l1_48 + (0.16512311995029449)*bt_g0_61;
    bt_l1_48 = bt_l1_48 + (0.012908832170069218)*bt_g0_62;
    bt_l1_48 = bt_l1_48 + (0.21540956199169159)*bt_g0_63;
    bt_l1_49 = -0.076119519770145416;
    bt_l1_49 = bt_l1_49 + (0.15145896375179291)*bt_g0_0;
    bt_l1_49 = bt_l1_49 + (-0.010324984788894653)*bt_g0_1;
    bt_l1_49 = bt_l1_49 + (-0.023770978674292564)*bt_g0_2;
    bt_l1_49 = bt_l1_49 + (0.013054203242063522)*bt_g0_3;
    bt_l1_49 = bt_l1_49 + (0.07993953675031662)*bt_g0_4;
    bt_l1_49 = bt_l1_49 + (0.26833117008209229)*bt_g0_5;
    bt_l1_49 = bt_l1_49 + (0.090248771011829376)*bt_g0_6;
    bt_l1_49 = bt_l1_49 + (0.052679792046546936)*bt_g0_7;
    bt_l1_49 = bt_l1_49 + (0.1898278146982193)*bt_g0_8;
    bt_l1_49 = bt_l1_49 + (-0.013550912961363792)*bt_g0_9;
    bt_l1_49 = bt_l1_49 + (0.19228468835353851)*bt_g0_10;
    bt_l1_49 = bt_l1_49 + (0.1391356885433197)*bt_g0_11;
    bt_l1_49 = bt_l1_49 + (0.057508289813995361)*bt_g0_12;
    bt_l1_49 = bt_l1_49 + (-0.019111884757876396)*bt_g0_13;
    bt_l1_49 = bt_l1_49 + (0.18558038771152496)*bt_g0_14;
    bt_l1_49 = bt_l1_49 + (-0.21675901114940643)*bt_g0_15;
    bt_l1_49 = bt_l1_49 + (0.093241050839424133)*bt_g0_16;
    bt_l1_49 = bt_l1_49 + (0.018713857978582382)*bt_g0_17;
    bt_l1_49 = bt_l1_49 + (-0.12781524658203125)*bt_g0_18;
    bt_l1_49 = bt_l1_49 + (-0.14354522526264191)*bt_g0_19;
    bt_l1_49 = bt_l1_49 + (-0.18340861797332764)*bt_g0_20;
    bt_l1_49 = bt_l1_49 + (0.0067579708993434906)*bt_g0_21;
    bt_l1_49 = bt_l1_49 + (-0.12271217256784439)*bt_g0_22;
    bt_l1_49 = bt_l1_49 + (0.10659574717283249)*bt_g0_23;
    bt_l1_49 = bt_l1_49 + (-0.079888537526130676)*bt_g0_24;
    bt_l1_49 = bt_l1_49 + (-0.29388484358787537)*bt_g0_25;
    bt_l1_49 = bt_l1_49 + (-0.015981525182723999)*bt_g0_26;
    bt_l1_49 = bt_l1_49 + (0.17451381683349609)*bt_g0_27;
    bt_l1_49 = bt_l1_49 + (-0.055969018489122391)*bt_g0_28;
    bt_l1_49 = bt_l1_49 + (-0.013932066038250923)*bt_g0_29;
    bt_l1_49 = bt_l1_49 + (-0.0040112016722559929)*bt_g0_30;
    bt_l1_49 = bt_l1_49 + (-0.030741306021809578)*bt_g0_31;
    bt_l1_49 = bt_l1_49 + (0.098742827773094177)*bt_g0_32;
    bt_l1_49 = bt_l1_49 + (0.077936850488185883)*bt_g0_33;
    bt_l1_49 = bt_l1_49 + (-0.088681250810623169)*bt_g0_34;
    bt_l1_49 = bt_l1_49 + (0.020812584087252617)*bt_g0_35;
    bt_l1_49 = bt_l1_49 + (0.13939639925956726)*bt_g0_36;
    bt_l1_49 = bt_l1_49 + (0.061266884207725525)*bt_g0_37;
    bt_l1_49 = bt_l1_49 + (0.10077226161956787)*bt_g0_38;
    bt_l1_49 = bt_l1_49 + (-0.052806723862886429)*bt_g0_39;
    bt_l1_49 = bt_l1_49 + (0.17370527982711792)*bt_g0_40;
    bt_l1_49 = bt_l1_49 + (-0.11713674664497375)*bt_g0_41;
    bt_l1_49 = bt_l1_49 + (-0.11963886022567749)*bt_g0_42;
    bt_l1_49 = bt_l1_49 + (-0.056277673691511154)*bt_g0_43;
    bt_l1_49 = bt_l1_49 + (0.12190934270620346)*bt_g0_44;
    bt_l1_49 = bt_l1_49 + (-0.1217535212635994)*bt_g0_45;
    bt_l1_49 = bt_l1_49 + (0.10317255556583405)*bt_g0_46;
    bt_l1_49 = bt_l1_49 + (0.075359165668487549)*bt_g0_47;
    bt_l1_49 = bt_l1_49 + (-0.069727569818496704)*bt_g0_48;
    bt_l1_49 = bt_l1_49 + (0.010129657573997974)*bt_g0_49;
    bt_l1_49 = bt_l1_49 + (0.10783746093511581)*bt_g0_50;
    bt_l1_49 = bt_l1_49 + (0.0086298985406756401)*bt_g0_51;
    bt_l1_49 = bt_l1_49 + (0.25508227944374084)*bt_g0_52;
    bt_l1_49 = bt_l1_49 + (-0.040740285068750381)*bt_g0_53;
    bt_l1_49 = bt_l1_49 + (-0.0043940255418419838)*bt_g0_54;
    bt_l1_49 = bt_l1_49 + (-0.014839768409729004)*bt_g0_55;
    bt_l1_49 = bt_l1_49 + (-0.089399248361587524)*bt_g0_56;
    bt_l1_49 = bt_l1_49 + (0.10667864233255386)*bt_g0_57;
    bt_l1_49 = bt_l1_49 + (-0.047610994428396225)*bt_g0_58;
    bt_l1_49 = bt_l1_49 + (0.042778003960847855)*bt_g0_59;
    bt_l1_49 = bt_l1_49 + (0.082318633794784546)*bt_g0_60;
    bt_l1_49 = bt_l1_49 + (0.13916084170341492)*bt_g0_61;
    bt_l1_49 = bt_l1_49 + (-0.14656518399715424)*bt_g0_62;
    bt_l1_49 = bt_l1_49 + (0.030136780813336372)*bt_g0_63;
    bt_l1_50 = 0.0026572686620056629;
    bt_l1_50 = bt_l1_50 + (0.022685281932353973)*bt_g0_0;
    bt_l1_50 = bt_l1_50 + (0.17275875806808472)*bt_g0_1;
    bt_l1_50 = bt_l1_50 + (-0.10427998751401901)*bt_g0_2;
    bt_l1_50 = bt_l1_50 + (0.10054159909486771)*bt_g0_3;
    bt_l1_50 = bt_l1_50 + (-0.0046879327856004238)*bt_g0_4;
    bt_l1_50 = bt_l1_50 + (0.010104524902999401)*bt_g0_5;
    bt_l1_50 = bt_l1_50 + (-0.05771675705909729)*bt_g0_6;
    bt_l1_50 = bt_l1_50 + (-0.031510807573795319)*bt_g0_7;
    bt_l1_50 = bt_l1_50 + (-0.26472705602645874)*bt_g0_8;
    bt_l1_50 = bt_l1_50 + (-0.010320057161152363)*bt_g0_9;
    bt_l1_50 = bt_l1_50 + (0.030910493806004524)*bt_g0_10;
    bt_l1_50 = bt_l1_50 + (0.056397765874862671)*bt_g0_11;
    bt_l1_50 = bt_l1_50 + (-0.022601790726184845)*bt_g0_12;
    bt_l1_50 = bt_l1_50 + (-0.077043093740940094)*bt_g0_13;
    bt_l1_50 = bt_l1_50 + (-0.28073844313621521)*bt_g0_14;
    bt_l1_50 = bt_l1_50 + (-0.10679765790700912)*bt_g0_15;
    bt_l1_50 = bt_l1_50 + (0.10747224092483521)*bt_g0_16;
    bt_l1_50 = bt_l1_50 + (-0.0089317131787538528)*bt_g0_17;
    bt_l1_50 = bt_l1_50 + (0.22888894379138947)*bt_g0_18;
    bt_l1_50 = bt_l1_50 + (0.13638170063495636)*bt_g0_19;
    bt_l1_50 = bt_l1_50 + (-0.21608293056488037)*bt_g0_20;
    bt_l1_50 = bt_l1_50 + (-0.0099913785234093666)*bt_g0_21;
    bt_l1_50 = bt_l1_50 + (0.042079225182533264)*bt_g0_22;
    bt_l1_50 = bt_l1_50 + (-0.62337517738342285)*bt_g0_23;
    bt_l1_50 = bt_l1_50 + (-0.23445329070091248)*bt_g0_24;
    bt_l1_50 = bt_l1_50 + (-0.021718049421906471)*bt_g0_25;
    bt_l1_50 = bt_l1_50 + (0.10387453436851501)*bt_g0_26;
    bt_l1_50 = bt_l1_50 + (0.095721513032913208)*bt_g0_27;
    bt_l1_50 = bt_l1_50 + (-0.2868659496307373)*bt_g0_28;
    bt_l1_50 = bt_l1_50 + (0.10504902899265289)*bt_g0_29;
    bt_l1_50 = bt_l1_50 + (0.010414307937026024)*bt_g0_30;
    bt_l1_50 = bt_l1_50 + (0.082906268537044525)*bt_g0_31;
    bt_l1_50 = bt_l1_50 + (-0.11375486105680466)*bt_g0_32;
    bt_l1_50 = bt_l1_50 + (-0.001361916190944612)*bt_g0_33;
    bt_l1_50 = bt_l1_50 + (0.1012168750166893)*bt_g0_34;
    bt_l1_50 = bt_l1_50 + (0.053350646048784256)*bt_g0_35;
    bt_l1_50 = bt_l1_50 + (-0.28965175151824951)*bt_g0_36;
    bt_l1_50 = bt_l1_50 + (-0.19187243282794952)*bt_g0_37;
    bt_l1_50 = bt_l1_50 + (0.029371201992034912)*bt_g0_38;
    bt_l1_50 = bt_l1_50 + (-0.2426755279302597)*bt_g0_39;
    bt_l1_50 = bt_l1_50 + (-0.053197771310806274)*bt_g0_40;
    bt_l1_50 = bt_l1_50 + (0.20659328997135162)*bt_g0_41;
    bt_l1_50 = bt_l1_50 + (0.10439759492874146)*bt_g0_42;
    bt_l1_50 = bt_l1_50 + (-0.034892499446868896)*bt_g0_43;
    bt_l1_50 = bt_l1_50 + (-0.0010908783879131079)*bt_g0_44;
    bt_l1_50 = bt_l1_50 + (0.22988957166671753)*bt_g0_45;
    bt_l1_50 = bt_l1_50 + (0.014341813512146473)*bt_g0_46;
    bt_l1_50 = bt_l1_50 + (0.018605586141347885)*bt_g0_47;
    bt_l1_50 = bt_l1_50 + (0.20617422461509705)*bt_g0_48;
    bt_l1_50 = bt_l1_50 + (0.060520127415657043)*bt_g0_49;
    bt_l1_50 = bt_l1_50 + (0.019822312518954277)*bt_g0_50;
    bt_l1_50 = bt_l1_50 + (-0.22173650562763214)*bt_g0_51;
    bt_l1_50 = bt_l1_50 + (0.016855962574481964)*bt_g0_52;
    bt_l1_50 = bt_l1_50 + (0.033742453902959824)*bt_g0_53;
    bt_l1_50 = bt_l1_50 + (-0.08168116956949234)*bt_g0_54;
    bt_l1_50 = bt_l1_50 + (-0.051544185727834702)*bt_g0_55;
    bt_l1_50 = bt_l1_50 + (0.1171577051281929)*bt_g0_56;
    bt_l1_50 = bt_l1_50 + (-0.044413719326257706)*bt_g0_57;
    bt_l1_50 = bt_l1_50 + (-0.14254167675971985)*bt_g0_58;
    bt_l1_50 = bt_l1_50 + (-0.061404850333929062)*bt_g0_59;
    bt_l1_50 = bt_l1_50 + (0.17594052851200104)*bt_g0_60;
    bt_l1_50 = bt_l1_50 + (-0.22170625627040863)*bt_g0_61;
    bt_l1_50 = bt_l1_50 + (-0.23850348591804504)*bt_g0_62;
    bt_l1_50 = bt_l1_50 + (-0.10171981155872345)*bt_g0_63;
    bt_l1_51 = 0.0095957135781645775;
    bt_l1_51 = bt_l1_51 + (0.095187649130821228)*bt_g0_0;
    bt_l1_51 = bt_l1_51 + (0.13093672692775726)*bt_g0_1;
    bt_l1_51 = bt_l1_51 + (-0.025486381724476814)*bt_g0_2;
    bt_l1_51 = bt_l1_51 + (-0.029186666011810303)*bt_g0_3;
    bt_l1_51 = bt_l1_51 + (0.092539601027965546)*bt_g0_4;
    bt_l1_51 = bt_l1_51 + (0.12677274644374847)*bt_g0_5;
    bt_l1_51 = bt_l1_51 + (-0.093862943351268768)*bt_g0_6;
    bt_l1_51 = bt_l1_51 + (-0.11639417707920074)*bt_g0_7;
    bt_l1_51 = bt_l1_51 + (-0.0080306101590394974)*bt_g0_8;
    bt_l1_51 = bt_l1_51 + (-0.036407332867383957)*bt_g0_9;
    bt_l1_51 = bt_l1_51 + (0.15137758851051331)*bt_g0_10;
    bt_l1_51 = bt_l1_51 + (0.1013825312256813)*bt_g0_11;
    bt_l1_51 = bt_l1_51 + (0.12229196727275848)*bt_g0_12;
    bt_l1_51 = bt_l1_51 + (0.049876723438501358)*bt_g0_13;
    bt_l1_51 = bt_l1_51 + (-1.9786180928349495e-05)*bt_g0_14;
    bt_l1_51 = bt_l1_51 + (0.048019420355558395)*bt_g0_15;
    bt_l1_51 = bt_l1_51 + (-0.014611063525080681)*bt_g0_16;
    bt_l1_51 = bt_l1_51 + (-0.044399168342351913)*bt_g0_17;
    bt_l1_51 = bt_l1_51 + (0.10574249923229218)*bt_g0_18;
    bt_l1_51 = bt_l1_51 + (0.10389982908964157)*bt_g0_19;
    bt_l1_51 = bt_l1_51 + (-0.16825617849826813)*bt_g0_20;
    bt_l1_51 = bt_l1_51 + (0.025920670479536057)*bt_g0_21;
    bt_l1_51 = bt_l1_51 + (0.012969476170837879)*bt_g0_22;
    bt_l1_51 = bt_l1_51 + (-0.070288516581058502)*bt_g0_23;
    bt_l1_51 = bt_l1_51 + (-0.15250758826732635)*bt_g0_24;
    bt_l1_51 = bt_l1_51 + (-0.090368829667568207)*bt_g0_25;
    bt_l1_51 = bt_l1_51 + (0.0557430200278759)*bt_g0_26;
    bt_l1_51 = bt_l1_51 + (-0.097734741866588593)*bt_g0_27;
    bt_l1_51 = bt_l1_51 + (-0.11802143603563309)*bt_g0_28;
    bt_l1_51 = bt_l1_51 + (-0.028423033654689789)*bt_g0_29;
    bt_l1_51 = bt_l1_51 + (-0.086869791150093079)*bt_g0_30;
    bt_l1_51 = bt_l1_51 + (0.089586630463600159)*bt_g0_31;
    bt_l1_51 = bt_l1_51 + (-0.095762304961681366)*bt_g0_32;
    bt_l1_51 = bt_l1_51 + (0.12871454656124115)*bt_g0_33;
    bt_l1_51 = bt_l1_51 + (0.097410723567008972)*bt_g0_34;
    bt_l1_51 = bt_l1_51 + (-0.16400735080242157)*bt_g0_35;
    bt_l1_51 = bt_l1_51 + (-0.18035675585269928)*bt_g0_36;
    bt_l1_51 = bt_l1_51 + (-0.17894397675991058)*bt_g0_37;
    bt_l1_51 = bt_l1_51 + (-0.12125777453184128)*bt_g0_38;
    bt_l1_51 = bt_l1_51 + (-0.20327635109424591)*bt_g0_39;
    bt_l1_51 = bt_l1_51 + (0.044223979115486145)*bt_g0_40;
    bt_l1_51 = bt_l1_51 + (0.010610291734337807)*bt_g0_41;
    bt_l1_51 = bt_l1_51 + (-0.068477511405944824)*bt_g0_42;
    bt_l1_51 = bt_l1_51 + (-0.022967774420976639)*bt_g0_43;
    bt_l1_51 = bt_l1_51 + (-0.021812863647937775)*bt_g0_44;
    bt_l1_51 = bt_l1_51 + (0.064536862075328827)*bt_g0_45;
    bt_l1_51 = bt_l1_51 + (-0.00061633915174752474)*bt_g0_46;
    bt_l1_51 = bt_l1_51 + (0.0057050539180636406)*bt_g0_47;
    bt_l1_51 = bt_l1_51 + (0.046913020312786102)*bt_g0_48;
    bt_l1_51 = bt_l1_51 + (-0.069368012249469757)*bt_g0_49;
    bt_l1_51 = bt_l1_51 + (-0.045869104564189911)*bt_g0_50;
    bt_l1_51 = bt_l1_51 + (-0.018513362854719162)*bt_g0_51;
    bt_l1_51 = bt_l1_51 + (-0.069474540650844574)*bt_g0_52;
    bt_l1_51 = bt_l1_51 + (0.10423671454191208)*bt_g0_53;
    bt_l1_51 = bt_l1_51 + (-0.10580406337976456)*bt_g0_54;
    bt_l1_51 = bt_l1_51 + (0.082552880048751831)*bt_g0_55;
    bt_l1_51 = bt_l1_51 + (-0.032773055136203766)*bt_g0_56;
    bt_l1_51 = bt_l1_51 + (-0.12726835906505585)*bt_g0_57;
    bt_l1_51 = bt_l1_51 + (-0.2128806859254837)*bt_g0_58;
    bt_l1_51 = bt_l1_51 + (0.022409956902265549)*bt_g0_59;
    bt_l1_51 = bt_l1_51 + (0.038095131516456604)*bt_g0_60;
    bt_l1_51 = bt_l1_51 + (-0.02525811456143856)*bt_g0_61;
    bt_l1_51 = bt_l1_51 + (-0.15205396711826324)*bt_g0_62;
    bt_l1_51 = bt_l1_51 + (0.10070594400167465)*bt_g0_63;
    bt_l1_52 = -0.014461904764175415;
    bt_l1_52 = bt_l1_52 + (0.0020956622902303934)*bt_g0_0;
    bt_l1_52 = bt_l1_52 + (-0.17062219977378845)*bt_g0_1;
    bt_l1_52 = bt_l1_52 + (0.16142565011978149)*bt_g0_2;
    bt_l1_52 = bt_l1_52 + (-0.17753183841705322)*bt_g0_3;
    bt_l1_52 = bt_l1_52 + (-0.020295996218919754)*bt_g0_4;
    bt_l1_52 = bt_l1_52 + (0.0097949812188744545)*bt_g0_5;
    bt_l1_52 = bt_l1_52 + (-0.11989603936672211)*bt_g0_6;
    bt_l1_52 = bt_l1_52 + (-0.011471875011920929)*bt_g0_7;
    bt_l1_52 = bt_l1_52 + (0.057446114718914032)*bt_g0_8;
    bt_l1_52 = bt_l1_52 + (0.0041326526552438736)*bt_g0_9;
    bt_l1_52 = bt_l1_52 + (0.014309169724583626)*bt_g0_10;
    bt_l1_52 = bt_l1_52 + (0.088184073567390442)*bt_g0_11;
    bt_l1_52 = bt_l1_52 + (-0.0213463194668293)*bt_g0_12;
    bt_l1_52 = bt_l1_52 + (0.046845894306898117)*bt_g0_13;
    bt_l1_52 = bt_l1_52 + (0.022684743627905846)*bt_g0_14;
    bt_l1_52 = bt_l1_52 + (0.27944931387901306)*bt_g0_15;
    bt_l1_52 = bt_l1_52 + (0.039982631802558899)*bt_g0_16;
    bt_l1_52 = bt_l1_52 + (0.032585382461547852)*bt_g0_17;
    bt_l1_52 = bt_l1_52 + (-0.12812642753124237)*bt_g0_18;
    bt_l1_52 = bt_l1_52 + (0.059438254684209824)*bt_g0_19;
    bt_l1_52 = bt_l1_52 + (0.064316920936107635)*bt_g0_20;
    bt_l1_52 = bt_l1_52 + (-0.17351415753364563)*bt_g0_21;
    bt_l1_52 = bt_l1_52 + (-0.32456380128860474)*bt_g0_22;
    bt_l1_52 = bt_l1_52 + (0.070168092846870422)*bt_g0_23;
    bt_l1_52 = bt_l1_52 + (-0.029019858688116074)*bt_g0_24;
    bt_l1_52 = bt_l1_52 + (-0.3058408796787262)*bt_g0_25;
    bt_l1_52 = bt_l1_52 + (0.12181563675403595)*bt_g0_26;
    bt_l1_52 = bt_l1_52 + (-0.18489581346511841)*bt_g0_27;
    bt_l1_52 = bt_l1_52 + (-0.037566512823104858)*bt_g0_28;
    bt_l1_52 = bt_l1_52 + (-0.089225292205810547)*bt_g0_29;
    bt_l1_52 = bt_l1_52 + (0.1092458963394165)*bt_g0_30;
    bt_l1_52 = bt_l1_52 + (0.058338649570941925)*bt_g0_31;
    bt_l1_52 = bt_l1_52 + (-0.044083759188652039)*bt_g0_32;
    bt_l1_52 = bt_l1_52 + (-0.27679780125617981)*bt_g0_33;
    bt_l1_52 = bt_l1_52 + (0.011887436732649803)*bt_g0_34;
    bt_l1_52 = bt_l1_52 + (0.18638953566551208)*bt_g0_35;
    bt_l1_52 = bt_l1_52 + (0.3047584593296051)*bt_g0_36;
    bt_l1_52 = bt_l1_52 + (0.25063061714172363)*bt_g0_37;
    bt_l1_52 = bt_l1_52 + (0.22437934577465057)*bt_g0_38;
    bt_l1_52 = bt_l1_52 + (-0.0999283567070961)*bt_g0_39;
    bt_l1_52 = bt_l1_52 + (-0.091461397707462311)*bt_g0_40;
    bt_l1_52 = bt_l1_52 + (0.040526945143938065)*bt_g0_41;
    bt_l1_52 = bt_l1_52 + (0.18554674088954926)*bt_g0_42;
    bt_l1_52 = bt_l1_52 + (-0.054394591599702835)*bt_g0_43;
    bt_l1_52 = bt_l1_52 + (-0.33559736609458923)*bt_g0_44;
    bt_l1_52 = bt_l1_52 + (-0.1075182631611824)*bt_g0_45;
    bt_l1_52 = bt_l1_52 + (0.083031058311462402)*bt_g0_46;
    bt_l1_52 = bt_l1_52 + (0.09940125048160553)*bt_g0_47;
    bt_l1_52 = bt_l1_52 + (-0.20035539567470551)*bt_g0_48;
    bt_l1_52 = bt_l1_52 + (0.23749804496765137)*bt_g0_49;
    bt_l1_52 = bt_l1_52 + (-0.019996309652924538)*bt_g0_50;
    bt_l1_52 = bt_l1_52 + (0.10061613470315933)*bt_g0_51;
    bt_l1_52 = bt_l1_52 + (-0.12219765037298203)*bt_g0_52;
    bt_l1_52 = bt_l1_52 + (-0.09381064772605896)*bt_g0_53;
    bt_l1_52 = bt_l1_52 + (-0.042205337435007095)*bt_g0_54;
    bt_l1_52 = bt_l1_52 + (0.022725049406290054)*bt_g0_55;
    bt_l1_52 = bt_l1_52 + (-0.0090637831017374992)*bt_g0_56;
    bt_l1_52 = bt_l1_52 + (0.0075151398777961731)*bt_g0_57;
    bt_l1_52 = bt_l1_52 + (0.15781204402446747)*bt_g0_58;
    bt_l1_52 = bt_l1_52 + (0.15824307501316071)*bt_g0_59;
    bt_l1_52 = bt_l1_52 + (-0.072175204753875732)*bt_g0_60;
    bt_l1_52 = bt_l1_52 + (0.017957890406250954)*bt_g0_61;
    bt_l1_52 = bt_l1_52 + (0.37811696529388428)*bt_g0_62;
    bt_l1_52 = bt_l1_52 + (0.046051912009716034)*bt_g0_63;
    bt_l1_53 = -0.012863084673881531;
    bt_l1_53 = bt_l1_53 + (0.056516867130994797)*bt_g0_0;
    bt_l1_53 = bt_l1_53 + (-0.049675386399030685)*bt_g0_1;
    bt_l1_53 = bt_l1_53 + (0.094534337520599365)*bt_g0_2;
    bt_l1_53 = bt_l1_53 + (-0.076072558760643005)*bt_g0_3;
    bt_l1_53 = bt_l1_53 + (0.0273179542273283)*bt_g0_4;
    bt_l1_53 = bt_l1_53 + (-0.22410875558853149)*bt_g0_5;
    bt_l1_53 = bt_l1_53 + (-0.073680564761161804)*bt_g0_6;
    bt_l1_53 = bt_l1_53 + (0.021888885647058487)*bt_g0_7;
    bt_l1_53 = bt_l1_53 + (0.13145932555198669)*bt_g0_8;
    bt_l1_53 = bt_l1_53 + (-0.085808739066123962)*bt_g0_9;
    bt_l1_53 = bt_l1_53 + (-0.06986863911151886)*bt_g0_10;
    bt_l1_53 = bt_l1_53 + (0.14744535088539124)*bt_g0_11;
    bt_l1_53 = bt_l1_53 + (0.064960308372974396)*bt_g0_12;
    bt_l1_53 = bt_l1_53 + (0.21166136860847473)*bt_g0_13;
    bt_l1_53 = bt_l1_53 + (0.19597087800502777)*bt_g0_14;
    bt_l1_53 = bt_l1_53 + (-0.3325786292552948)*bt_g0_15;
    bt_l1_53 = bt_l1_53 + (-0.16871829330921173)*bt_g0_16;
    bt_l1_53 = bt_l1_53 + (0.091760903596878052)*bt_g0_17;
    bt_l1_53 = bt_l1_53 + (0.05394083634018898)*bt_g0_18;
    bt_l1_53 = bt_l1_53 + (0.16561140120029449)*bt_g0_19;
    bt_l1_53 = bt_l1_53 + (-0.0099580176174640656)*bt_g0_20;
    bt_l1_53 = bt_l1_53 + (0.041470091789960861)*bt_g0_21;
    bt_l1_53 = bt_l1_53 + (-0.16953426599502563)*bt_g0_22;
    bt_l1_53 = bt_l1_53 + (0.1122136116027832)*bt_g0_23;
    bt_l1_53 = bt_l1_53 + (0.58660918474197388)*bt_g0_24;
    bt_l1_53 = bt_l1_53 + (0.08730015903711319)*bt_g0_25;
    bt_l1_53 = bt_l1_53 + (-0.24594758450984955)*bt_g0_26;
    bt_l1_53 = bt_l1_53 + (-0.037397138774394989)*bt_g0_27;
    bt_l1_53 = bt_l1_53 + (0.32891938090324402)*bt_g0_28;
    bt_l1_53 = bt_l1_53 + (0.059584725648164749)*bt_g0_29;
    bt_l1_53 = bt_l1_53 + (-0.0043420642614364624)*bt_g0_30;
    bt_l1_53 = bt_l1_53 + (-0.017997758463025093)*bt_g0_31;
    bt_l1_53 = bt_l1_53 + (0.17913000285625458)*bt_g0_32;
    bt_l1_53 = bt_l1_53 + (-0.1652006208896637)*bt_g0_33;
    bt_l1_53 = bt_l1_53 + (0.1430676281452179)*bt_g0_34;
    bt_l1_53 = bt_l1_53 + (0.057292349636554718)*bt_g0_35;
    bt_l1_53 = bt_l1_53 + (-0.13089154660701752)*bt_g0_36;
    bt_l1_53 = bt_l1_53 + (-0.021992018446326256)*bt_g0_37;
    bt_l1_53 = bt_l1_53 + (-0.13826958835124969)*bt_g0_38;
    bt_l1_53 = bt_l1_53 + (-0.0055157202295958996)*bt_g0_39;
    bt_l1_53 = bt_l1_53 + (-0.015431672334671021)*bt_g0_40;
    bt_l1_53 = bt_l1_53 + (0.026258688420057297)*bt_g0_41;
    bt_l1_53 = bt_l1_53 + (-0.11284758150577545)*bt_g0_42;
    bt_l1_53 = bt_l1_53 + (0.015373896807432175)*bt_g0_43;
    bt_l1_53 = bt_l1_53 + (0.32781356573104858)*bt_g0_44;
    bt_l1_53 = bt_l1_53 + (0.054659362882375717)*bt_g0_45;
    bt_l1_53 = bt_l1_53 + (0.059080839157104492)*bt_g0_46;
    bt_l1_53 = bt_l1_53 + (0.072766900062561035)*bt_g0_47;
    bt_l1_53 = bt_l1_53 + (0.11078733950853348)*bt_g0_48;
    bt_l1_53 = bt_l1_53 + (-0.12980319559574127)*bt_g0_49;
    bt_l1_53 = bt_l1_53 + (0.01152291614562273)*bt_g0_50;
    bt_l1_53 = bt_l1_53 + (0.22574906051158905)*bt_g0_51;
    bt_l1_53 = bt_l1_53 + (0.18509584665298462)*bt_g0_52;
    bt_l1_53 = bt_l1_53 + (-0.011096834205091)*bt_g0_53;
    bt_l1_53 = bt_l1_53 + (-0.047318652272224426)*bt_g0_54;
    bt_l1_53 = bt_l1_53 + (0.15201166272163391)*bt_g0_55;
    bt_l1_53 = bt_l1_53 + (0.16000998020172119)*bt_g0_56;
    bt_l1_53 = bt_l1_53 + (0.043478779494762421)*bt_g0_57;
    bt_l1_53 = bt_l1_53 + (-0.11554400622844696)*bt_g0_58;
    bt_l1_53 = bt_l1_53 + (-0.12881147861480713)*bt_g0_59;
    bt_l1_53 = bt_l1_53 + (-0.28521105647087097)*bt_g0_60;
    bt_l1_53 = bt_l1_53 + (0.23081481456756592)*bt_g0_61;
    bt_l1_53 = bt_l1_53 + (-0.49295786023139954)*bt_g0_62;
    bt_l1_53 = bt_l1_53 + (0.20501254498958588)*bt_g0_63;
    bt_l1_54 = -0.0068554566241800785;
    bt_l1_54 = bt_l1_54 + (0.088018573820590973)*bt_g0_0;
    bt_l1_54 = bt_l1_54 + (0.13088330626487732)*bt_g0_1;
    bt_l1_54 = bt_l1_54 + (0.027713531628251076)*bt_g0_2;
    bt_l1_54 = bt_l1_54 + (0.1058380976319313)*bt_g0_3;
    bt_l1_54 = bt_l1_54 + (0.0019624719861894846)*bt_g0_4;
    bt_l1_54 = bt_l1_54 + (-0.055840056389570236)*bt_g0_5;
    bt_l1_54 = bt_l1_54 + (0.051605705171823502)*bt_g0_6;
    bt_l1_54 = bt_l1_54 + (-0.030093882232904434)*bt_g0_7;
    bt_l1_54 = bt_l1_54 + (0.093219757080078125)*bt_g0_8;
    bt_l1_54 = bt_l1_54 + (0.041150316596031189)*bt_g0_9;
    bt_l1_54 = bt_l1_54 + (0.058321386575698853)*bt_g0_10;
    bt_l1_54 = bt_l1_54 + (0.027851317077875137)*bt_g0_11;
    bt_l1_54 = bt_l1_54 + (-0.14432129263877869)*bt_g0_12;
    bt_l1_54 = bt_l1_54 + (-0.018955579027533531)*bt_g0_13;
    bt_l1_54 = bt_l1_54 + (-0.072583556175231934)*bt_g0_14;
    bt_l1_54 = bt_l1_54 + (-0.036197137087583542)*bt_g0_15;
    bt_l1_54 = bt_l1_54 + (-0.16779798269271851)*bt_g0_16;
    bt_l1_54 = bt_l1_54 + (-0.12195181846618652)*bt_g0_17;
    bt_l1_54 = bt_l1_54 + (0.078593388199806213)*bt_g0_18;
    bt_l1_54 = bt_l1_54 + (-0.069054916501045227)*bt_g0_19;
    bt_l1_54 = bt_l1_54 + (-0.0075768842361867428)*bt_g0_20;
    bt_l1_54 = bt_l1_54 + (0.058806456625461578)*bt_g0_21;
    bt_l1_54 = bt_l1_54 + (-0.021174542605876923)*bt_g0_22;
    bt_l1_54 = bt_l1_54 + (-0.017421767115592957)*bt_g0_23;
    bt_l1_54 = bt_l1_54 + (-0.32772937417030334)*bt_g0_24;
    bt_l1_54 = bt_l1_54 + (-0.12836652994155884)*bt_g0_25;
    bt_l1_54 = bt_l1_54 + (0.068585298955440521)*bt_g0_26;
    bt_l1_54 = bt_l1_54 + (-0.096194997429847717)*bt_g0_27;
    bt_l1_54 = bt_l1_54 + (-0.10035586357116699)*bt_g0_28;
    bt_l1_54 = bt_l1_54 + (-0.038390025496482849)*bt_g0_29;
    bt_l1_54 = bt_l1_54 + (0.024132249876856804)*bt_g0_30;
    bt_l1_54 = bt_l1_54 + (-0.018657790496945381)*bt_g0_31;
    bt_l1_54 = bt_l1_54 + (-0.17058144509792328)*bt_g0_32;
    bt_l1_54 = bt_l1_54 + (0.01129576563835144)*bt_g0_33;
    bt_l1_54 = bt_l1_54 + (-0.12267591804265976)*bt_g0_34;
    bt_l1_54 = bt_l1_54 + (0.22388654947280884)*bt_g0_35;
    bt_l1_54 = bt_l1_54 + (-0.029868312180042267)*bt_g0_36;
    bt_l1_54 = bt_l1_54 + (-0.1008121594786644)*bt_g0_37;
    bt_l1_54 = bt_l1_54 + (-0.062345065176486969)*bt_g0_38;
    bt_l1_54 = bt_l1_54 + (-0.060562197118997574)*bt_g0_39;
    bt_l1_54 = bt_l1_54 + (0.097920835018157959)*bt_g0_40;
    bt_l1_54 = bt_l1_54 + (-0.063832134008407593)*bt_g0_41;
    bt_l1_54 = bt_l1_54 + (0.023362442851066589)*bt_g0_42;
    bt_l1_54 = bt_l1_54 + (-0.07341717928647995)*bt_g0_43;
    bt_l1_54 = bt_l1_54 + (-0.19088225066661835)*bt_g0_44;
    bt_l1_54 = bt_l1_54 + (-0.0010184623533859849)*bt_g0_45;
    bt_l1_54 = bt_l1_54 + (0.018525050953030586)*bt_g0_46;
    bt_l1_54 = bt_l1_54 + (0.068564705550670624)*bt_g0_47;
    bt_l1_54 = bt_l1_54 + (-0.018901340663433075)*bt_g0_48;
    bt_l1_54 = bt_l1_54 + (0.17311355471611023)*bt_g0_49;
    bt_l1_54 = bt_l1_54 + (-0.082324527204036713)*bt_g0_50;
    bt_l1_54 = bt_l1_54 + (-0.10529303550720215)*bt_g0_51;
    bt_l1_54 = bt_l1_54 + (0.025419898331165314)*bt_g0_52;
    bt_l1_54 = bt_l1_54 + (0.017848210409283638)*bt_g0_53;
    bt_l1_54 = bt_l1_54 + (-0.011009448207914829)*bt_g0_54;
    bt_l1_54 = bt_l1_54 + (0.072188526391983032)*bt_g0_55;
    bt_l1_54 = bt_l1_54 + (0.072250120341777802)*bt_g0_56;
    bt_l1_54 = bt_l1_54 + (-0.097421549260616302)*bt_g0_57;
    bt_l1_54 = bt_l1_54 + (0.045699726790189743)*bt_g0_58;
    bt_l1_54 = bt_l1_54 + (0.10212226212024689)*bt_g0_59;
    bt_l1_54 = bt_l1_54 + (0.17259690165519714)*bt_g0_60;
    bt_l1_54 = bt_l1_54 + (-0.071458496153354645)*bt_g0_61;
    bt_l1_54 = bt_l1_54 + (0.02954440750181675)*bt_g0_62;
    bt_l1_54 = bt_l1_54 + (0.026523403823375702)*bt_g0_63;
    bt_l1_55 = 0.1236879900097847;
    bt_l1_55 = bt_l1_55 + (-0.078195095062255859)*bt_g0_0;
    bt_l1_55 = bt_l1_55 + (0.055713318288326263)*bt_g0_1;
    bt_l1_55 = bt_l1_55 + (-0.085400693118572235)*bt_g0_2;
    bt_l1_55 = bt_l1_55 + (0.15678757429122925)*bt_g0_3;
    bt_l1_55 = bt_l1_55 + (0.044857010245323181)*bt_g0_4;
    bt_l1_55 = bt_l1_55 + (0.12446357309818268)*bt_g0_5;
    bt_l1_55 = bt_l1_55 + (0.11192186176776886)*bt_g0_6;
    bt_l1_55 = bt_l1_55 + (0.021300647407770157)*bt_g0_7;
    bt_l1_55 = bt_l1_55 + (-0.12118787318468094)*bt_g0_8;
    bt_l1_55 = bt_l1_55 + (0.020474962890148163)*bt_g0_9;
    bt_l1_55 = bt_l1_55 + (-0.063713781535625458)*bt_g0_10;
    bt_l1_55 = bt_l1_55 + (0.0031346967443823814)*bt_g0_11;
    bt_l1_55 = bt_l1_55 + (0.059383060783147812)*bt_g0_12;
    bt_l1_55 = bt_l1_55 + (0.10922112315893173)*bt_g0_13;
    bt_l1_55 = bt_l1_55 + (-0.12882110476493835)*bt_g0_14;
    bt_l1_55 = bt_l1_55 + (-0.099081262946128845)*bt_g0_15;
    bt_l1_55 = bt_l1_55 + (0.0069388328120112419)*bt_g0_16;
    bt_l1_55 = bt_l1_55 + (0.017576558515429497)*bt_g0_17;
    bt_l1_55 = bt_l1_55 + (0.14842377603054047)*bt_g0_18;
    bt_l1_55 = bt_l1_55 + (0.12534180283546448)*bt_g0_19;
    bt_l1_55 = bt_l1_55 + (-0.047768283635377884)*bt_g0_20;
    bt_l1_55 = bt_l1_55 + (-0.043871469795703888)*bt_g0_21;
    bt_l1_55 = bt_l1_55 + (0.025559278205037117)*bt_g0_22;
    bt_l1_55 = bt_l1_55 + (-0.45011049509048462)*bt_g0_23;
    bt_l1_55 = bt_l1_55 + (0.38400602340698242)*bt_g0_24;
    bt_l1_55 = bt_l1_55 + (0.20868073403835297)*bt_g0_25;
    bt_l1_55 = bt_l1_55 + (-0.10510896146297455)*bt_g0_26;
    bt_l1_55 = bt_l1_55 + (0.003747554263100028)*bt_g0_27;
    bt_l1_55 = bt_l1_55 + (-0.25766974687576294)*bt_g0_28;
    bt_l1_55 = bt_l1_55 + (-0.018183089792728424)*bt_g0_29;
    bt_l1_55 = bt_l1_55 + (-0.0087796878069639206)*bt_g0_30;
    bt_l1_55 = bt_l1_55 + (0.12361440062522888)*bt_g0_31;
    bt_l1_55 = bt_l1_55 + (-0.04522327333688736)*bt_g0_32;
    bt_l1_55 = bt_l1_55 + (-0.047600883990526199)*bt_g0_33;
    bt_l1_55 = bt_l1_55 + (0.11536583304405212)*bt_g0_34;
    bt_l1_55 = bt_l1_55 + (-0.26933923363685608)*bt_g0_35;
    bt_l1_55 = bt_l1_55 + (-0.12876570224761963)*bt_g0_36;
    bt_l1_55 = bt_l1_55 + (-0.026450322940945625)*bt_g0_37;
    bt_l1_55 = bt_l1_55 + (0.056170571595430374)*bt_g0_38;
    bt_l1_55 = bt_l1_55 + (-0.097737640142440796)*bt_g0_39;
    bt_l1_55 = bt_l1_55 + (0.076570756733417511)*bt_g0_40;
    bt_l1_55 = bt_l1_55 + (0.08586592972278595)*bt_g0_41;
    bt_l1_55 = bt_l1_55 + (-0.081839479506015778)*bt_g0_42;
    bt_l1_55 = bt_l1_55 + (-0.12064396589994431)*bt_g0_43;
    bt_l1_55 = bt_l1_55 + (0.0071646496653556824)*bt_g0_44;
    bt_l1_55 = bt_l1_55 + (0.10913930088281631)*bt_g0_45;
    bt_l1_55 = bt_l1_55 + (-0.057552900165319443)*bt_g0_46;
    bt_l1_55 = bt_l1_55 + (0.066619947552680969)*bt_g0_47;
    bt_l1_55 = bt_l1_55 + (0.028874590992927551)*bt_g0_48;
    bt_l1_55 = bt_l1_55 + (-0.11124158650636673)*bt_g0_49;
    bt_l1_55 = bt_l1_55 + (0.19685333967208862)*bt_g0_50;
    bt_l1_55 = bt_l1_55 + (-0.28406399488449097)*bt_g0_51;
    bt_l1_55 = bt_l1_55 + (0.10810296982526779)*bt_g0_52;
    bt_l1_55 = bt_l1_55 + (-0.022099129855632782)*bt_g0_53;
    bt_l1_55 = bt_l1_55 + (0.091128841042518616)*bt_g0_54;
    bt_l1_55 = bt_l1_55 + (-0.00091169949155300856)*bt_g0_55;
    bt_l1_55 = bt_l1_55 + (0.0069932672195136547)*bt_g0_56;
    bt_l1_55 = bt_l1_55 + (-0.096817277371883392)*bt_g0_57;
    bt_l1_55 = bt_l1_55 + (-0.01799565926194191)*bt_g0_58;
    bt_l1_55 = bt_l1_55 + (-0.13270500302314758)*bt_g0_59;
    bt_l1_55 = bt_l1_55 + (-0.018351662904024124)*bt_g0_60;
    bt_l1_55 = bt_l1_55 + (-0.0036199872847646475)*bt_g0_61;
    bt_l1_55 = bt_l1_55 + (-0.44087508320808411)*bt_g0_62;
    bt_l1_55 = bt_l1_55 + (-0.18398435413837433)*bt_g0_63;
    bt_l1_56 = 0.1106288880109787;
    bt_l1_56 = bt_l1_56 + (0.031097631901502609)*bt_g0_0;
    bt_l1_56 = bt_l1_56 + (0.041328620165586472)*bt_g0_1;
    bt_l1_56 = bt_l1_56 + (0.13463068008422852)*bt_g0_2;
    bt_l1_56 = bt_l1_56 + (-0.15725672245025635)*bt_g0_3;
    bt_l1_56 = bt_l1_56 + (0.073874585330486298)*bt_g0_4;
    bt_l1_56 = bt_l1_56 + (-0.34363260865211487)*bt_g0_5;
    bt_l1_56 = bt_l1_56 + (-0.081378430128097534)*bt_g0_6;
    bt_l1_56 = bt_l1_56 + (-0.21914784610271454)*bt_g0_7;
    bt_l1_56 = bt_l1_56 + (-0.032757733017206192)*bt_g0_8;
    bt_l1_56 = bt_l1_56 + (-0.05652935802936554)*bt_g0_9;
    bt_l1_56 = bt_l1_56 + (0.065828442573547363)*bt_g0_10;
    bt_l1_56 = bt_l1_56 + (-0.068848490715026855)*bt_g0_11;
    bt_l1_56 = bt_l1_56 + (0.046551920473575592)*bt_g0_12;
    bt_l1_56 = bt_l1_56 + (-0.083662189543247223)*bt_g0_13;
    bt_l1_56 = bt_l1_56 + (0.066018082201480865)*bt_g0_14;
    bt_l1_56 = bt_l1_56 + (-0.23542097210884094)*bt_g0_15;
    bt_l1_56 = bt_l1_56 + (-0.56516075134277344)*bt_g0_16;
    bt_l1_56 = bt_l1_56 + (0.02276403084397316)*bt_g0_17;
    bt_l1_56 = bt_l1_56 + (0.070770405232906342)*bt_g0_18;
    bt_l1_56 = bt_l1_56 + (-0.048187464475631714)*bt_g0_19;
    bt_l1_56 = bt_l1_56 + (0.036811448633670807)*bt_g0_20;
    bt_l1_56 = bt_l1_56 + (-0.029363851994276047)*bt_g0_21;
    bt_l1_56 = bt_l1_56 + (-0.062698908150196075)*bt_g0_22;
    bt_l1_56 = bt_l1_56 + (0.20280921459197998)*bt_g0_23;
    bt_l1_56 = bt_l1_56 + (-0.05466490238904953)*bt_g0_24;
    bt_l1_56 = bt_l1_56 + (-0.040283352136611938)*bt_g0_25;
    bt_l1_56 = bt_l1_56 + (0.031380157917737961)*bt_g0_26;
    bt_l1_56 = bt_l1_56 + (-0.14397814869880676)*bt_g0_27;
    bt_l1_56 = bt_l1_56 + (-0.069095566868782043)*bt_g0_28;
    bt_l1_56 = bt_l1_56 + (0.084253191947937012)*bt_g0_29;
    bt_l1_56 = bt_l1_56 + (0.057395033538341522)*bt_g0_30;
    bt_l1_56 = bt_l1_56 + (0.015039242804050446)*bt_g0_31;
    bt_l1_56 = bt_l1_56 + (0.021209819242358208)*bt_g0_32;
    bt_l1_56 = bt_l1_56 + (-0.040844108909368515)*bt_g0_33;
    bt_l1_56 = bt_l1_56 + (-0.023727202787995338)*bt_g0_34;
    bt_l1_56 = bt_l1_56 + (-0.070701718330383301)*bt_g0_35;
    bt_l1_56 = bt_l1_56 + (-0.13229206204414368)*bt_g0_36;
    bt_l1_56 = bt_l1_56 + (-0.2576671838760376)*bt_g0_37;
    bt_l1_56 = bt_l1_56 + (-0.35521337389945984)*bt_g0_38;
    bt_l1_56 = bt_l1_56 + (0.025346012786030769)*bt_g0_39;
    bt_l1_56 = bt_l1_56 + (0.14733715355396271)*bt_g0_40;
    bt_l1_56 = bt_l1_56 + (0.17287017405033112)*bt_g0_41;
    bt_l1_56 = bt_l1_56 + (0.024701613932847977)*bt_g0_42;
    bt_l1_56 = bt_l1_56 + (0.19121305644512177)*bt_g0_43;
    bt_l1_56 = bt_l1_56 + (0.147562175989151)*bt_g0_44;
    bt_l1_56 = bt_l1_56 + (0.10955379903316498)*bt_g0_45;
    bt_l1_56 = bt_l1_56 + (0.13094775378704071)*bt_g0_46;
    bt_l1_56 = bt_l1_56 + (0.21110664308071136)*bt_g0_47;
    bt_l1_56 = bt_l1_56 + (0.020101437345147133)*bt_g0_48;
    bt_l1_56 = bt_l1_56 + (0.009227704256772995)*bt_g0_49;
    bt_l1_56 = bt_l1_56 + (-0.16596432030200958)*bt_g0_50;
    bt_l1_56 = bt_l1_56 + (0.10754027962684631)*bt_g0_51;
    bt_l1_56 = bt_l1_56 + (-0.13487210869789124)*bt_g0_52;
    bt_l1_56 = bt_l1_56 + (0.043257027864456177)*bt_g0_53;
    bt_l1_56 = bt_l1_56 + (-0.080602802336215973)*bt_g0_54;
    bt_l1_56 = bt_l1_56 + (-0.02563096210360527)*bt_g0_55;
    bt_l1_56 = bt_l1_56 + (-0.1160770058631897)*bt_g0_56;
    bt_l1_56 = bt_l1_56 + (0.052256964147090912)*bt_g0_57;
    bt_l1_56 = bt_l1_56 + (-0.20749491453170776)*bt_g0_58;
    bt_l1_56 = bt_l1_56 + (0.068776980042457581)*bt_g0_59;
    bt_l1_56 = bt_l1_56 + (-0.0030008212197571993)*bt_g0_60;
    bt_l1_56 = bt_l1_56 + (-0.21819581091403961)*bt_g0_61;
    bt_l1_56 = bt_l1_56 + (-0.18561835587024689)*bt_g0_62;
    bt_l1_56 = bt_l1_56 + (0.1614190936088562)*bt_g0_63;
    bt_l1_57 = -0.082984209060668945;
    bt_l1_57 = bt_l1_57 + (0.10784106701612473)*bt_g0_0;
    bt_l1_57 = bt_l1_57 + (0.15473610162734985)*bt_g0_1;
    bt_l1_57 = bt_l1_57 + (-0.10424920171499252)*bt_g0_2;
    bt_l1_57 = bt_l1_57 + (-0.12390753626823425)*bt_g0_3;
    bt_l1_57 = bt_l1_57 + (0.0042405691929161549)*bt_g0_4;
    bt_l1_57 = bt_l1_57 + (-0.051331259310245514)*bt_g0_5;
    bt_l1_57 = bt_l1_57 + (0.084193304181098938)*bt_g0_6;
    bt_l1_57 = bt_l1_57 + (-0.032845817506313324)*bt_g0_7;
    bt_l1_57 = bt_l1_57 + (-0.07875523716211319)*bt_g0_8;
    bt_l1_57 = bt_l1_57 + (0.04704274982213974)*bt_g0_9;
    bt_l1_57 = bt_l1_57 + (0.01994292251765728)*bt_g0_10;
    bt_l1_57 = bt_l1_57 + (0.089487873017787933)*bt_g0_11;
    bt_l1_57 = bt_l1_57 + (0.13231566548347473)*bt_g0_12;
    bt_l1_57 = bt_l1_57 + (-0.14932288229465485)*bt_g0_13;
    bt_l1_57 = bt_l1_57 + (-0.13785046339035034)*bt_g0_14;
    bt_l1_57 = bt_l1_57 + (0.052839074283838272)*bt_g0_15;
    bt_l1_57 = bt_l1_57 + (-0.052082747220993042)*bt_g0_16;
    bt_l1_57 = bt_l1_57 + (0.032248549163341522)*bt_g0_17;
    bt_l1_57 = bt_l1_57 + (-0.042471326887607574)*bt_g0_18;
    bt_l1_57 = bt_l1_57 + (0.065556637942790985)*bt_g0_19;
    bt_l1_57 = bt_l1_57 + (0.039503619074821472)*bt_g0_20;
    bt_l1_57 = bt_l1_57 + (0.064967811107635498)*bt_g0_21;
    bt_l1_57 = bt_l1_57 + (0.12558278441429138)*bt_g0_22;
    bt_l1_57 = bt_l1_57 + (-0.0044933692552149296)*bt_g0_23;
    bt_l1_57 = bt_l1_57 + (-0.25751358270645142)*bt_g0_24;
    bt_l1_57 = bt_l1_57 + (-0.21725577116012573)*bt_g0_25;
    bt_l1_57 = bt_l1_57 + (0.18002277612686157)*bt_g0_26;
    bt_l1_57 = bt_l1_57 + (-0.16875006258487701)*bt_g0_27;
    bt_l1_57 = bt_l1_57 + (-0.35215425491333008)*bt_g0_28;
    bt_l1_57 = bt_l1_57 + (0.0052697546780109406)*bt_g0_29;
    bt_l1_57 = bt_l1_57 + (0.068809144198894501)*bt_g0_30;
    bt_l1_57 = bt_l1_57 + (0.085060298442840576)*bt_g0_31;
    bt_l1_57 = bt_l1_57 + (-0.032059691846370697)*bt_g0_32;
    bt_l1_57 = bt_l1_57 + (0.13087901473045349)*bt_g0_33;
    bt_l1_57 = bt_l1_57 + (-0.041218750178813934)*bt_g0_34;
    bt_l1_57 = bt_l1_57 + (-0.02823277935385704)*bt_g0_35;
    bt_l1_57 = bt_l1_57 + (-0.12353185564279556)*bt_g0_36;
    bt_l1_57 = bt_l1_57 + (-0.051149368286132812)*bt_g0_37;
    bt_l1_57 = bt_l1_57 + (-0.15959499776363373)*bt_g0_38;
    bt_l1_57 = bt_l1_57 + (-0.24659667909145355)*bt_g0_39;
    bt_l1_57 = bt_l1_57 + (0.17941954731941223)*bt_g0_40;
    bt_l1_57 = bt_l1_57 + (0.037666864693164825)*bt_g0_41;
    bt_l1_57 = bt_l1_57 + (0.12880140542984009)*bt_g0_42;
    bt_l1_57 = bt_l1_57 + (-0.041056182235479355)*bt_g0_43;
    bt_l1_57 = bt_l1_57 + (-0.13686768710613251)*bt_g0_44;
    bt_l1_57 = bt_l1_57 + (0.11391717195510864)*bt_g0_45;
    bt_l1_57 = bt_l1_57 + (0.0041622943244874477)*bt_g0_46;
    bt_l1_57 = bt_l1_57 + (0.12101114541292191)*bt_g0_47;
    bt_l1_57 = bt_l1_57 + (0.17908869683742523)*bt_g0_48;
    bt_l1_57 = bt_l1_57 + (0.038592234253883362)*bt_g0_49;
    bt_l1_57 = bt_l1_57 + (-0.065856374800205231)*bt_g0_50;
    bt_l1_57 = bt_l1_57 + (-0.039111673831939697)*bt_g0_51;
    bt_l1_57 = bt_l1_57 + (-0.08204919844865799)*bt_g0_52;
    bt_l1_57 = bt_l1_57 + (-0.057228874415159225)*bt_g0_53;
    bt_l1_57 = bt_l1_57 + (0.029542315751314163)*bt_g0_54;
    bt_l1_57 = bt_l1_57 + (0.025685923174023628)*bt_g0_55;
    bt_l1_57 = bt_l1_57 + (0.026267077773809433)*bt_g0_56;
    bt_l1_57 = bt_l1_57 + (0.017196690663695335)*bt_g0_57;
    bt_l1_57 = bt_l1_57 + (-0.063653893768787384)*bt_g0_58;
    bt_l1_57 = bt_l1_57 + (0.090347684919834137)*bt_g0_59;
    bt_l1_57 = bt_l1_57 + (-0.0069559668190777302)*bt_g0_60;
    bt_l1_57 = bt_l1_57 + (-0.14650778472423553)*bt_g0_61;
    bt_l1_57 = bt_l1_57 + (-0.054623812437057495)*bt_g0_62;
    bt_l1_57 = bt_l1_57 + (-0.11789414286613464)*bt_g0_63;
    bt_l1_58 = 0.023790197446942329;
    bt_l1_58 = bt_l1_58 + (-0.191854327917099)*bt_g0_0;
    bt_l1_58 = bt_l1_58 + (-0.1380779892206192)*bt_g0_1;
    bt_l1_58 = bt_l1_58 + (0.15966279804706573)*bt_g0_2;
    bt_l1_58 = bt_l1_58 + (-0.072274558246135712)*bt_g0_3;
    bt_l1_58 = bt_l1_58 + (0.012429855763912201)*bt_g0_4;
    bt_l1_58 = bt_l1_58 + (0.41962048411369324)*bt_g0_5;
    bt_l1_58 = bt_l1_58 + (-0.087405078113079071)*bt_g0_6;
    bt_l1_58 = bt_l1_58 + (0.054273258894681931)*bt_g0_7;
    bt_l1_58 = bt_l1_58 + (0.038550388067960739)*bt_g0_8;
    bt_l1_58 = bt_l1_58 + (0.16888304054737091)*bt_g0_9;
    bt_l1_58 = bt_l1_58 + (-0.00027302806847728789)*bt_g0_10;
    bt_l1_58 = bt_l1_58 + (0.018384452909231186)*bt_g0_11;
    bt_l1_58 = bt_l1_58 + (0.005937445443123579)*bt_g0_12;
    bt_l1_58 = bt_l1_58 + (-0.11615700274705887)*bt_g0_13;
    bt_l1_58 = bt_l1_58 + (0.025318192318081856)*bt_g0_14;
    bt_l1_58 = bt_l1_58 + (0.39777383208274841)*bt_g0_15;
    bt_l1_58 = bt_l1_58 + (0.33553820848464966)*bt_g0_16;
    bt_l1_58 = bt_l1_58 + (0.015647487714886665)*bt_g0_17;
    bt_l1_58 = bt_l1_58 + (-0.13486151397228241)*bt_g0_18;
    bt_l1_58 = bt_l1_58 + (0.030051156878471375)*bt_g0_19;
    bt_l1_58 = bt_l1_58 + (0.1062944233417511)*bt_g0_20;
    bt_l1_58 = bt_l1_58 + (0.040416266769170761)*bt_g0_21;
    bt_l1_58 = bt_l1_58 + (-0.1696704775094986)*bt_g0_22;
    bt_l1_58 = bt_l1_58 + (0.34301933646202087)*bt_g0_23;
    bt_l1_58 = bt_l1_58 + (0.24071648716926575)*bt_g0_24;
    bt_l1_58 = bt_l1_58 + (-0.097899876534938812)*bt_g0_25;
    bt_l1_58 = bt_l1_58 + (0.083294562995433807)*bt_g0_26;
    bt_l1_58 = bt_l1_58 + (-0.0086629921570420265)*bt_g0_27;
    bt_l1_58 = bt_l1_58 + (0.35075089335441589)*bt_g0_28;
    bt_l1_58 = bt_l1_58 + (-0.056520108133554459)*bt_g0_29;
    bt_l1_58 = bt_l1_58 + (-0.13778330385684967)*bt_g0_30;
    bt_l1_58 = bt_l1_58 + (-0.13829332590103149)*bt_g0_31;
    bt_l1_58 = bt_l1_58 + (0.28960144519805908)*bt_g0_32;
    bt_l1_58 = bt_l1_58 + (-0.12687674164772034)*bt_g0_33;
    bt_l1_58 = bt_l1_58 + (-0.098442144691944122)*bt_g0_34;
    bt_l1_58 = bt_l1_58 + (0.043049417436122894)*bt_g0_35;
    bt_l1_58 = bt_l1_58 + (0.29661625623703003)*bt_g0_36;
    bt_l1_58 = bt_l1_58 + (0.081752531230449677)*bt_g0_37;
    bt_l1_58 = bt_l1_58 + (0.15905769169330597)*bt_g0_38;
    bt_l1_58 = bt_l1_58 + (0.16195088624954224)*bt_g0_39;
    bt_l1_58 = bt_l1_58 + (-0.10104640573263168)*bt_g0_40;
    bt_l1_58 = bt_l1_58 + (-0.063098125159740448)*bt_g0_41;
    bt_l1_58 = bt_l1_58 + (0.030233254656195641)*bt_g0_42;
    bt_l1_58 = bt_l1_58 + (-0.18023087084293365)*bt_g0_43;
    bt_l1_58 = bt_l1_58 + (0.078784845769405365)*bt_g0_44;
    bt_l1_58 = bt_l1_58 + (-0.24234247207641602)*bt_g0_45;
    bt_l1_58 = bt_l1_58 + (-0.25520673394203186)*bt_g0_46;
    bt_l1_58 = bt_l1_58 + (0.0015860310522839427)*bt_g0_47;
    bt_l1_58 = bt_l1_58 + (-0.087733760476112366)*bt_g0_48;
    bt_l1_58 = bt_l1_58 + (0.15455181896686554)*bt_g0_49;
    bt_l1_58 = bt_l1_58 + (-0.061263266950845718)*bt_g0_50;
    bt_l1_58 = bt_l1_58 + (0.13025398552417755)*bt_g0_51;
    bt_l1_58 = bt_l1_58 + (0.049015369266271591)*bt_g0_52;
    bt_l1_58 = bt_l1_58 + (-0.10397660732269287)*bt_g0_53;
    bt_l1_58 = bt_l1_58 + (0.081656903028488159)*bt_g0_54;
    bt_l1_58 = bt_l1_58 + (0.016763152554631233)*bt_g0_55;
    bt_l1_58 = bt_l1_58 + (-0.093122154474258423)*bt_g0_56;
    bt_l1_58 = bt_l1_58 + (-0.0065545253455638885)*bt_g0_57;
    bt_l1_58 = bt_l1_58 + (0.09278617799282074)*bt_g0_58;
    bt_l1_58 = bt_l1_58 + (-0.11781325191259384)*bt_g0_59;
    bt_l1_58 = bt_l1_58 + (0.024905823171138763)*bt_g0_60;
    bt_l1_58 = bt_l1_58 + (0.1916743665933609)*bt_g0_61;
    bt_l1_58 = bt_l1_58 + (0.3642461895942688)*bt_g0_62;
    bt_l1_58 = bt_l1_58 + (0.03497825562953949)*bt_g0_63;
    bt_l1_59 = 0.041995730251073837;
    bt_l1_59 = bt_l1_59 + (-0.077660873532295227)*bt_g0_0;
    bt_l1_59 = bt_l1_59 + (0.11264769732952118)*bt_g0_1;
    bt_l1_59 = bt_l1_59 + (-0.010953737422823906)*bt_g0_2;
    bt_l1_59 = bt_l1_59 + (-0.050618831068277359)*bt_g0_3;
    bt_l1_59 = bt_l1_59 + (0.014977222308516502)*bt_g0_4;
    bt_l1_59 = bt_l1_59 + (-0.13609312474727631)*bt_g0_5;
    bt_l1_59 = bt_l1_59 + (0.1104883998632431)*bt_g0_6;
    bt_l1_59 = bt_l1_59 + (-0.10576494783163071)*bt_g0_7;
    bt_l1_59 = bt_l1_59 + (-0.29058122634887695)*bt_g0_8;
    bt_l1_59 = bt_l1_59 + (-0.055634945631027222)*bt_g0_9;
    bt_l1_59 = bt_l1_59 + (-0.03628901019692421)*bt_g0_10;
    bt_l1_59 = bt_l1_59 + (0.10803987085819244)*bt_g0_11;
    bt_l1_59 = bt_l1_59 + (0.015943139791488647)*bt_g0_12;
    bt_l1_59 = bt_l1_59 + (0.011659784242510796)*bt_g0_13;
    bt_l1_59 = bt_l1_59 + (-0.10204503685235977)*bt_g0_14;
    bt_l1_59 = bt_l1_59 + (-0.12198946624994278)*bt_g0_15;
    bt_l1_59 = bt_l1_59 + (0.020585842430591583)*bt_g0_16;
    bt_l1_59 = bt_l1_59 + (-0.0911264568567276)*bt_g0_17;
    bt_l1_59 = bt_l1_59 + (0.11143919825553894)*bt_g0_18;
    bt_l1_59 = bt_l1_59 + (-0.010256017558276653)*bt_g0_19;
    bt_l1_59 = bt_l1_59 + (-0.080131255090236664)*bt_g0_20;
    bt_l1_59 = bt_l1_59 + (0.069891437888145447)*bt_g0_21;
    bt_l1_59 = bt_l1_59 + (0.0017791965510696173)*bt_g0_22;
    bt_l1_59 = bt_l1_59 + (-0.26889324188232422)*bt_g0_23;
    bt_l1_59 = bt_l1_59 + (-0.37404799461364746)*bt_g0_24;
    bt_l1_59 = bt_l1_59 + (0.14648178219795227)*bt_g0_25;
    bt_l1_59 = bt_l1_59 + (-0.033160146325826645)*bt_g0_26;
    bt_l1_59 = bt_l1_59 + (0.096988558769226074)*bt_g0_27;
    bt_l1_59 = bt_l1_59 + (-0.39476555585861206)*bt_g0_28;
    bt_l1_59 = bt_l1_59 + (-0.0082603590562939644)*bt_g0_29;
    bt_l1_59 = bt_l1_59 + (-0.027440281584858894)*bt_g0_30;
    bt_l1_59 = bt_l1_59 + (-0.0585455521941185)*bt_g0_31;
    bt_l1_59 = bt_l1_59 + (0.07850685715675354)*bt_g0_32;
    bt_l1_59 = bt_l1_59 + (0.18479534983634949)*bt_g0_33;
    bt_l1_59 = bt_l1_59 + (0.086212120950222015)*bt_g0_34;
    bt_l1_59 = bt_l1_59 + (-0.053705714643001556)*bt_g0_35;
    bt_l1_59 = bt_l1_59 + (-0.35322415828704834)*bt_g0_36;
    bt_l1_59 = bt_l1_59 + (-0.2298920750617981)*bt_g0_37;
    bt_l1_59 = bt_l1_59 + (-0.090429112315177917)*bt_g0_38;
    bt_l1_59 = bt_l1_59 + (-0.23472516238689423)*bt_g0_39;
    bt_l1_59 = bt_l1_59 + (-0.07548464834690094)*bt_g0_40;
    bt_l1_59 = bt_l1_59 + (0.086340822279453278)*bt_g0_41;
    bt_l1_59 = bt_l1_59 + (0.037380170077085495)*bt_g0_42;
    bt_l1_59 = bt_l1_59 + (-0.047225221991539001)*bt_g0_43;
    bt_l1_59 = bt_l1_59 + (-0.0402049720287323)*bt_g0_44;
    bt_l1_59 = bt_l1_59 + (0.031609710305929184)*bt_g0_45;
    bt_l1_59 = bt_l1_59 + (0.0075136362574994564)*bt_g0_46;
    bt_l1_59 = bt_l1_59 + (0.11918025463819504)*bt_g0_47;
    bt_l1_59 = bt_l1_59 + (0.1669013500213623)*bt_g0_48;
    bt_l1_59 = bt_l1_59 + (-0.062598362565040588)*bt_g0_49;
    bt_l1_59 = bt_l1_59 + (0.02225848101079464)*bt_g0_50;
    bt_l1_59 = bt_l1_59 + (-0.18488141894340515)*bt_g0_51;
    bt_l1_59 = bt_l1_59 + (-0.10568001121282578)*bt_g0_52;
    bt_l1_59 = bt_l1_59 + (0.0058508529327809811)*bt_g0_53;
    bt_l1_59 = bt_l1_59 + (0.14710539579391479)*bt_g0_54;
    bt_l1_59 = bt_l1_59 + (0.023200821131467819)*bt_g0_55;
    bt_l1_59 = bt_l1_59 + (0.042623993009328842)*bt_g0_56;
    bt_l1_59 = bt_l1_59 + (0.056010037660598755)*bt_g0_57;
    bt_l1_59 = bt_l1_59 + (-0.092357158660888672)*bt_g0_58;
    bt_l1_59 = bt_l1_59 + (0.094005227088928223)*bt_g0_59;
    bt_l1_59 = bt_l1_59 + (0.1156800240278244)*bt_g0_60;
    bt_l1_59 = bt_l1_59 + (-0.143083855509758)*bt_g0_61;
    bt_l1_59 = bt_l1_59 + (-0.042073141783475876)*bt_g0_62;
    bt_l1_59 = bt_l1_59 + (0.00085897650569677353)*bt_g0_63;
    bt_l1_60 = 0.09817216545343399;
    bt_l1_60 = bt_l1_60 + (0.058868855237960815)*bt_g0_0;
    bt_l1_60 = bt_l1_60 + (0.065110981464385986)*bt_g0_1;
    bt_l1_60 = bt_l1_60 + (-0.017222747206687927)*bt_g0_2;
    bt_l1_60 = bt_l1_60 + (-0.035897683352231979)*bt_g0_3;
    bt_l1_60 = bt_l1_60 + (0.14418689906597137)*bt_g0_4;
    bt_l1_60 = bt_l1_60 + (0.10261562466621399)*bt_g0_5;
    bt_l1_60 = bt_l1_60 + (0.11664306372404099)*bt_g0_6;
    bt_l1_60 = bt_l1_60 + (0.076625443994998932)*bt_g0_7;
    bt_l1_60 = bt_l1_60 + (-0.097980469465255737)*bt_g0_8;
    bt_l1_60 = bt_l1_60 + (0.075917512178421021)*bt_g0_9;
    bt_l1_60 = bt_l1_60 + (-0.0034417675342410803)*bt_g0_10;
    bt_l1_60 = bt_l1_60 + (0.1250280886888504)*bt_g0_11;
    bt_l1_60 = bt_l1_60 + (0.078999839723110199)*bt_g0_12;
    bt_l1_60 = bt_l1_60 + (0.13954076170921326)*bt_g0_13;
    bt_l1_60 = bt_l1_60 + (0.13240861892700195)*bt_g0_14;
    bt_l1_60 = bt_l1_60 + (-0.042842455208301544)*bt_g0_15;
    bt_l1_60 = bt_l1_60 + (0.21413221955299377)*bt_g0_16;
    bt_l1_60 = bt_l1_60 + (0.078405223786830902)*bt_g0_17;
    bt_l1_60 = bt_l1_60 + (-0.12817907333374023)*bt_g0_18;
    bt_l1_60 = bt_l1_60 + (-0.058156739920377731)*bt_g0_19;
    bt_l1_60 = bt_l1_60 + (-0.047319192439317703)*bt_g0_20;
    bt_l1_60 = bt_l1_60 + (0.14864397048950195)*bt_g0_21;
    bt_l1_60 = bt_l1_60 + (0.11036602407693863)*bt_g0_22;
    bt_l1_60 = bt_l1_60 + (0.13721172511577606)*bt_g0_23;
    bt_l1_60 = bt_l1_60 + (0.57935917377471924)*bt_g0_24;
    bt_l1_60 = bt_l1_60 + (0.61371326446533203)*bt_g0_25;
    bt_l1_60 = bt_l1_60 + (-0.21385449171066284)*bt_g0_26;
    bt_l1_60 = bt_l1_60 + (-0.13372944295406342)*bt_g0_27;
    bt_l1_60 = bt_l1_60 + (-0.88536345958709717)*bt_g0_28;
    bt_l1_60 = bt_l1_60 + (-0.14904804527759552)*bt_g0_29;
    bt_l1_60 = bt_l1_60 + (-0.063139967620372772)*bt_g0_30;
    bt_l1_60 = bt_l1_60 + (0.12058912217617035)*bt_g0_31;
    bt_l1_60 = bt_l1_60 + (-0.015574676916003227)*bt_g0_32;
    bt_l1_60 = bt_l1_60 + (-0.090690024197101593)*bt_g0_33;
    bt_l1_60 = bt_l1_60 + (0.02397955022752285)*bt_g0_34;
    bt_l1_60 = bt_l1_60 + (-0.20140968263149261)*bt_g0_35;
    bt_l1_60 = bt_l1_60 + (-0.084000147879123688)*bt_g0_36;
    bt_l1_60 = bt_l1_60 + (0.41965177655220032)*bt_g0_37;
    bt_l1_60 = bt_l1_60 + (0.12680846452713013)*bt_g0_38;
    bt_l1_60 = bt_l1_60 + (-0.37189087271690369)*bt_g0_39;
    bt_l1_60 = bt_l1_60 + (-0.052481602877378464)*bt_g0_40;
    bt_l1_60 = bt_l1_60 + (-0.073673076927661896)*bt_g0_41;
    bt_l1_60 = bt_l1_60 + (0.066683322191238403)*bt_g0_42;
    bt_l1_60 = bt_l1_60 + (0.047000855207443237)*bt_g0_43;
    bt_l1_60 = bt_l1_60 + (-0.13419504463672638)*bt_g0_44;
    bt_l1_60 = bt_l1_60 + (-0.095420919358730316)*bt_g0_45;
    bt_l1_60 = bt_l1_60 + (-0.033024121075868607)*bt_g0_46;
    bt_l1_60 = bt_l1_60 + (-0.057030443102121353)*bt_g0_47;
    bt_l1_60 = bt_l1_60 + (-0.1308312714099884)*bt_g0_48;
    bt_l1_60 = bt_l1_60 + (-0.075369462370872498)*bt_g0_49;
    bt_l1_60 = bt_l1_60 + (-0.013785272836685181)*bt_g0_50;
    bt_l1_60 = bt_l1_60 + (0.035255219787359238)*bt_g0_51;
    bt_l1_60 = bt_l1_60 + (0.18980570137500763)*bt_g0_52;
    bt_l1_60 = bt_l1_60 + (-0.12760618329048157)*bt_g0_53;
    bt_l1_60 = bt_l1_60 + (0.057008728384971619)*bt_g0_54;
    bt_l1_60 = bt_l1_60 + (0.027608590200543404)*bt_g0_55;
    bt_l1_60 = bt_l1_60 + (0.076930172741413116)*bt_g0_56;
    bt_l1_60 = bt_l1_60 + (0.030781833454966545)*bt_g0_57;
    bt_l1_60 = bt_l1_60 + (0.063313454389572144)*bt_g0_58;
    bt_l1_60 = bt_l1_60 + (-0.11310648918151855)*bt_g0_59;
    bt_l1_60 = bt_l1_60 + (-0.14234048128128052)*bt_g0_60;
    bt_l1_60 = bt_l1_60 + (0.20670142769813538)*bt_g0_61;
    bt_l1_60 = bt_l1_60 + (0.084251902997493744)*bt_g0_62;
    bt_l1_60 = bt_l1_60 + (0.034178376197814941)*bt_g0_63;
    bt_l1_61 = -0.051392834633588791;
    bt_l1_61 = bt_l1_61 + (0.021246695891022682)*bt_g0_0;
    bt_l1_61 = bt_l1_61 + (-0.07250300794839859)*bt_g0_1;
    bt_l1_61 = bt_l1_61 + (-0.087950095534324646)*bt_g0_2;
    bt_l1_61 = bt_l1_61 + (-0.023108866065740585)*bt_g0_3;
    bt_l1_61 = bt_l1_61 + (0.00023228002828545868)*bt_g0_4;
    bt_l1_61 = bt_l1_61 + (-0.010641337372362614)*bt_g0_5;
    bt_l1_61 = bt_l1_61 + (0.0097367633134126663)*bt_g0_6;
    bt_l1_61 = bt_l1_61 + (0.039066582918167114)*bt_g0_7;
    bt_l1_61 = bt_l1_61 + (-0.092632658779621124)*bt_g0_8;
    bt_l1_61 = bt_l1_61 + (0.045219559222459793)*bt_g0_9;
    bt_l1_61 = bt_l1_61 + (0.030435111373662949)*bt_g0_10;
    bt_l1_61 = bt_l1_61 + (0.074719846248626709)*bt_g0_11;
    bt_l1_61 = bt_l1_61 + (-0.13641723990440369)*bt_g0_12;
    bt_l1_61 = bt_l1_61 + (-0.036068998277187347)*bt_g0_13;
    bt_l1_61 = bt_l1_61 + (0.035132456570863724)*bt_g0_14;
    bt_l1_61 = bt_l1_61 + (0.024072771891951561)*bt_g0_15;
    bt_l1_61 = bt_l1_61 + (0.25007271766662598)*bt_g0_16;
    bt_l1_61 = bt_l1_61 + (0.0098945694044232368)*bt_g0_17;
    bt_l1_61 = bt_l1_61 + (0.018835131078958511)*bt_g0_18;
    bt_l1_61 = bt_l1_61 + (-0.048976007848978043)*bt_g0_19;
    bt_l1_61 = bt_l1_61 + (0.20147089660167694)*bt_g0_20;
    bt_l1_61 = bt_l1_61 + (-0.065140761435031891)*bt_g0_21;
    bt_l1_61 = bt_l1_61 + (-0.053972810506820679)*bt_g0_22;
    bt_l1_61 = bt_l1_61 + (0.081810474395751953)*bt_g0_23;
    bt_l1_61 = bt_l1_61 + (0.15089894831180573)*bt_g0_24;
    bt_l1_61 = bt_l1_61 + (0.19148415327072144)*bt_g0_25;
    bt_l1_61 = bt_l1_61 + (-0.0046911612153053284)*bt_g0_26;
    bt_l1_61 = bt_l1_61 + (-0.0692400261759758)*bt_g0_27;
    bt_l1_61 = bt_l1_61 + (-0.040461163967847824)*bt_g0_28;
    bt_l1_61 = bt_l1_61 + (-0.073865242302417755)*bt_g0_29;
    bt_l1_61 = bt_l1_61 + (0.045275676995515823)*bt_g0_30;
    bt_l1_61 = bt_l1_61 + (-0.051440227776765823)*bt_g0_31;
    bt_l1_61 = bt_l1_61 + (-0.18162687122821808)*bt_g0_32;
    bt_l1_61 = bt_l1_61 + (-0.093230269849300385)*bt_g0_33;
    bt_l1_61 = bt_l1_61 + (-0.016983790323138237)*bt_g0_34;
    bt_l1_61 = bt_l1_61 + (-0.045639526098966599)*bt_g0_35;
    bt_l1_61 = bt_l1_61 + (-0.024635627865791321)*bt_g0_36;
    bt_l1_61 = bt_l1_61 + (0.13243590295314789)*bt_g0_37;
    bt_l1_61 = bt_l1_61 + (0.035801757127046585)*bt_g0_38;
    bt_l1_61 = bt_l1_61 + (-0.072029933333396912)*bt_g0_39;
    bt_l1_61 = bt_l1_61 + (-0.0028059619944542646)*bt_g0_40;
    bt_l1_61 = bt_l1_61 + (0.025881849229335785)*bt_g0_41;
    bt_l1_61 = bt_l1_61 + (0.0039894119836390018)*bt_g0_42;
    bt_l1_61 = bt_l1_61 + (0.070650465786457062)*bt_g0_43;
    bt_l1_61 = bt_l1_61 + (-0.079762116074562073)*bt_g0_44;
    bt_l1_61 = bt_l1_61 + (0.075034916400909424)*bt_g0_45;
    bt_l1_61 = bt_l1_61 + (-0.088705457746982574)*bt_g0_46;
    bt_l1_61 = bt_l1_61 + (0.042116038501262665)*bt_g0_47;
    bt_l1_61 = bt_l1_61 + (-0.069343283772468567)*bt_g0_48;
    bt_l1_61 = bt_l1_61 + (0.0068680425174534321)*bt_g0_49;
    bt_l1_61 = bt_l1_61 + (-0.079326838254928589)*bt_g0_50;
    bt_l1_61 = bt_l1_61 + (0.059735603630542755)*bt_g0_51;
    bt_l1_61 = bt_l1_61 + (-0.022650651633739471)*bt_g0_52;
    bt_l1_61 = bt_l1_61 + (0.027716759592294693)*bt_g0_53;
    bt_l1_61 = bt_l1_61 + (-0.03352322056889534)*bt_g0_54;
    bt_l1_61 = bt_l1_61 + (0.04441365972161293)*bt_g0_55;
    bt_l1_61 = bt_l1_61 + (-0.056224435567855835)*bt_g0_56;
    bt_l1_61 = bt_l1_61 + (0.072162710130214691)*bt_g0_57;
    bt_l1_61 = bt_l1_61 + (0.12035655975341797)*bt_g0_58;
    bt_l1_61 = bt_l1_61 + (-0.075545072555541992)*bt_g0_59;
    bt_l1_61 = bt_l1_61 + (-0.0028766391333192587)*bt_g0_60;
    bt_l1_61 = bt_l1_61 + (0.025274282321333885)*bt_g0_61;
    bt_l1_61 = bt_l1_61 + (0.030088618397712708)*bt_g0_62;
    bt_l1_61 = bt_l1_61 + (-0.047141239047050476)*bt_g0_63;
    bt_l1_62 = 0.082446262240409851;
    bt_l1_62 = bt_l1_62 + (0.097697511315345764)*bt_g0_0;
    bt_l1_62 = bt_l1_62 + (0.16174718737602234)*bt_g0_1;
    bt_l1_62 = bt_l1_62 + (0.010055222548544407)*bt_g0_2;
    bt_l1_62 = bt_l1_62 + (0.10102237015962601)*bt_g0_3;
    bt_l1_62 = bt_l1_62 + (0.17186811566352844)*bt_g0_4;
    bt_l1_62 = bt_l1_62 + (-0.10919364541769028)*bt_g0_5;
    bt_l1_62 = bt_l1_62 + (0.10354131460189819)*bt_g0_6;
    bt_l1_62 = bt_l1_62 + (-0.093637123703956604)*bt_g0_7;
    bt_l1_62 = bt_l1_62 + (-0.13303478062152863)*bt_g0_8;
    bt_l1_62 = bt_l1_62 + (0.11800278723239899)*bt_g0_9;
    bt_l1_62 = bt_l1_62 + (0.0071960063651204109)*bt_g0_10;
    bt_l1_62 = bt_l1_62 + (0.041122928261756897)*bt_g0_11;
    bt_l1_62 = bt_l1_62 + (-0.025413449853658676)*bt_g0_12;
    bt_l1_62 = bt_l1_62 + (-0.061718251556158066)*bt_g0_13;
    bt_l1_62 = bt_l1_62 + (-0.035678442567586899)*bt_g0_14;
    bt_l1_62 = bt_l1_62 + (-0.13181799650192261)*bt_g0_15;
    bt_l1_62 = bt_l1_62 + (-0.11214374750852585)*bt_g0_16;
    bt_l1_62 = bt_l1_62 + (-0.04034809023141861)*bt_g0_17;
    bt_l1_62 = bt_l1_62 + (0.1304192841053009)*bt_g0_18;
    bt_l1_62 = bt_l1_62 + (0.11747395247220993)*bt_g0_19;
    bt_l1_62 = bt_l1_62 + (-0.02554994635283947)*bt_g0_20;
    bt_l1_62 = bt_l1_62 + (0.11829107999801636)*bt_g0_21;
    bt_l1_62 = bt_l1_62 + (-0.016118956729769707)*bt_g0_22;
    bt_l1_62 = bt_l1_62 + (0.047647561877965927)*bt_g0_23;
    bt_l1_62 = bt_l1_62 + (0.082920357584953308)*bt_g0_24;
    bt_l1_62 = bt_l1_62 + (0.037155795842409134)*bt_g0_25;
    bt_l1_62 = bt_l1_62 + (-0.01498070452362299)*bt_g0_26;
    bt_l1_62 = bt_l1_62 + (-0.026250714436173439)*bt_g0_27;
    bt_l1_62 = bt_l1_62 + (0.12665180861949921)*bt_g0_28;
    bt_l1_62 = bt_l1_62 + (0.057760324329137802)*bt_g0_29;
    bt_l1_62 = bt_l1_62 + (0.023682733997702599)*bt_g0_30;
    bt_l1_62 = bt_l1_62 + (0.057348601520061493)*bt_g0_31;
    bt_l1_62 = bt_l1_62 + (0.064255565404891968)*bt_g0_32;
    bt_l1_62 = bt_l1_62 + (-0.035451661795377731)*bt_g0_33;
    bt_l1_62 = bt_l1_62 + (-0.036895431578159332)*bt_g0_34;
    bt_l1_62 = bt_l1_62 + (-0.0073332898318767548)*bt_g0_35;
    bt_l1_62 = bt_l1_62 + (-0.22759860754013062)*bt_g0_36;
    bt_l1_62 = bt_l1_62 + (-0.19815626740455627)*bt_g0_37;
    bt_l1_62 = bt_l1_62 + (-0.20062190294265747)*bt_g0_38;
    bt_l1_62 = bt_l1_62 + (-0.11175821721553802)*bt_g0_39;
    bt_l1_62 = bt_l1_62 + (0.10797002911567688)*bt_g0_40;
    bt_l1_62 = bt_l1_62 + (-0.070996291935443878)*bt_g0_41;
    bt_l1_62 = bt_l1_62 + (-0.13283601403236389)*bt_g0_42;
    bt_l1_62 = bt_l1_62 + (0.097756169736385345)*bt_g0_43;
    bt_l1_62 = bt_l1_62 + (-0.07933247834444046)*bt_g0_44;
    bt_l1_62 = bt_l1_62 + (0.17305505275726318)*bt_g0_45;
    bt_l1_62 = bt_l1_62 + (0.067870296537876129)*bt_g0_46;
    bt_l1_62 = bt_l1_62 + (-0.11461030691862106)*bt_g0_47;
    bt_l1_62 = bt_l1_62 + (0.10840997844934464)*bt_g0_48;
    bt_l1_62 = bt_l1_62 + (0.013859823346138)*bt_g0_49;
    bt_l1_62 = bt_l1_62 + (0.079533763229846954)*bt_g0_50;
    bt_l1_62 = bt_l1_62 + (-0.068040557205677032)*bt_g0_51;
    bt_l1_62 = bt_l1_62 + (0.049552079290151596)*bt_g0_52;
    bt_l1_62 = bt_l1_62 + (0.11454278975725174)*bt_g0_53;
    bt_l1_62 = bt_l1_62 + (0.053496871143579483)*bt_g0_54;
    bt_l1_62 = bt_l1_62 + (0.012734353542327881)*bt_g0_55;
    bt_l1_62 = bt_l1_62 + (0.017213638871908188)*bt_g0_56;
    bt_l1_62 = bt_l1_62 + (0.036019962280988693)*bt_g0_57;
    bt_l1_62 = bt_l1_62 + (-0.078394815325737)*bt_g0_58;
    bt_l1_62 = bt_l1_62 + (-0.151994988322258)*bt_g0_59;
    bt_l1_62 = bt_l1_62 + (-0.018312854692339897)*bt_g0_60;
    bt_l1_62 = bt_l1_62 + (-0.15745252370834351)*bt_g0_61;
    bt_l1_62 = bt_l1_62 + (-0.24487118422985077)*bt_g0_62;
    bt_l1_62 = bt_l1_62 + (-0.0062623238191008568)*bt_g0_63;
    bt_l1_63 = 0.081055521965026855;
    bt_l1_63 = bt_l1_63 + (0.053242363035678864)*bt_g0_0;
    bt_l1_63 = bt_l1_63 + (-0.079887062311172485)*bt_g0_1;
    bt_l1_63 = bt_l1_63 + (0.040852371603250504)*bt_g0_2;
    bt_l1_63 = bt_l1_63 + (-0.19495132565498352)*bt_g0_3;
    bt_l1_63 = bt_l1_63 + (-0.030605025589466095)*bt_g0_4;
    bt_l1_63 = bt_l1_63 + (-0.21913352608680725)*bt_g0_5;
    bt_l1_63 = bt_l1_63 + (-0.2001984566450119)*bt_g0_6;
    bt_l1_63 = bt_l1_63 + (0.023735655471682549)*bt_g0_7;
    bt_l1_63 = bt_l1_63 + (0.21188387274742126)*bt_g0_8;
    bt_l1_63 = bt_l1_63 + (-0.018235772848129272)*bt_g0_9;
    bt_l1_63 = bt_l1_63 + (-0.0068283425644040108)*bt_g0_10;
    bt_l1_63 = bt_l1_63 + (-0.11579257994890213)*bt_g0_11;
    bt_l1_63 = bt_l1_63 + (-0.071008242666721344)*bt_g0_12;
    bt_l1_63 = bt_l1_63 + (-0.086719788610935211)*bt_g0_13;
    bt_l1_63 = bt_l1_63 + (-0.16635319590568542)*bt_g0_14;
    bt_l1_63 = bt_l1_63 + (0.11730216443538666)*bt_g0_15;
    bt_l1_63 = bt_l1_63 + (-0.095878526568412781)*bt_g0_16;
    bt_l1_63 = bt_l1_63 + (0.092149324715137482)*bt_g0_17;
    bt_l1_63 = bt_l1_63 + (0.018741194158792496)*bt_g0_18;
    bt_l1_63 = bt_l1_63 + (0.022022038698196411)*bt_g0_19;
    bt_l1_63 = bt_l1_63 + (0.017233803868293762)*bt_g0_20;
    bt_l1_63 = bt_l1_63 + (-0.096198715269565582)*bt_g0_21;
    bt_l1_63 = bt_l1_63 + (0.033317305147647858)*bt_g0_22;
    bt_l1_63 = bt_l1_63 + (-0.10428042709827423)*bt_g0_23;
    bt_l1_63 = bt_l1_63 + (0.058488819748163223)*bt_g0_24;
    bt_l1_63 = bt_l1_63 + (-0.38219025731086731)*bt_g0_25;
    bt_l1_63 = bt_l1_63 + (0.15557666122913361)*bt_g0_26;
    bt_l1_63 = bt_l1_63 + (0.0023786316160112619)*bt_g0_27;
    bt_l1_63 = bt_l1_63 + (0.060671456158161163)*bt_g0_28;
    bt_l1_63 = bt_l1_63 + (0.087717995047569275)*bt_g0_29;
    bt_l1_63 = bt_l1_63 + (-0.087128698825836182)*bt_g0_30;
    bt_l1_63 = bt_l1_63 + (0.056606575846672058)*bt_g0_31;
    bt_l1_63 = bt_l1_63 + (-0.12536731362342834)*bt_g0_32;
    bt_l1_63 = bt_l1_63 + (-0.087271116673946381)*bt_g0_33;
    bt_l1_63 = bt_l1_63 + (0.04485691711306572)*bt_g0_34;
    bt_l1_63 = bt_l1_63 + (0.13371145725250244)*bt_g0_35;
    bt_l1_63 = bt_l1_63 + (0.27272588014602661)*bt_g0_36;
    bt_l1_63 = bt_l1_63 + (0.21434755623340607)*bt_g0_37;
    bt_l1_63 = bt_l1_63 + (0.12678903341293335)*bt_g0_38;
    bt_l1_63 = bt_l1_63 + (0.096234098076820374)*bt_g0_39;
    bt_l1_63 = bt_l1_63 + (-0.12462873756885529)*bt_g0_40;
    bt_l1_63 = bt_l1_63 + (-0.1146358847618103)*bt_g0_41;
    bt_l1_63 = bt_l1_63 + (0.083003029227256775)*bt_g0_42;
    bt_l1_63 = bt_l1_63 + (-0.13831271231174469)*bt_g0_43;
    bt_l1_63 = bt_l1_63 + (-0.26532921195030212)*bt_g0_44;
    bt_l1_63 = bt_l1_63 + (-0.18277205526828766)*bt_g0_45;
    bt_l1_63 = bt_l1_63 + (-0.019149722531437874)*bt_g0_46;
    bt_l1_63 = bt_l1_63 + (-0.062303181737661362)*bt_g0_47;
    bt_l1_63 = bt_l1_63 + (0.0012521983589977026)*bt_g0_48;
    bt_l1_63 = bt_l1_63 + (0.028933132067322731)*bt_g0_49;
    bt_l1_63 = bt_l1_63 + (-0.022990155965089798)*bt_g0_50;
    bt_l1_63 = bt_l1_63 + (-0.10131999105215073)*bt_g0_51;
    bt_l1_63 = bt_l1_63 + (0.021538238972425461)*bt_g0_52;
    bt_l1_63 = bt_l1_63 + (0.0037436760030686855)*bt_g0_53;
    bt_l1_63 = bt_l1_63 + (-0.094865113496780396)*bt_g0_54;
    bt_l1_63 = bt_l1_63 + (0.092678748071193695)*bt_g0_55;
    bt_l1_63 = bt_l1_63 + (-0.080262079834938049)*bt_g0_56;
    bt_l1_63 = bt_l1_63 + (-0.10836941003799438)*bt_g0_57;
    bt_l1_63 = bt_l1_63 + (0.098608121275901794)*bt_g0_58;
    bt_l1_63 = bt_l1_63 + (0.15758807957172394)*bt_g0_59;
    bt_l1_63 = bt_l1_63 + (-0.020027292892336845)*bt_g0_60;
    bt_l1_63 = bt_l1_63 + (-0.036273416131734848)*bt_g0_61;
    bt_l1_63 = bt_l1_63 + (0.23625066876411438)*bt_g0_62;
    bt_l1_63 = bt_l1_63 + (0.022329298779368401)*bt_g0_63;
    bt1_mean = (bt_l1_0 + bt_l1_1 + bt_l1_2 + bt_l1_3 + bt_l1_4 + bt_l1_5 + bt_l1_6 + bt_l1_7 + bt_l1_8 + bt_l1_9 + bt_l1_10 + bt_l1_11 + bt_l1_12 + bt_l1_13 + bt_l1_14 + bt_l1_15 + bt_l1_16 + bt_l1_17 + bt_l1_18 + bt_l1_19 + bt_l1_20 + bt_l1_21 + bt_l1_22 + bt_l1_23 + bt_l1_24 + bt_l1_25 + bt_l1_26 + bt_l1_27 + bt_l1_28 + bt_l1_29 + bt_l1_30 + bt_l1_31 + bt_l1_32 + bt_l1_33 + bt_l1_34 + bt_l1_35 + bt_l1_36 + bt_l1_37 + bt_l1_38 + bt_l1_39 + bt_l1_40 + bt_l1_41 + bt_l1_42 + bt_l1_43 + bt_l1_44 + bt_l1_45 + bt_l1_46 + bt_l1_47 + bt_l1_48 + bt_l1_49 + bt_l1_50 + bt_l1_51 + bt_l1_52 + bt_l1_53 + bt_l1_54 + bt_l1_55 + bt_l1_56 + bt_l1_57 + bt_l1_58 + bt_l1_59 + bt_l1_60 + bt_l1_61 + bt_l1_62 + bt_l1_63) / 64;
    bt1_var = (((bt_l1_0) - bt1_mean)*((bt_l1_0) - bt1_mean) + ((bt_l1_1) - bt1_mean)*((bt_l1_1) - bt1_mean) + ((bt_l1_2) - bt1_mean)*((bt_l1_2) - bt1_mean) + ((bt_l1_3) - bt1_mean)*((bt_l1_3) - bt1_mean) + ((bt_l1_4) - bt1_mean)*((bt_l1_4) - bt1_mean) + ((bt_l1_5) - bt1_mean)*((bt_l1_5) - bt1_mean) + ((bt_l1_6) - bt1_mean)*((bt_l1_6) - bt1_mean) + ((bt_l1_7) - bt1_mean)*((bt_l1_7) - bt1_mean) + ((bt_l1_8) - bt1_mean)*((bt_l1_8) - bt1_mean) + ((bt_l1_9) - bt1_mean)*((bt_l1_9) - bt1_mean) + ((bt_l1_10) - bt1_mean)*((bt_l1_10) - bt1_mean) + ((bt_l1_11) - bt1_mean)*((bt_l1_11) - bt1_mean) + ((bt_l1_12) - bt1_mean)*((bt_l1_12) - bt1_mean) + ((bt_l1_13) - bt1_mean)*((bt_l1_13) - bt1_mean) + ((bt_l1_14) - bt1_mean)*((bt_l1_14) - bt1_mean) + ((bt_l1_15) - bt1_mean)*((bt_l1_15) - bt1_mean) + ((bt_l1_16) - bt1_mean)*((bt_l1_16) - bt1_mean) + ((bt_l1_17) - bt1_mean)*((bt_l1_17) - bt1_mean) + ((bt_l1_18) - bt1_mean)*((bt_l1_18) - bt1_mean) + ((bt_l1_19) - bt1_mean)*((bt_l1_19) - bt1_mean) + ((bt_l1_20) - bt1_mean)*((bt_l1_20) - bt1_mean) + ((bt_l1_21) - bt1_mean)*((bt_l1_21) - bt1_mean) + ((bt_l1_22) - bt1_mean)*((bt_l1_22) - bt1_mean) + ((bt_l1_23) - bt1_mean)*((bt_l1_23) - bt1_mean) + ((bt_l1_24) - bt1_mean)*((bt_l1_24) - bt1_mean) + ((bt_l1_25) - bt1_mean)*((bt_l1_25) - bt1_mean) + ((bt_l1_26) - bt1_mean)*((bt_l1_26) - bt1_mean) + ((bt_l1_27) - bt1_mean)*((bt_l1_27) - bt1_mean) + ((bt_l1_28) - bt1_mean)*((bt_l1_28) - bt1_mean) + ((bt_l1_29) - bt1_mean)*((bt_l1_29) - bt1_mean) + ((bt_l1_30) - bt1_mean)*((bt_l1_30) - bt1_mean) + ((bt_l1_31) - bt1_mean)*((bt_l1_31) - bt1_mean) + ((bt_l1_32) - bt1_mean)*((bt_l1_32) - bt1_mean) + ((bt_l1_33) - bt1_mean)*((bt_l1_33) - bt1_mean) + ((bt_l1_34) - bt1_mean)*((bt_l1_34) - bt1_mean) + ((bt_l1_35) - bt1_mean)*((bt_l1_35) - bt1_mean) + ((bt_l1_36) - bt1_mean)*((bt_l1_36) - bt1_mean) + ((bt_l1_37) - bt1_mean)*((bt_l1_37) - bt1_mean) + ((bt_l1_38) - bt1_mean)*((bt_l1_38) - bt1_mean) + ((bt_l1_39) - bt1_mean)*((bt_l1_39) - bt1_mean) + ((bt_l1_40) - bt1_mean)*((bt_l1_40) - bt1_mean) + ((bt_l1_41) - bt1_mean)*((bt_l1_41) - bt1_mean) + ((bt_l1_42) - bt1_mean)*((bt_l1_42) - bt1_mean) + ((bt_l1_43) - bt1_mean)*((bt_l1_43) - bt1_mean) + ((bt_l1_44) - bt1_mean)*((bt_l1_44) - bt1_mean) + ((bt_l1_45) - bt1_mean)*((bt_l1_45) - bt1_mean) + ((bt_l1_46) - bt1_mean)*((bt_l1_46) - bt1_mean) + ((bt_l1_47) - bt1_mean)*((bt_l1_47) - bt1_mean) + ((bt_l1_48) - bt1_mean)*((bt_l1_48) - bt1_mean) + ((bt_l1_49) - bt1_mean)*((bt_l1_49) - bt1_mean) + ((bt_l1_50) - bt1_mean)*((bt_l1_50) - bt1_mean) + ((bt_l1_51) - bt1_mean)*((bt_l1_51) - bt1_mean) + ((bt_l1_52) - bt1_mean)*((bt_l1_52) - bt1_mean) + ((bt_l1_53) - bt1_mean)*((bt_l1_53) - bt1_mean) + ((bt_l1_54) - bt1_mean)*((bt_l1_54) - bt1_mean) + ((bt_l1_55) - bt1_mean)*((bt_l1_55) - bt1_mean) + ((bt_l1_56) - bt1_mean)*((bt_l1_56) - bt1_mean) + ((bt_l1_57) - bt1_mean)*((bt_l1_57) - bt1_mean) + ((bt_l1_58) - bt1_mean)*((bt_l1_58) - bt1_mean) + ((bt_l1_59) - bt1_mean)*((bt_l1_59) - bt1_mean) + ((bt_l1_60) - bt1_mean)*((bt_l1_60) - bt1_mean) + ((bt_l1_61) - bt1_mean)*((bt_l1_61) - bt1_mean) + ((bt_l1_62) - bt1_mean)*((bt_l1_62) - bt1_mean) + ((bt_l1_63) - bt1_mean)*((bt_l1_63) - bt1_mean)) / 64;
    bt_n1_0 = (((bt_l1_0) - bt1_mean) / sqrt(bt1_var + ln_eps)) * (1.1280735731124878) + (-0.078351214528083801);
    bt_g1_0 = gelu_approx(bt_n1_0);
    bt_n1_1 = (((bt_l1_1) - bt1_mean) / sqrt(bt1_var + ln_eps)) * (1.6843913793563843) + (-0.18028208613395691);
    bt_g1_1 = gelu_approx(bt_n1_1);
    bt_n1_2 = (((bt_l1_2) - bt1_mean) / sqrt(bt1_var + ln_eps)) * (0.77138584852218628) + (-0.15971484780311584);
    bt_g1_2 = gelu_approx(bt_n1_2);
    bt_n1_3 = (((bt_l1_3) - bt1_mean) / sqrt(bt1_var + ln_eps)) * (0.8693498969078064) + (-0.068175733089447021);
    bt_g1_3 = gelu_approx(bt_n1_3);
    bt_n1_4 = (((bt_l1_4) - bt1_mean) / sqrt(bt1_var + ln_eps)) * (1.2694017887115479) + (-0.06950252503156662);
    bt_g1_4 = gelu_approx(bt_n1_4);
    bt_n1_5 = (((bt_l1_5) - bt1_mean) / sqrt(bt1_var + ln_eps)) * (1.3196588754653931) + (-0.2054765373468399);
    bt_g1_5 = gelu_approx(bt_n1_5);
    bt_n1_6 = (((bt_l1_6) - bt1_mean) / sqrt(bt1_var + ln_eps)) * (0.72691929340362549) + (-0.16757501661777496);
    bt_g1_6 = gelu_approx(bt_n1_6);
    bt_n1_7 = (((bt_l1_7) - bt1_mean) / sqrt(bt1_var + ln_eps)) * (1.2169077396392822) + (-0.16953457891941071);
    bt_g1_7 = gelu_approx(bt_n1_7);
    bt_n1_8 = (((bt_l1_8) - bt1_mean) / sqrt(bt1_var + ln_eps)) * (1.0206743478775024) + (-0.022980079054832458);
    bt_g1_8 = gelu_approx(bt_n1_8);
    bt_n1_9 = (((bt_l1_9) - bt1_mean) / sqrt(bt1_var + ln_eps)) * (1.0336717367172241) + (-0.08597862720489502);
    bt_g1_9 = gelu_approx(bt_n1_9);
    bt_n1_10 = (((bt_l1_10) - bt1_mean) / sqrt(bt1_var + ln_eps)) * (1.0443495512008667) + (0.0075568617321550846);
    bt_g1_10 = gelu_approx(bt_n1_10);
    bt_n1_11 = (((bt_l1_11) - bt1_mean) / sqrt(bt1_var + ln_eps)) * (0.98213201761245728) + (0.058352775871753693);
    bt_g1_11 = gelu_approx(bt_n1_11);
    bt_n1_12 = (((bt_l1_12) - bt1_mean) / sqrt(bt1_var + ln_eps)) * (1.1030983924865723) + (0.028452266007661819);
    bt_g1_12 = gelu_approx(bt_n1_12);
    bt_n1_13 = (((bt_l1_13) - bt1_mean) / sqrt(bt1_var + ln_eps)) * (1.1436107158660889) + (-0.010156826116144657);
    bt_g1_13 = gelu_approx(bt_n1_13);
    bt_n1_14 = (((bt_l1_14) - bt1_mean) / sqrt(bt1_var + ln_eps)) * (0.97405713796615601) + (-0.18611191213130951);
    bt_g1_14 = gelu_approx(bt_n1_14);
    bt_n1_15 = (((bt_l1_15) - bt1_mean) / sqrt(bt1_var + ln_eps)) * (0.87771594524383545) + (-0.15645833313465118);
    bt_g1_15 = gelu_approx(bt_n1_15);
    bt_n1_16 = (((bt_l1_16) - bt1_mean) / sqrt(bt1_var + ln_eps)) * (1.1325256824493408) + (-0.046884145587682724);
    bt_g1_16 = gelu_approx(bt_n1_16);
    bt_n1_17 = (((bt_l1_17) - bt1_mean) / sqrt(bt1_var + ln_eps)) * (1.9042993783950806) + (-0.047495149075984955);
    bt_g1_17 = gelu_approx(bt_n1_17);
    bt_n1_18 = (((bt_l1_18) - bt1_mean) / sqrt(bt1_var + ln_eps)) * (0.81336861848831177) + (-0.17485101521015167);
    bt_g1_18 = gelu_approx(bt_n1_18);
    bt_n1_19 = (((bt_l1_19) - bt1_mean) / sqrt(bt1_var + ln_eps)) * (3.0619289875030518) + (-0.035884015262126923);
    bt_g1_19 = gelu_approx(bt_n1_19);
    bt_n1_20 = (((bt_l1_20) - bt1_mean) / sqrt(bt1_var + ln_eps)) * (0.94217687845230103) + (-0.24187947809696198);
    bt_g1_20 = gelu_approx(bt_n1_20);
    bt_n1_21 = (((bt_l1_21) - bt1_mean) / sqrt(bt1_var + ln_eps)) * (0.59728217124938965) + (-0.25352621078491211);
    bt_g1_21 = gelu_approx(bt_n1_21);
    bt_n1_22 = (((bt_l1_22) - bt1_mean) / sqrt(bt1_var + ln_eps)) * (1.07611083984375) + (0.013423394411802292);
    bt_g1_22 = gelu_approx(bt_n1_22);
    bt_n1_23 = (((bt_l1_23) - bt1_mean) / sqrt(bt1_var + ln_eps)) * (1.1980350017547607) + (-0.23679150640964508);
    bt_g1_23 = gelu_approx(bt_n1_23);
    bt_n1_24 = (((bt_l1_24) - bt1_mean) / sqrt(bt1_var + ln_eps)) * (0.82207363843917847) + (-0.13717229664325714);
    bt_g1_24 = gelu_approx(bt_n1_24);
    bt_n1_25 = (((bt_l1_25) - bt1_mean) / sqrt(bt1_var + ln_eps)) * (1.3010783195495605) + (-0.20293155312538147);
    bt_g1_25 = gelu_approx(bt_n1_25);
    bt_n1_26 = (((bt_l1_26) - bt1_mean) / sqrt(bt1_var + ln_eps)) * (0.95235544443130493) + (-0.095661930739879608);
    bt_g1_26 = gelu_approx(bt_n1_26);
    bt_n1_27 = (((bt_l1_27) - bt1_mean) / sqrt(bt1_var + ln_eps)) * (1.0811029672622681) + (-0.011679845862090588);
    bt_g1_27 = gelu_approx(bt_n1_27);
    bt_n1_28 = (((bt_l1_28) - bt1_mean) / sqrt(bt1_var + ln_eps)) * (1.0865211486816406) + (0.0048494148068130016);
    bt_g1_28 = gelu_approx(bt_n1_28);
    bt_n1_29 = (((bt_l1_29) - bt1_mean) / sqrt(bt1_var + ln_eps)) * (1.4856864213943481) + (-0.29325872659683228);
    bt_g1_29 = gelu_approx(bt_n1_29);
    bt_n1_30 = (((bt_l1_30) - bt1_mean) / sqrt(bt1_var + ln_eps)) * (1.1220613718032837) + (-0.012452210299670696);
    bt_g1_30 = gelu_approx(bt_n1_30);
    bt_n1_31 = (((bt_l1_31) - bt1_mean) / sqrt(bt1_var + ln_eps)) * (0.98516589403152466) + (-0.074596107006072998);
    bt_g1_31 = gelu_approx(bt_n1_31);
    bt_n1_32 = (((bt_l1_32) - bt1_mean) / sqrt(bt1_var + ln_eps)) * (1.1823426485061646) + (-0.0050700688734650612);
    bt_g1_32 = gelu_approx(bt_n1_32);
    bt_n1_33 = (((bt_l1_33) - bt1_mean) / sqrt(bt1_var + ln_eps)) * (1.0454554557800293) + (-0.0046490468084812164);
    bt_g1_33 = gelu_approx(bt_n1_33);
    bt_n1_34 = (((bt_l1_34) - bt1_mean) / sqrt(bt1_var + ln_eps)) * (1.6560503244400024) + (-0.41571164131164551);
    bt_g1_34 = gelu_approx(bt_n1_34);
    bt_n1_35 = (((bt_l1_35) - bt1_mean) / sqrt(bt1_var + ln_eps)) * (1.0468875169754028) + (0.0088928686454892159);
    bt_g1_35 = gelu_approx(bt_n1_35);
    bt_n1_36 = (((bt_l1_36) - bt1_mean) / sqrt(bt1_var + ln_eps)) * (1.0831688642501831) + (-0.10419737547636032);
    bt_g1_36 = gelu_approx(bt_n1_36);
    bt_n1_37 = (((bt_l1_37) - bt1_mean) / sqrt(bt1_var + ln_eps)) * (1.0382622480392456) + (-0.31828135251998901);
    bt_g1_37 = gelu_approx(bt_n1_37);
    bt_n1_38 = (((bt_l1_38) - bt1_mean) / sqrt(bt1_var + ln_eps)) * (0.86653703451156616) + (-0.22347292304039001);
    bt_g1_38 = gelu_approx(bt_n1_38);
    bt_n1_39 = (((bt_l1_39) - bt1_mean) / sqrt(bt1_var + ln_eps)) * (0.97383534908294678) + (-0.0071528325788676739);
    bt_g1_39 = gelu_approx(bt_n1_39);
    bt_n1_40 = (((bt_l1_40) - bt1_mean) / sqrt(bt1_var + ln_eps)) * (0.74003618955612183) + (-0.17908154428005219);
    bt_g1_40 = gelu_approx(bt_n1_40);
    bt_n1_41 = (((bt_l1_41) - bt1_mean) / sqrt(bt1_var + ln_eps)) * (1.6166329383850098) + (0.034470204263925552);
    bt_g1_41 = gelu_approx(bt_n1_41);
    bt_n1_42 = (((bt_l1_42) - bt1_mean) / sqrt(bt1_var + ln_eps)) * (1.1888558864593506) + (-0.09695751965045929);
    bt_g1_42 = gelu_approx(bt_n1_42);
    bt_n1_43 = (((bt_l1_43) - bt1_mean) / sqrt(bt1_var + ln_eps)) * (1.1644679307937622) + (-0.045711871236562729);
    bt_g1_43 = gelu_approx(bt_n1_43);
    bt_n1_44 = (((bt_l1_44) - bt1_mean) / sqrt(bt1_var + ln_eps)) * (1.0455996990203857) + (-0.10940653085708618);
    bt_g1_44 = gelu_approx(bt_n1_44);
    bt_n1_45 = (((bt_l1_45) - bt1_mean) / sqrt(bt1_var + ln_eps)) * (0.94047915935516357) + (0.053224477916955948);
    bt_g1_45 = gelu_approx(bt_n1_45);
    bt_n1_46 = (((bt_l1_46) - bt1_mean) / sqrt(bt1_var + ln_eps)) * (0.94806760549545288) + (-0.058628693222999573);
    bt_g1_46 = gelu_approx(bt_n1_46);
    bt_n1_47 = (((bt_l1_47) - bt1_mean) / sqrt(bt1_var + ln_eps)) * (1.0211492776870728) + (0.082565963268280029);
    bt_g1_47 = gelu_approx(bt_n1_47);
    bt_n1_48 = (((bt_l1_48) - bt1_mean) / sqrt(bt1_var + ln_eps)) * (0.92146283388137817) + (-0.049049802124500275);
    bt_g1_48 = gelu_approx(bt_n1_48);
    bt_n1_49 = (((bt_l1_49) - bt1_mean) / sqrt(bt1_var + ln_eps)) * (1.1020396947860718) + (-0.026548748835921288);
    bt_g1_49 = gelu_approx(bt_n1_49);
    bt_n1_50 = (((bt_l1_50) - bt1_mean) / sqrt(bt1_var + ln_eps)) * (1.1004194021224976) + (0.025796279311180115);
    bt_g1_50 = gelu_approx(bt_n1_50);
    bt_n1_51 = (((bt_l1_51) - bt1_mean) / sqrt(bt1_var + ln_eps)) * (0.98632586002349854) + (0.0095824813470244408);
    bt_g1_51 = gelu_approx(bt_n1_51);
    bt_n1_52 = (((bt_l1_52) - bt1_mean) / sqrt(bt1_var + ln_eps)) * (1.079961895942688) + (-0.087970852851867676);
    bt_g1_52 = gelu_approx(bt_n1_52);
    bt_n1_53 = (((bt_l1_53) - bt1_mean) / sqrt(bt1_var + ln_eps)) * (1.040069580078125) + (-0.0023158886469900608);
    bt_g1_53 = gelu_approx(bt_n1_53);
    bt_n1_54 = (((bt_l1_54) - bt1_mean) / sqrt(bt1_var + ln_eps)) * (0.9177558422088623) + (-0.039916396141052246);
    bt_g1_54 = gelu_approx(bt_n1_54);
    bt_n1_55 = (((bt_l1_55) - bt1_mean) / sqrt(bt1_var + ln_eps)) * (1.0340968370437622) + (-0.010473758913576603);
    bt_g1_55 = gelu_approx(bt_n1_55);
    bt_n1_56 = (((bt_l1_56) - bt1_mean) / sqrt(bt1_var + ln_eps)) * (1.1117323637008667) + (0.054366137832403183);
    bt_g1_56 = gelu_approx(bt_n1_56);
    bt_n1_57 = (((bt_l1_57) - bt1_mean) / sqrt(bt1_var + ln_eps)) * (1.0170168876647949) + (-0.008950348012149334);
    bt_g1_57 = gelu_approx(bt_n1_57);
    bt_n1_58 = (((bt_l1_58) - bt1_mean) / sqrt(bt1_var + ln_eps)) * (1.6051535606384277) + (-0.039383381605148315);
    bt_g1_58 = gelu_approx(bt_n1_58);
    bt_n1_59 = (((bt_l1_59) - bt1_mean) / sqrt(bt1_var + ln_eps)) * (1.0610140562057495) + (0.02409859374165535);
    bt_g1_59 = gelu_approx(bt_n1_59);
    bt_n1_60 = (((bt_l1_60) - bt1_mean) / sqrt(bt1_var + ln_eps)) * (1.1327093839645386) + (-0.21985059976577759);
    bt_g1_60 = gelu_approx(bt_n1_60);
    bt_n1_61 = (((bt_l1_61) - bt1_mean) / sqrt(bt1_var + ln_eps)) * (0.76333111524581909) + (-0.12747533619403839);
    bt_g1_61 = gelu_approx(bt_n1_61);
    bt_n1_62 = (((bt_l1_62) - bt1_mean) / sqrt(bt1_var + ln_eps)) * (0.9180641770362854) + (-0.03489898145198822);
    bt_g1_62 = gelu_approx(bt_n1_62);
    bt_n1_63 = (((bt_l1_63) - bt1_mean) / sqrt(bt1_var + ln_eps)) * (0.88720506429672241) + (-0.32938241958618164);
    bt_g1_63 = gelu_approx(bt_n1_63);
    hv_0 = 0.089975945651531219;
    hv_0 = hv_0 + (0.10803452134132385)*bt_g1_0;
    hv_0 = hv_0 + (0.063317209482192993)*bt_g1_1;
    hv_0 = hv_0 + (-0.021735021844506264)*bt_g1_2;
    hv_0 = hv_0 + (-0.042751632630825043)*bt_g1_3;
    hv_0 = hv_0 + (-0.34085312485694885)*bt_g1_4;
    hv_0 = hv_0 + (-0.028955914080142975)*bt_g1_5;
    hv_0 = hv_0 + (-0.044292785227298737)*bt_g1_6;
    hv_0 = hv_0 + (-0.1909138560295105)*bt_g1_7;
    hv_0 = hv_0 + (-0.10494758188724518)*bt_g1_8;
    hv_0 = hv_0 + (-0.031430818140506744)*bt_g1_9;
    hv_0 = hv_0 + (-0.28136572241783142)*bt_g1_10;
    hv_0 = hv_0 + (-0.029149135574698448)*bt_g1_11;
    hv_0 = hv_0 + (0.12927044928073883)*bt_g1_12;
    hv_0 = hv_0 + (-0.19060474634170532)*bt_g1_13;
    hv_0 = hv_0 + (-0.01328894030302763)*bt_g1_14;
    hv_0 = hv_0 + (-0.037310965359210968)*bt_g1_15;
    hv_0 = hv_0 + (-0.15382249653339386)*bt_g1_16;
    hv_0 = hv_0 + (-0.0032546136062592268)*bt_g1_17;
    hv_0 = hv_0 + (0.040805600583553314)*bt_g1_18;
    hv_0 = hv_0 + (-0.20003905892372131)*bt_g1_19;
    hv_0 = hv_0 + (0.05011272057890892)*bt_g1_20;
    hv_0 = hv_0 + (-0.017336247488856316)*bt_g1_21;
    hv_0 = hv_0 + (-0.073002465069293976)*bt_g1_22;
    hv_0 = hv_0 + (-0.12715208530426025)*bt_g1_23;
    hv_0 = hv_0 + (-0.13176684081554413)*bt_g1_24;
    hv_0 = hv_0 + (-0.11755061149597168)*bt_g1_25;
    hv_0 = hv_0 + (0.065392814576625824)*bt_g1_26;
    hv_0 = hv_0 + (-0.18576546013355255)*bt_g1_27;
    hv_0 = hv_0 + (0.094904437661170959)*bt_g1_28;
    hv_0 = hv_0 + (0.14432571828365326)*bt_g1_29;
    hv_0 = hv_0 + (-0.3067658543586731)*bt_g1_30;
    hv_0 = hv_0 + (0.10192535817623138)*bt_g1_31;
    hv_0 = hv_0 + (-0.1556166410446167)*bt_g1_32;
    hv_0 = hv_0 + (-0.084713682532310486)*bt_g1_33;
    hv_0 = hv_0 + (0.099480666220188141)*bt_g1_34;
    hv_0 = hv_0 + (0.048510003834962845)*bt_g1_35;
    hv_0 = hv_0 + (0.073073290288448334)*bt_g1_36;
    hv_0 = hv_0 + (0.035391118377447128)*bt_g1_37;
    hv_0 = hv_0 + (-0.11602769047021866)*bt_g1_38;
    hv_0 = hv_0 + (-0.025468645617365837)*bt_g1_39;
    hv_0 = hv_0 + (0.0039855362847447395)*bt_g1_40;
    hv_0 = hv_0 + (-0.076880991458892822)*bt_g1_41;
    hv_0 = hv_0 + (-0.020430527627468109)*bt_g1_42;
    hv_0 = hv_0 + (-0.14934562146663666)*bt_g1_43;
    hv_0 = hv_0 + (-0.034803934395313263)*bt_g1_44;
    hv_0 = hv_0 + (0.039980627596378326)*bt_g1_45;
    hv_0 = hv_0 + (-0.033569019287824631)*bt_g1_46;
    hv_0 = hv_0 + (-0.091515563428401947)*bt_g1_47;
    hv_0 = hv_0 + (-0.12853001058101654)*bt_g1_48;
    hv_0 = hv_0 + (-0.04969961941242218)*bt_g1_49;
    hv_0 = hv_0 + (0.083703503012657166)*bt_g1_50;
    hv_0 = hv_0 + (0.090070158243179321)*bt_g1_51;
    hv_0 = hv_0 + (-0.077809721231460571)*bt_g1_52;
    hv_0 = hv_0 + (-0.15772543847560883)*bt_g1_53;
    hv_0 = hv_0 + (-0.02045433409512043)*bt_g1_54;
    hv_0 = hv_0 + (0.069321863353252411)*bt_g1_55;
    hv_0 = hv_0 + (-0.13590331375598907)*bt_g1_56;
    hv_0 = hv_0 + (0.14009645581245422)*bt_g1_57;
    hv_0 = hv_0 + (0.11241506785154343)*bt_g1_58;
    hv_0 = hv_0 + (0.15835928916931152)*bt_g1_59;
    hv_0 = hv_0 + (0.10682065784931183)*bt_g1_60;
    hv_0 = hv_0 + (0.027372637763619423)*bt_g1_61;
    hv_0 = hv_0 + (-0.11570487171411514)*bt_g1_62;
    hv_0 = hv_0 + (0.086645990610122681)*bt_g1_63;
    hv_1 = 0.074330359697341919;
    hv_1 = hv_1 + (0.086956232786178589)*bt_g1_0;
    hv_1 = hv_1 + (-0.29284897446632385)*bt_g1_1;
    hv_1 = hv_1 + (0.01931716687977314)*bt_g1_2;
    hv_1 = hv_1 + (0.042080633342266083)*bt_g1_3;
    hv_1 = hv_1 + (0.016745602712035179)*bt_g1_4;
    hv_1 = hv_1 + (0.0084526408463716507)*bt_g1_5;
    hv_1 = hv_1 + (-0.073265492916107178)*bt_g1_6;
    hv_1 = hv_1 + (0.064800523221492767)*bt_g1_7;
    hv_1 = hv_1 + (-0.30931228399276733)*bt_g1_8;
    hv_1 = hv_1 + (0.16397026181221008)*bt_g1_9;
    hv_1 = hv_1 + (-0.12620893120765686)*bt_g1_10;
    hv_1 = hv_1 + (-0.24968627095222473)*bt_g1_11;
    hv_1 = hv_1 + (-0.05648939311504364)*bt_g1_12;
    hv_1 = hv_1 + (-0.098972007632255554)*bt_g1_13;
    hv_1 = hv_1 + (-0.16224850714206696)*bt_g1_14;
    hv_1 = hv_1 + (-0.062190413475036621)*bt_g1_15;
    hv_1 = hv_1 + (0.31691193580627441)*bt_g1_16;
    hv_1 = hv_1 + (-0.061077922582626343)*bt_g1_17;
    hv_1 = hv_1 + (-0.0090429028496146202)*bt_g1_18;
    hv_1 = hv_1 + (-0.010001679882407188)*bt_g1_19;
    hv_1 = hv_1 + (-0.046753492206335068)*bt_g1_20;
    hv_1 = hv_1 + (0.046349119395017624)*bt_g1_21;
    hv_1 = hv_1 + (0.1082022488117218)*bt_g1_22;
    hv_1 = hv_1 + (-0.2330043762922287)*bt_g1_23;
    hv_1 = hv_1 + (0.016938285902142525)*bt_g1_24;
    hv_1 = hv_1 + (-0.19033414125442505)*bt_g1_25;
    hv_1 = hv_1 + (0.1631687730550766)*bt_g1_26;
    hv_1 = hv_1 + (0.075717024505138397)*bt_g1_27;
    hv_1 = hv_1 + (0.068031348288059235)*bt_g1_28;
    hv_1 = hv_1 + (0.020688079297542572)*bt_g1_29;
    hv_1 = hv_1 + (-0.15642338991165161)*bt_g1_30;
    hv_1 = hv_1 + (-0.014583364129066467)*bt_g1_31;
    hv_1 = hv_1 + (0.16507171094417572)*bt_g1_32;
    hv_1 = hv_1 + (-0.18003043532371521)*bt_g1_33;
    hv_1 = hv_1 + (-0.058112103492021561)*bt_g1_34;
    hv_1 = hv_1 + (0.035667739808559418)*bt_g1_35;
    hv_1 = hv_1 + (-0.14450079202651978)*bt_g1_36;
    hv_1 = hv_1 + (-0.169880211353302)*bt_g1_37;
    hv_1 = hv_1 + (-0.018617812544107437)*bt_g1_38;
    hv_1 = hv_1 + (0.041260208934545517)*bt_g1_39;
    hv_1 = hv_1 + (0.0014870702289044857)*bt_g1_40;
    hv_1 = hv_1 + (0.20881152153015137)*bt_g1_41;
    hv_1 = hv_1 + (0.25959905982017517)*bt_g1_42;
    hv_1 = hv_1 + (0.22862401604652405)*bt_g1_43;
    hv_1 = hv_1 + (-0.15193317830562592)*bt_g1_44;
    hv_1 = hv_1 + (-0.16383615136146545)*bt_g1_45;
    hv_1 = hv_1 + (0.12189781665802002)*bt_g1_46;
    hv_1 = hv_1 + (-0.28166952729225159)*bt_g1_47;
    hv_1 = hv_1 + (-0.073405452072620392)*bt_g1_48;
    hv_1 = hv_1 + (0.028621889650821686)*bt_g1_49;
    hv_1 = hv_1 + (0.11000411212444305)*bt_g1_50;
    hv_1 = hv_1 + (-0.049675259739160538)*bt_g1_51;
    hv_1 = hv_1 + (-0.29218938946723938)*bt_g1_52;
    hv_1 = hv_1 + (-0.30493456125259399)*bt_g1_53;
    hv_1 = hv_1 + (0.11533570289611816)*bt_g1_54;
    hv_1 = hv_1 + (-0.037901856005191803)*bt_g1_55;
    hv_1 = hv_1 + (0.036252327263355255)*bt_g1_56;
    hv_1 = hv_1 + (0.048540815711021423)*bt_g1_57;
    hv_1 = hv_1 + (0.60212123394012451)*bt_g1_58;
    hv_1 = hv_1 + (0.014807295054197311)*bt_g1_59;
    hv_1 = hv_1 + (0.19245150685310364)*bt_g1_60;
    hv_1 = hv_1 + (-0.048360656946897507)*bt_g1_61;
    hv_1 = hv_1 + (0.093964949250221252)*bt_g1_62;
    hv_1 = hv_1 + (0.0057084118016064167)*bt_g1_63;
    hv_2 = 0.064806871116161346;
    hv_2 = hv_2 + (0.003880626056343317)*bt_g1_0;
    hv_2 = hv_2 + (-0.15962064266204834)*bt_g1_1;
    hv_2 = hv_2 + (0.033133547753095627)*bt_g1_2;
    hv_2 = hv_2 + (0.040485717356204987)*bt_g1_3;
    hv_2 = hv_2 + (0.2200724333524704)*bt_g1_4;
    hv_2 = hv_2 + (0.3356705904006958)*bt_g1_5;
    hv_2 = hv_2 + (0.13072571158409119)*bt_g1_6;
    hv_2 = hv_2 + (-0.092210277915000916)*bt_g1_7;
    hv_2 = hv_2 + (-0.28845775127410889)*bt_g1_8;
    hv_2 = hv_2 + (0.021075734868645668)*bt_g1_9;
    hv_2 = hv_2 + (0.050799861550331116)*bt_g1_10;
    hv_2 = hv_2 + (-0.075921244919300079)*bt_g1_11;
    hv_2 = hv_2 + (-0.26271694898605347)*bt_g1_12;
    hv_2 = hv_2 + (0.071728579699993134)*bt_g1_13;
    hv_2 = hv_2 + (0.15404981374740601)*bt_g1_14;
    hv_2 = hv_2 + (0.12548033893108368)*bt_g1_15;
    hv_2 = hv_2 + (0.44875851273536682)*bt_g1_16;
    hv_2 = hv_2 + (0.10094510018825531)*bt_g1_17;
    hv_2 = hv_2 + (0.043213251978158951)*bt_g1_18;
    hv_2 = hv_2 + (-0.27987194061279297)*bt_g1_19;
    hv_2 = hv_2 + (0.066266357898712158)*bt_g1_20;
    hv_2 = hv_2 + (0.061477478593587875)*bt_g1_21;
    hv_2 = hv_2 + (-0.15273255109786987)*bt_g1_22;
    hv_2 = hv_2 + (0.0097356829792261124)*bt_g1_23;
    hv_2 = hv_2 + (0.080248214304447174)*bt_g1_24;
    hv_2 = hv_2 + (-0.24501888453960419)*bt_g1_25;
    hv_2 = hv_2 + (-0.0044098449870944023)*bt_g1_26;
    hv_2 = hv_2 + (-0.033109277486801147)*bt_g1_27;
    hv_2 = hv_2 + (0.036153927445411682)*bt_g1_28;
    hv_2 = hv_2 + (-0.13666778802871704)*bt_g1_29;
    hv_2 = hv_2 + (0.16255255043506622)*bt_g1_30;
    hv_2 = hv_2 + (0.045285418629646301)*bt_g1_31;
    hv_2 = hv_2 + (0.21465402841567993)*bt_g1_32;
    hv_2 = hv_2 + (0.27838677167892456)*bt_g1_33;
    hv_2 = hv_2 + (-0.28801211714744568)*bt_g1_34;
    hv_2 = hv_2 + (-0.10296311229467392)*bt_g1_35;
    hv_2 = hv_2 + (0.14294132590293884)*bt_g1_36;
    hv_2 = hv_2 + (-0.1549532413482666)*bt_g1_37;
    hv_2 = hv_2 + (0.1089709997177124)*bt_g1_38;
    hv_2 = hv_2 + (0.11321989446878433)*bt_g1_39;
    hv_2 = hv_2 + (-0.00020017630595248193)*bt_g1_40;
    hv_2 = hv_2 + (-0.024467365816235542)*bt_g1_41;
    hv_2 = hv_2 + (-0.094773821532726288)*bt_g1_42;
    hv_2 = hv_2 + (0.13443544507026672)*bt_g1_43;
    hv_2 = hv_2 + (-0.25154876708984375)*bt_g1_44;
    hv_2 = hv_2 + (-0.1426871120929718)*bt_g1_45;
    hv_2 = hv_2 + (-0.022837789729237556)*bt_g1_46;
    hv_2 = hv_2 + (-0.099902190268039703)*bt_g1_47;
    hv_2 = hv_2 + (-0.097305551171302795)*bt_g1_48;
    hv_2 = hv_2 + (0.1943979412317276)*bt_g1_49;
    hv_2 = hv_2 + (0.20912548899650574)*bt_g1_50;
    hv_2 = hv_2 + (-0.059442993253469467)*bt_g1_51;
    hv_2 = hv_2 + (-0.39241546392440796)*bt_g1_52;
    hv_2 = hv_2 + (0.16018562018871307)*bt_g1_53;
    hv_2 = hv_2 + (0.11894547939300537)*bt_g1_54;
    hv_2 = hv_2 + (0.086140893399715424)*bt_g1_55;
    hv_2 = hv_2 + (0.15053270757198334)*bt_g1_56;
    hv_2 = hv_2 + (0.12360756099224091)*bt_g1_57;
    hv_2 = hv_2 + (0.65250611305236816)*bt_g1_58;
    hv_2 = hv_2 + (-0.0030899518169462681)*bt_g1_59;
    hv_2 = hv_2 + (0.085868000984191895)*bt_g1_60;
    hv_2 = hv_2 + (0.024471275508403778)*bt_g1_61;
    hv_2 = hv_2 + (0.086685776710510254)*bt_g1_62;
    hv_2 = hv_2 + (-0.04630693793296814)*bt_g1_63;
    hv_3 = 0.11156391352415085;
    hv_3 = hv_3 + (0.012161803431808949)*bt_g1_0;
    hv_3 = hv_3 + (0.15682360529899597)*bt_g1_1;
    hv_3 = hv_3 + (-0.031104985624551773)*bt_g1_2;
    hv_3 = hv_3 + (-0.00079659093171358109)*bt_g1_3;
    hv_3 = hv_3 + (-0.058701857924461365)*bt_g1_4;
    hv_3 = hv_3 + (0.10240961611270905)*bt_g1_5;
    hv_3 = hv_3 + (-0.051269847899675369)*bt_g1_6;
    hv_3 = hv_3 + (0.08421923965215683)*bt_g1_7;
    hv_3 = hv_3 + (0.12812468409538269)*bt_g1_8;
    hv_3 = hv_3 + (0.056041520088911057)*bt_g1_9;
    hv_3 = hv_3 + (0.11853676289319992)*bt_g1_10;
    hv_3 = hv_3 + (-0.057913288474082947)*bt_g1_11;
    hv_3 = hv_3 + (-0.11832858622074127)*bt_g1_12;
    hv_3 = hv_3 + (-0.084502808749675751)*bt_g1_13;
    hv_3 = hv_3 + (-0.18487727642059326)*bt_g1_14;
    hv_3 = hv_3 + (-0.11024754494428635)*bt_g1_15;
    hv_3 = hv_3 + (-0.0028601479716598988)*bt_g1_16;
    hv_3 = hv_3 + (0.14721469581127167)*bt_g1_17;
    hv_3 = hv_3 + (-0.042098056524991989)*bt_g1_18;
    hv_3 = hv_3 + (-0.041895091533660889)*bt_g1_19;
    hv_3 = hv_3 + (-0.10288792103528976)*bt_g1_20;
    hv_3 = hv_3 + (0.12504057586193085)*bt_g1_21;
    hv_3 = hv_3 + (0.024905430153012276)*bt_g1_22;
    hv_3 = hv_3 + (-0.011850691400468349)*bt_g1_23;
    hv_3 = hv_3 + (-0.0025527128018438816)*bt_g1_24;
    hv_3 = hv_3 + (0.21276500821113586)*bt_g1_25;
    hv_3 = hv_3 + (-0.027116596698760986)*bt_g1_26;
    hv_3 = hv_3 + (-0.013524757698178291)*bt_g1_27;
    hv_3 = hv_3 + (-0.15726038813591003)*bt_g1_28;
    hv_3 = hv_3 + (-0.05869051069021225)*bt_g1_29;
    hv_3 = hv_3 + (0.19167520105838776)*bt_g1_30;
    hv_3 = hv_3 + (0.1392798125743866)*bt_g1_31;
    hv_3 = hv_3 + (-0.045651793479919434)*bt_g1_32;
    hv_3 = hv_3 + (0.36501514911651611)*bt_g1_33;
    hv_3 = hv_3 + (-0.018114252015948296)*bt_g1_34;
    hv_3 = hv_3 + (0.043926447629928589)*bt_g1_35;
    hv_3 = hv_3 + (0.15253816545009613)*bt_g1_36;
    hv_3 = hv_3 + (0.20136874914169312)*bt_g1_37;
    hv_3 = hv_3 + (0.051489736884832382)*bt_g1_38;
    hv_3 = hv_3 + (-0.0014558198163285851)*bt_g1_39;
    hv_3 = hv_3 + (-0.087956622242927551)*bt_g1_40;
    hv_3 = hv_3 + (0.043774042278528214)*bt_g1_41;
    hv_3 = hv_3 + (0.14981000125408173)*bt_g1_42;
    hv_3 = hv_3 + (-0.15587945282459259)*bt_g1_43;
    hv_3 = hv_3 + (0.015689965337514877)*bt_g1_44;
    hv_3 = hv_3 + (-0.027762284502387047)*bt_g1_45;
    hv_3 = hv_3 + (0.13417808711528778)*bt_g1_46;
    hv_3 = hv_3 + (0.093406349420547485)*bt_g1_47;
    hv_3 = hv_3 + (0.067230589687824249)*bt_g1_48;
    hv_3 = hv_3 + (0.060261070728302002)*bt_g1_49;
    hv_3 = hv_3 + (0.15570272505283356)*bt_g1_50;
    hv_3 = hv_3 + (0.12612991034984589)*bt_g1_51;
    hv_3 = hv_3 + (0.030387552455067635)*bt_g1_52;
    hv_3 = hv_3 + (-0.0077447681687772274)*bt_g1_53;
    hv_3 = hv_3 + (0.079639323055744171)*bt_g1_54;
    hv_3 = hv_3 + (0.090800389647483826)*bt_g1_55;
    hv_3 = hv_3 + (0.24079710245132446)*bt_g1_56;
    hv_3 = hv_3 + (0.10239497572183609)*bt_g1_57;
    hv_3 = hv_3 + (0.1369977742433548)*bt_g1_58;
    hv_3 = hv_3 + (0.020585855469107628)*bt_g1_59;
    hv_3 = hv_3 + (-0.048195019364356995)*bt_g1_60;
    hv_3 = hv_3 + (0.025789352133870125)*bt_g1_61;
    hv_3 = hv_3 + (-0.069926269352436066)*bt_g1_62;
    hv_3 = hv_3 + (0.069125428795814514)*bt_g1_63;
    hv_4 = -0.015837693586945534;
    hv_4 = hv_4 + (0.036146301776170731)*bt_g1_0;
    hv_4 = hv_4 + (0.035318769514560699)*bt_g1_1;
    hv_4 = hv_4 + (0.033752910792827606)*bt_g1_2;
    hv_4 = hv_4 + (-0.12075763940811157)*bt_g1_3;
    hv_4 = hv_4 + (-0.075723238289356232)*bt_g1_4;
    hv_4 = hv_4 + (-0.057664960622787476)*bt_g1_5;
    hv_4 = hv_4 + (-0.01024965662509203)*bt_g1_6;
    hv_4 = hv_4 + (-0.18551969528198242)*bt_g1_7;
    hv_4 = hv_4 + (-0.10167732834815979)*bt_g1_8;
    hv_4 = hv_4 + (0.10854823142290115)*bt_g1_9;
    hv_4 = hv_4 + (0.0039683859795331955)*bt_g1_10;
    hv_4 = hv_4 + (-0.12003421038389206)*bt_g1_11;
    hv_4 = hv_4 + (0.17721031606197357)*bt_g1_12;
    hv_4 = hv_4 + (0.14723557233810425)*bt_g1_13;
    hv_4 = hv_4 + (-0.047011155635118484)*bt_g1_14;
    hv_4 = hv_4 + (0.12872408330440521)*bt_g1_15;
    hv_4 = hv_4 + (-0.23445683717727661)*bt_g1_16;
    hv_4 = hv_4 + (0.0077689546160399914)*bt_g1_17;
    hv_4 = hv_4 + (0.089182697236537933)*bt_g1_18;
    hv_4 = hv_4 + (-0.068031787872314453)*bt_g1_19;
    hv_4 = hv_4 + (-0.038118764758110046)*bt_g1_20;
    hv_4 = hv_4 + (0.090575560927391052)*bt_g1_21;
    hv_4 = hv_4 + (0.049773532897233963)*bt_g1_22;
    hv_4 = hv_4 + (0.13943600654602051)*bt_g1_23;
    hv_4 = hv_4 + (0.11105038225650787)*bt_g1_24;
    hv_4 = hv_4 + (-0.042398404330015182)*bt_g1_25;
    hv_4 = hv_4 + (0.1286676824092865)*bt_g1_26;
    hv_4 = hv_4 + (0.22913208603858948)*bt_g1_27;
    hv_4 = hv_4 + (0.24722288548946381)*bt_g1_28;
    hv_4 = hv_4 + (-0.049746967852115631)*bt_g1_29;
    hv_4 = hv_4 + (-0.1069226935505867)*bt_g1_30;
    hv_4 = hv_4 + (0.021633898839354515)*bt_g1_31;
    hv_4 = hv_4 + (0.012493918649852276)*bt_g1_32;
    hv_4 = hv_4 + (-0.12614311277866364)*bt_g1_33;
    hv_4 = hv_4 + (0.11137234419584274)*bt_g1_34;
    hv_4 = hv_4 + (0.12500900030136108)*bt_g1_35;
    hv_4 = hv_4 + (0.060268931090831757)*bt_g1_36;
    hv_4 = hv_4 + (-0.027263009920716286)*bt_g1_37;
    hv_4 = hv_4 + (0.057842489331960678)*bt_g1_38;
    hv_4 = hv_4 + (-0.11325373500585556)*bt_g1_39;
    hv_4 = hv_4 + (-0.094222009181976318)*bt_g1_40;
    hv_4 = hv_4 + (0.014434630051255226)*bt_g1_41;
    hv_4 = hv_4 + (-0.01609940268099308)*bt_g1_42;
    hv_4 = hv_4 + (0.13479737937450409)*bt_g1_43;
    hv_4 = hv_4 + (-0.00049638701602816582)*bt_g1_44;
    hv_4 = hv_4 + (-0.13343422114849091)*bt_g1_45;
    hv_4 = hv_4 + (0.080158941447734833)*bt_g1_46;
    hv_4 = hv_4 + (-0.11568944156169891)*bt_g1_47;
    hv_4 = hv_4 + (-0.17011313140392303)*bt_g1_48;
    hv_4 = hv_4 + (-0.06017051637172699)*bt_g1_49;
    hv_4 = hv_4 + (0.035295818001031876)*bt_g1_50;
    hv_4 = hv_4 + (0.022284744307398796)*bt_g1_51;
    hv_4 = hv_4 + (-0.037888806313276291)*bt_g1_52;
    hv_4 = hv_4 + (-0.084887690842151642)*bt_g1_53;
    hv_4 = hv_4 + (0.14462876319885254)*bt_g1_54;
    hv_4 = hv_4 + (0.033321831375360489)*bt_g1_55;
    hv_4 = hv_4 + (-0.15647178888320923)*bt_g1_56;
    hv_4 = hv_4 + (0.11842608451843262)*bt_g1_57;
    hv_4 = hv_4 + (-0.084760271012783051)*bt_g1_58;
    hv_4 = hv_4 + (0.00022932032879907638)*bt_g1_59;
    hv_4 = hv_4 + (0.078504860401153564)*bt_g1_60;
    hv_4 = hv_4 + (-0.054200079292058945)*bt_g1_61;
    hv_4 = hv_4 + (0.066018089652061462)*bt_g1_62;
    hv_4 = hv_4 + (0.095735475420951843)*bt_g1_63;
    hv_5 = -0.19657456874847412;
    hv_5 = hv_5 + (-0.26901596784591675)*bt_g1_0;
    hv_5 = hv_5 + (-0.013507665134966373)*bt_g1_1;
    hv_5 = hv_5 + (0.015232502482831478)*bt_g1_2;
    hv_5 = hv_5 + (-0.1244020015001297)*bt_g1_3;
    hv_5 = hv_5 + (-0.13605454564094543)*bt_g1_4;
    hv_5 = hv_5 + (0.13596068322658539)*bt_g1_5;
    hv_5 = hv_5 + (-0.0063620111905038357)*bt_g1_6;
    hv_5 = hv_5 + (0.016317008063197136)*bt_g1_7;
    hv_5 = hv_5 + (0.10555163025856018)*bt_g1_8;
    hv_5 = hv_5 + (-0.092200480401515961)*bt_g1_9;
    hv_5 = hv_5 + (0.015841659158468246)*bt_g1_10;
    hv_5 = hv_5 + (0.060073979198932648)*bt_g1_11;
    hv_5 = hv_5 + (-0.1989985853433609)*bt_g1_12;
    hv_5 = hv_5 + (-0.10057135671377182)*bt_g1_13;
    hv_5 = hv_5 + (0.030328793451189995)*bt_g1_14;
    hv_5 = hv_5 + (0.046540915966033936)*bt_g1_15;
    hv_5 = hv_5 + (0.072101414203643799)*bt_g1_16;
    hv_5 = hv_5 + (-0.10793817788362503)*bt_g1_17;
    hv_5 = hv_5 + (-0.018491141498088837)*bt_g1_18;
    hv_5 = hv_5 + (-0.27816325426101685)*bt_g1_19;
    hv_5 = hv_5 + (-0.11621838063001633)*bt_g1_20;
    hv_5 = hv_5 + (0.061878129839897156)*bt_g1_21;
    hv_5 = hv_5 + (-0.27915573120117188)*bt_g1_22;
    hv_5 = hv_5 + (-0.056998971849679947)*bt_g1_23;
    hv_5 = hv_5 + (0.047567404806613922)*bt_g1_24;
    hv_5 = hv_5 + (0.066310316324234009)*bt_g1_25;
    hv_5 = hv_5 + (-0.099490851163864136)*bt_g1_26;
    hv_5 = hv_5 + (-0.14636602997779846)*bt_g1_27;
    hv_5 = hv_5 + (-0.055342584848403931)*bt_g1_28;
    hv_5 = hv_5 + (0.021469146013259888)*bt_g1_29;
    hv_5 = hv_5 + (-0.10404510051012039)*bt_g1_30;
    hv_5 = hv_5 + (-0.07032669335603714)*bt_g1_31;
    hv_5 = hv_5 + (-0.11752670258283615)*bt_g1_32;
    hv_5 = hv_5 + (-0.051293537020683289)*bt_g1_33;
    hv_5 = hv_5 + (0.18370965123176575)*bt_g1_34;
    hv_5 = hv_5 + (-0.23530896008014679)*bt_g1_35;
    hv_5 = hv_5 + (-0.078164771199226379)*bt_g1_36;
    hv_5 = hv_5 + (0.034363958984613419)*bt_g1_37;
    hv_5 = hv_5 + (0.056600045412778854)*bt_g1_38;
    hv_5 = hv_5 + (-0.055882487446069717)*bt_g1_39;
    hv_5 = hv_5 + (-0.010450187139213085)*bt_g1_40;
    hv_5 = hv_5 + (-0.074650079011917114)*bt_g1_41;
    hv_5 = hv_5 + (-0.2827160656452179)*bt_g1_42;
    hv_5 = hv_5 + (0.26253876090049744)*bt_g1_43;
    hv_5 = hv_5 + (0.16781696677207947)*bt_g1_44;
    hv_5 = hv_5 + (-0.087493419647216797)*bt_g1_45;
    hv_5 = hv_5 + (-0.12738333642482758)*bt_g1_46;
    hv_5 = hv_5 + (0.10042194277048111)*bt_g1_47;
    hv_5 = hv_5 + (0.00328831747174263)*bt_g1_48;
    hv_5 = hv_5 + (-0.25120770931243896)*bt_g1_49;
    hv_5 = hv_5 + (-0.16240829229354858)*bt_g1_50;
    hv_5 = hv_5 + (-0.12232062965631485)*bt_g1_51;
    hv_5 = hv_5 + (0.019727550446987152)*bt_g1_52;
    hv_5 = hv_5 + (-0.064908109605312347)*bt_g1_53;
    hv_5 = hv_5 + (-0.09708094596862793)*bt_g1_54;
    hv_5 = hv_5 + (-0.055654190480709076)*bt_g1_55;
    hv_5 = hv_5 + (-0.19617268443107605)*bt_g1_56;
    hv_5 = hv_5 + (-0.23231866955757141)*bt_g1_57;
    hv_5 = hv_5 + (0.19607318937778473)*bt_g1_58;
    hv_5 = hv_5 + (-0.25392261147499084)*bt_g1_59;
    hv_5 = hv_5 + (0.12148483842611313)*bt_g1_60;
    hv_5 = hv_5 + (0.025781117379665375)*bt_g1_61;
    hv_5 = hv_5 + (-0.13772827386856079)*bt_g1_62;
    hv_5 = hv_5 + (0.054297253489494324)*bt_g1_63;
    hv_6 = 0.090901918709278107;
    hv_6 = hv_6 + (-0.010031882673501968)*bt_g1_0;
    hv_6 = hv_6 + (0.217709019780159)*bt_g1_1;
    hv_6 = hv_6 + (-0.040698140859603882)*bt_g1_2;
    hv_6 = hv_6 + (0.087712585926055908)*bt_g1_3;
    hv_6 = hv_6 + (-0.085824951529502869)*bt_g1_4;
    hv_6 = hv_6 + (0.01301801111549139)*bt_g1_5;
    hv_6 = hv_6 + (0.092024534940719604)*bt_g1_6;
    hv_6 = hv_6 + (-0.073918774724006653)*bt_g1_7;
    hv_6 = hv_6 + (0.062607228755950928)*bt_g1_8;
    hv_6 = hv_6 + (-0.18017923831939697)*bt_g1_9;
    hv_6 = hv_6 + (0.10631377995014191)*bt_g1_10;
    hv_6 = hv_6 + (0.026403116062283516)*bt_g1_11;
    hv_6 = hv_6 + (-0.17588673532009125)*bt_g1_12;
    hv_6 = hv_6 + (-0.072180755436420441)*bt_g1_13;
    hv_6 = hv_6 + (0.018679346889257431)*bt_g1_14;
    hv_6 = hv_6 + (0.085152864456176758)*bt_g1_15;
    hv_6 = hv_6 + (0.036513935774564743)*bt_g1_16;
    hv_6 = hv_6 + (0.10597740113735199)*bt_g1_17;
    hv_6 = hv_6 + (0.080359101295471191)*bt_g1_18;
    hv_6 = hv_6 + (-0.12845727801322937)*bt_g1_19;
    hv_6 = hv_6 + (-0.00061764213023707271)*bt_g1_20;
    hv_6 = hv_6 + (0.066579163074493408)*bt_g1_21;
    hv_6 = hv_6 + (-0.065321594476699829)*bt_g1_22;
    hv_6 = hv_6 + (-0.035163432359695435)*bt_g1_23;
    hv_6 = hv_6 + (-0.021181747317314148)*bt_g1_24;
    hv_6 = hv_6 + (-0.0039048900362104177)*bt_g1_25;
    hv_6 = hv_6 + (0.048699621111154556)*bt_g1_26;
    hv_6 = hv_6 + (-0.16538123786449432)*bt_g1_27;
    hv_6 = hv_6 + (-0.36626201868057251)*bt_g1_28;
    hv_6 = hv_6 + (0.049870476126670837)*bt_g1_29;
    hv_6 = hv_6 + (0.067832767963409424)*bt_g1_30;
    hv_6 = hv_6 + (0.072486929595470428)*bt_g1_31;
    hv_6 = hv_6 + (-0.031420286744832993)*bt_g1_32;
    hv_6 = hv_6 + (0.039479613304138184)*bt_g1_33;
    hv_6 = hv_6 + (0.0087655670940876007)*bt_g1_34;
    hv_6 = hv_6 + (-0.23743121325969696)*bt_g1_35;
    hv_6 = hv_6 + (0.12982472777366638)*bt_g1_36;
    hv_6 = hv_6 + (0.065646670758724213)*bt_g1_37;
    hv_6 = hv_6 + (0.025641746819019318)*bt_g1_38;
    hv_6 = hv_6 + (-0.0071904086507856846)*bt_g1_39;
    hv_6 = hv_6 + (0.028216170147061348)*bt_g1_40;
    hv_6 = hv_6 + (0.23177134990692139)*bt_g1_41;
    hv_6 = hv_6 + (0.001144076231867075)*bt_g1_42;
    hv_6 = hv_6 + (0.0079022664576768875)*bt_g1_43;
    hv_6 = hv_6 + (0.14961729943752289)*bt_g1_44;
    hv_6 = hv_6 + (0.062253128737211227)*bt_g1_45;
    hv_6 = hv_6 + (0.11231657117605209)*bt_g1_46;
    hv_6 = hv_6 + (0.04247003048658371)*bt_g1_47;
    hv_6 = hv_6 + (-0.046467367559671402)*bt_g1_48;
    hv_6 = hv_6 + (0.0096083842217922211)*bt_g1_49;
    hv_6 = hv_6 + (-0.043292094022035599)*bt_g1_50;
    hv_6 = hv_6 + (0.15419705212116241)*bt_g1_51;
    hv_6 = hv_6 + (0.16192609071731567)*bt_g1_52;
    hv_6 = hv_6 + (0.022262034937739372)*bt_g1_53;
    hv_6 = hv_6 + (-0.018529137596487999)*bt_g1_54;
    hv_6 = hv_6 + (0.18632663786411285)*bt_g1_55;
    hv_6 = hv_6 + (0.04322197288274765)*bt_g1_56;
    hv_6 = hv_6 + (-0.20092882215976715)*bt_g1_57;
    hv_6 = hv_6 + (0.098350681364536285)*bt_g1_58;
    hv_6 = hv_6 + (-0.17909005284309387)*bt_g1_59;
    hv_6 = hv_6 + (0.063224852085113525)*bt_g1_60;
    hv_6 = hv_6 + (0.041665356606245041)*bt_g1_61;
    hv_6 = hv_6 + (0.067352332174777985)*bt_g1_62;
    hv_6 = hv_6 + (0.13937275111675262)*bt_g1_63;
    hv_7 = 0.080782972276210785;
    hv_7 = hv_7 + (-0.25474736094474792)*bt_g1_0;
    hv_7 = hv_7 + (-0.044457059353590012)*bt_g1_1;
    hv_7 = hv_7 + (0.09081963449716568)*bt_g1_2;
    hv_7 = hv_7 + (0.026554640382528305)*bt_g1_3;
    hv_7 = hv_7 + (0.12856993079185486)*bt_g1_4;
    hv_7 = hv_7 + (0.29293975234031677)*bt_g1_5;
    hv_7 = hv_7 + (-0.010178221389651299)*bt_g1_6;
    hv_7 = hv_7 + (-0.13908028602600098)*bt_g1_7;
    hv_7 = hv_7 + (0.049373261630535126)*bt_g1_8;
    hv_7 = hv_7 + (-0.062884755432605743)*bt_g1_9;
    hv_7 = hv_7 + (-0.11204705387353897)*bt_g1_10;
    hv_7 = hv_7 + (-0.0051706726662814617)*bt_g1_11;
    hv_7 = hv_7 + (-0.13654239475727081)*bt_g1_12;
    hv_7 = hv_7 + (0.036475580185651779)*bt_g1_13;
    hv_7 = hv_7 + (0.078950919210910797)*bt_g1_14;
    hv_7 = hv_7 + (0.11169120669364929)*bt_g1_15;
    hv_7 = hv_7 + (0.0023469773586839437)*bt_g1_16;
    hv_7 = hv_7 + (0.0035991624463349581)*bt_g1_17;
    hv_7 = hv_7 + (0.070538640022277832)*bt_g1_18;
    hv_7 = hv_7 + (-0.55027323961257935)*bt_g1_19;
    hv_7 = hv_7 + (0.042087405920028687)*bt_g1_20;
    hv_7 = hv_7 + (0.23315782845020294)*bt_g1_21;
    hv_7 = hv_7 + (-0.10614307224750519)*bt_g1_22;
    hv_7 = hv_7 + (0.19107809662818909)*bt_g1_23;
    hv_7 = hv_7 + (-0.013308317400515079)*bt_g1_24;
    hv_7 = hv_7 + (0.10652852058410645)*bt_g1_25;
    hv_7 = hv_7 + (0.11247773468494415)*bt_g1_26;
    hv_7 = hv_7 + (-0.058442376554012299)*bt_g1_27;
    hv_7 = hv_7 + (-0.014725606888532639)*bt_g1_28;
    hv_7 = hv_7 + (-0.01296269241720438)*bt_g1_29;
    hv_7 = hv_7 + (0.022858254611492157)*bt_g1_30;
    hv_7 = hv_7 + (0.014899498783051968)*bt_g1_31;
    hv_7 = hv_7 + (0.14250610768795013)*bt_g1_32;
    hv_7 = hv_7 + (0.19843535125255585)*bt_g1_33;
    hv_7 = hv_7 + (0.10653996467590332)*bt_g1_34;
    hv_7 = hv_7 + (-0.027332814410328865)*bt_g1_35;
    hv_7 = hv_7 + (0.37007796764373779)*bt_g1_36;
    hv_7 = hv_7 + (0.03789031133055687)*bt_g1_37;
    hv_7 = hv_7 + (0.082087159156799316)*bt_g1_38;
    hv_7 = hv_7 + (0.015264186076819897)*bt_g1_39;
    hv_7 = hv_7 + (0.11455016583204269)*bt_g1_40;
    hv_7 = hv_7 + (-0.33149588108062744)*bt_g1_41;
    hv_7 = hv_7 + (-0.20718194544315338)*bt_g1_42;
    hv_7 = hv_7 + (0.13307271897792816)*bt_g1_43;
    hv_7 = hv_7 + (-0.021592797711491585)*bt_g1_44;
    hv_7 = hv_7 + (-0.047078445553779602)*bt_g1_45;
    hv_7 = hv_7 + (0.11715837568044662)*bt_g1_46;
    hv_7 = hv_7 + (0.067623041570186615)*bt_g1_47;
    hv_7 = hv_7 + (-0.010031861253082752)*bt_g1_48;
    hv_7 = hv_7 + (-0.2486109584569931)*bt_g1_49;
    hv_7 = hv_7 + (0.026397330686450005)*bt_g1_50;
    hv_7 = hv_7 + (-0.093960583209991455)*bt_g1_51;
    hv_7 = hv_7 + (-0.047927528619766235)*bt_g1_52;
    hv_7 = hv_7 + (-0.10808232426643372)*bt_g1_53;
    hv_7 = hv_7 + (-0.0074294633232057095)*bt_g1_54;
    hv_7 = hv_7 + (0.086277268826961517)*bt_g1_55;
    hv_7 = hv_7 + (0.0066236099228262901)*bt_g1_56;
    hv_7 = hv_7 + (-0.056097302585840225)*bt_g1_57;
    hv_7 = hv_7 + (0.140168696641922)*bt_g1_58;
    hv_7 = hv_7 + (-0.12846668064594269)*bt_g1_59;
    hv_7 = hv_7 + (0.1372159868478775)*bt_g1_60;
    hv_7 = hv_7 + (-0.05621684342622757)*bt_g1_61;
    hv_7 = hv_7 + (0.1024726927280426)*bt_g1_62;
    hv_7 = hv_7 + (0.089726604521274567)*bt_g1_63;
    hv_8 = 0.018928084522485733;
    hv_8 = hv_8 + (-0.11509376764297485)*bt_g1_0;
    hv_8 = hv_8 + (0.079325020313262939)*bt_g1_1;
    hv_8 = hv_8 + (-0.15834805369377136)*bt_g1_2;
    hv_8 = hv_8 + (0.10734653472900391)*bt_g1_3;
    hv_8 = hv_8 + (-0.019158730283379555)*bt_g1_4;
    hv_8 = hv_8 + (-0.11551303416490555)*bt_g1_5;
    hv_8 = hv_8 + (-0.095059379935264587)*bt_g1_6;
    hv_8 = hv_8 + (-0.11505871266126633)*bt_g1_7;
    hv_8 = hv_8 + (0.055707454681396484)*bt_g1_8;
    hv_8 = hv_8 + (-0.37302553653717041)*bt_g1_9;
    hv_8 = hv_8 + (0.15811283886432648)*bt_g1_10;
    hv_8 = hv_8 + (0.081245899200439453)*bt_g1_11;
    hv_8 = hv_8 + (-0.18109875917434692)*bt_g1_12;
    hv_8 = hv_8 + (-0.2045082300901413)*bt_g1_13;
    hv_8 = hv_8 + (-0.26567992568016052)*bt_g1_14;
    hv_8 = hv_8 + (-0.011786828748881817)*bt_g1_15;
    hv_8 = hv_8 + (0.26392185688018799)*bt_g1_16;
    hv_8 = hv_8 + (0.13564935326576233)*bt_g1_17;
    hv_8 = hv_8 + (-0.11300850659608841)*bt_g1_18;
    hv_8 = hv_8 + (0.064484000205993652)*bt_g1_19;
    hv_8 = hv_8 + (-0.060323383659124374)*bt_g1_20;
    hv_8 = hv_8 + (0.13823850452899933)*bt_g1_21;
    hv_8 = hv_8 + (-0.15397119522094727)*bt_g1_22;
    hv_8 = hv_8 + (0.017277572304010391)*bt_g1_23;
    hv_8 = hv_8 + (-0.095176652073860168)*bt_g1_24;
    hv_8 = hv_8 + (0.14544332027435303)*bt_g1_25;
    hv_8 = hv_8 + (0.1112527996301651)*bt_g1_26;
    hv_8 = hv_8 + (-0.02122645266354084)*bt_g1_27;
    hv_8 = hv_8 + (-0.2052113264799118)*bt_g1_28;
    hv_8 = hv_8 + (0.038171559572219849)*bt_g1_29;
    hv_8 = hv_8 + (0.13417963683605194)*bt_g1_30;
    hv_8 = hv_8 + (0.19577677547931671)*bt_g1_31;
    hv_8 = hv_8 + (0.11779114603996277)*bt_g1_32;
    hv_8 = hv_8 + (0.20316019654273987)*bt_g1_33;
    hv_8 = hv_8 + (-0.13590700924396515)*bt_g1_34;
    hv_8 = hv_8 + (-0.13848035037517548)*bt_g1_35;
    hv_8 = hv_8 + (0.10608118027448654)*bt_g1_36;
    hv_8 = hv_8 + (-0.070657581090927124)*bt_g1_37;
    hv_8 = hv_8 + (0.048230327665805817)*bt_g1_38;
    hv_8 = hv_8 + (0.15287849307060242)*bt_g1_39;
    hv_8 = hv_8 + (-0.042564094066619873)*bt_g1_40;
    hv_8 = hv_8 + (-0.052576221525669098)*bt_g1_41;
    hv_8 = hv_8 + (0.17793571949005127)*bt_g1_42;
    hv_8 = hv_8 + (-0.10081075876951218)*bt_g1_43;
    hv_8 = hv_8 + (-0.1966390460729599)*bt_g1_44;
    hv_8 = hv_8 + (0.092667244374752045)*bt_g1_45;
    hv_8 = hv_8 + (0.053332556039094925)*bt_g1_46;
    hv_8 = hv_8 + (-0.051409758627414703)*bt_g1_47;
    hv_8 = hv_8 + (0.03421904519200325)*bt_g1_48;
    hv_8 = hv_8 + (-0.012739928439259529)*bt_g1_49;
    hv_8 = hv_8 + (-0.062446244060993195)*bt_g1_50;
    hv_8 = hv_8 + (0.13704326748847961)*bt_g1_51;
    hv_8 = hv_8 + (-0.099023804068565369)*bt_g1_52;
    hv_8 = hv_8 + (0.10416535288095474)*bt_g1_53;
    hv_8 = hv_8 + (-0.25162804126739502)*bt_g1_54;
    hv_8 = hv_8 + (0.1425454169511795)*bt_g1_55;
    hv_8 = hv_8 + (0.14402666687965393)*bt_g1_56;
    hv_8 = hv_8 + (-0.21260404586791992)*bt_g1_57;
    hv_8 = hv_8 + (-0.045306049287319183)*bt_g1_58;
    hv_8 = hv_8 + (-0.16292968392372131)*bt_g1_59;
    hv_8 = hv_8 + (0.076824039220809937)*bt_g1_60;
    hv_8 = hv_8 + (0.0052228639833629131)*bt_g1_61;
    hv_8 = hv_8 + (0.10529804229736328)*bt_g1_62;
    hv_8 = hv_8 + (-0.029726983979344368)*bt_g1_63;
    hv_9 = -0.030944639816880226;
    hv_9 = hv_9 + (-0.070896409451961517)*bt_g1_0;
    hv_9 = hv_9 + (0.10737991333007812)*bt_g1_1;
    hv_9 = hv_9 + (-0.071229010820388794)*bt_g1_2;
    hv_9 = hv_9 + (0.18794621527194977)*bt_g1_3;
    hv_9 = hv_9 + (-0.051475316286087036)*bt_g1_4;
    hv_9 = hv_9 + (0.093212507665157318)*bt_g1_5;
    hv_9 = hv_9 + (-0.0056046280078589916)*bt_g1_6;
    hv_9 = hv_9 + (0.077645488083362579)*bt_g1_7;
    hv_9 = hv_9 + (0.045095846056938171)*bt_g1_8;
    hv_9 = hv_9 + (-0.13678079843521118)*bt_g1_9;
    hv_9 = hv_9 + (0.053753852844238281)*bt_g1_10;
    hv_9 = hv_9 + (0.2086193859577179)*bt_g1_11;
    hv_9 = hv_9 + (-0.061116453260183334)*bt_g1_12;
    hv_9 = hv_9 + (-0.16879421472549438)*bt_g1_13;
    hv_9 = hv_9 + (-0.085873454809188843)*bt_g1_14;
    hv_9 = hv_9 + (0.017380539327859879)*bt_g1_15;
    hv_9 = hv_9 + (0.12336308509111404)*bt_g1_16;
    hv_9 = hv_9 + (0.17196463048458099)*bt_g1_17;
    hv_9 = hv_9 + (0.01735946349799633)*bt_g1_18;
    hv_9 = hv_9 + (-0.54747354984283447)*bt_g1_19;
    hv_9 = hv_9 + (-0.022971726953983307)*bt_g1_20;
    hv_9 = hv_9 + (-0.084249503910541534)*bt_g1_21;
    hv_9 = hv_9 + (0.098550595343112946)*bt_g1_22;
    hv_9 = hv_9 + (0.10907132178544998)*bt_g1_23;
    hv_9 = hv_9 + (-0.044164270162582397)*bt_g1_24;
    hv_9 = hv_9 + (0.25315508246421814)*bt_g1_25;
    hv_9 = hv_9 + (0.0018708329880610108)*bt_g1_26;
    hv_9 = hv_9 + (0.038582179695367813)*bt_g1_27;
    hv_9 = hv_9 + (-0.061235204339027405)*bt_g1_28;
    hv_9 = hv_9 + (0.027509497478604317)*bt_g1_29;
    hv_9 = hv_9 + (0.17295421659946442)*bt_g1_30;
    hv_9 = hv_9 + (0.11457425355911255)*bt_g1_31;
    hv_9 = hv_9 + (0.18768921494483948)*bt_g1_32;
    hv_9 = hv_9 + (0.11144848167896271)*bt_g1_33;
    hv_9 = hv_9 + (-0.11912362277507782)*bt_g1_34;
    hv_9 = hv_9 + (0.014566042460501194)*bt_g1_35;
    hv_9 = hv_9 + (0.037655264139175415)*bt_g1_36;
    hv_9 = hv_9 + (-0.019824624061584473)*bt_g1_37;
    hv_9 = hv_9 + (-0.1048654168844223)*bt_g1_38;
    hv_9 = hv_9 + (0.18437136709690094)*bt_g1_39;
    hv_9 = hv_9 + (0.012553504668176174)*bt_g1_40;
    hv_9 = hv_9 + (-0.40988120436668396)*bt_g1_41;
    hv_9 = hv_9 + (0.023432040587067604)*bt_g1_42;
    hv_9 = hv_9 + (0.0064745321869850159)*bt_g1_43;
    hv_9 = hv_9 + (-0.047637045383453369)*bt_g1_44;
    hv_9 = hv_9 + (0.20024120807647705)*bt_g1_45;
    hv_9 = hv_9 + (0.11706095933914185)*bt_g1_46;
    hv_9 = hv_9 + (0.13109079003334045)*bt_g1_47;
    hv_9 = hv_9 + (0.17416208982467651)*bt_g1_48;
    hv_9 = hv_9 + (-0.13621549308300018)*bt_g1_49;
    hv_9 = hv_9 + (0.13862176239490509)*bt_g1_50;
    hv_9 = hv_9 + (0.15798252820968628)*bt_g1_51;
    hv_9 = hv_9 + (-0.13357260823249817)*bt_g1_52;
    hv_9 = hv_9 + (0.11335825175046921)*bt_g1_53;
    hv_9 = hv_9 + (-0.028056547045707703)*bt_g1_54;
    hv_9 = hv_9 + (0.075048930943012238)*bt_g1_55;
    hv_9 = hv_9 + (0.25453528761863708)*bt_g1_56;
    hv_9 = hv_9 + (-0.014412698335945606)*bt_g1_57;
    hv_9 = hv_9 + (-0.0045714066363871098)*bt_g1_58;
    hv_9 = hv_9 + (-0.0010691718198359013)*bt_g1_59;
    hv_9 = hv_9 + (0.033831123262643814)*bt_g1_60;
    hv_9 = hv_9 + (0.10934905707836151)*bt_g1_61;
    hv_9 = hv_9 + (0.090176932513713837)*bt_g1_62;
    hv_9 = hv_9 + (-0.13782955706119537)*bt_g1_63;
    hv_10 = -0.12957492470741272;
    hv_10 = hv_10 + (0.084422260522842407)*bt_g1_0;
    hv_10 = hv_10 + (-0.05410487949848175)*bt_g1_1;
    hv_10 = hv_10 + (0.002661596518009901)*bt_g1_2;
    hv_10 = hv_10 + (0.085997387766838074)*bt_g1_3;
    hv_10 = hv_10 + (0.046346813440322876)*bt_g1_4;
    hv_10 = hv_10 + (-0.027589717879891396)*bt_g1_5;
    hv_10 = hv_10 + (0.01172013022005558)*bt_g1_6;
    hv_10 = hv_10 + (-0.00057530595222488046)*bt_g1_7;
    hv_10 = hv_10 + (-0.069408126175403595)*bt_g1_8;
    hv_10 = hv_10 + (0.0047896243631839752)*bt_g1_9;
    hv_10 = hv_10 + (-0.18605351448059082)*bt_g1_10;
    hv_10 = hv_10 + (-0.11282987892627716)*bt_g1_11;
    hv_10 = hv_10 + (0.18878659605979919)*bt_g1_12;
    hv_10 = hv_10 + (-0.11408737301826477)*bt_g1_13;
    hv_10 = hv_10 + (0.072207011282444)*bt_g1_14;
    hv_10 = hv_10 + (-0.065806716680526733)*bt_g1_15;
    hv_10 = hv_10 + (-0.1513821929693222)*bt_g1_16;
    hv_10 = hv_10 + (-0.070360630750656128)*bt_g1_17;
    hv_10 = hv_10 + (0.078818731009960175)*bt_g1_18;
    hv_10 = hv_10 + (-0.069333732128143311)*bt_g1_19;
    hv_10 = hv_10 + (0.25646424293518066)*bt_g1_20;
    hv_10 = hv_10 + (-0.062997497618198395)*bt_g1_21;
    hv_10 = hv_10 + (0.13081361353397369)*bt_g1_22;
    hv_10 = hv_10 + (-0.13096463680267334)*bt_g1_23;
    hv_10 = hv_10 + (-0.073646806180477142)*bt_g1_24;
    hv_10 = hv_10 + (-0.016333853825926781)*bt_g1_25;
    hv_10 = hv_10 + (0.047669634222984314)*bt_g1_26;
    hv_10 = hv_10 + (0.052671235054731369)*bt_g1_27;
    hv_10 = hv_10 + (0.27397865056991577)*bt_g1_28;
    hv_10 = hv_10 + (0.1443629264831543)*bt_g1_29;
    hv_10 = hv_10 + (-0.10800620168447495)*bt_g1_30;
    hv_10 = hv_10 + (-0.13353937864303589)*bt_g1_31;
    hv_10 = hv_10 + (-0.025829194113612175)*bt_g1_32;
    hv_10 = hv_10 + (-0.0026957306545227766)*bt_g1_33;
    hv_10 = hv_10 + (0.026040807366371155)*bt_g1_34;
    hv_10 = hv_10 + (0.050419017672538757)*bt_g1_35;
    hv_10 = hv_10 + (-0.058515105396509171)*bt_g1_36;
    hv_10 = hv_10 + (-0.084168218076229095)*bt_g1_37;
    hv_10 = hv_10 + (-0.046390991657972336)*bt_g1_38;
    hv_10 = hv_10 + (-0.06596829742193222)*bt_g1_39;
    hv_10 = hv_10 + (0.095511049032211304)*bt_g1_40;
    hv_10 = hv_10 + (-0.17308983206748962)*bt_g1_41;
    hv_10 = hv_10 + (-0.077076859772205353)*bt_g1_42;
    hv_10 = hv_10 + (-0.16666325926780701)*bt_g1_43;
    hv_10 = hv_10 + (-0.008484850637614727)*bt_g1_44;
    hv_10 = hv_10 + (0.016032103449106216)*bt_g1_45;
    hv_10 = hv_10 + (-0.092270292341709137)*bt_g1_46;
    hv_10 = hv_10 + (-0.16231244802474976)*bt_g1_47;
    hv_10 = hv_10 + (-0.059585880488157272)*bt_g1_48;
    hv_10 = hv_10 + (0.06892799586057663)*bt_g1_49;
    hv_10 = hv_10 + (0.052933212369680405)*bt_g1_50;
    hv_10 = hv_10 + (0.017253903672099113)*bt_g1_51;
    hv_10 = hv_10 + (-0.024244166910648346)*bt_g1_52;
    hv_10 = hv_10 + (-0.08451833575963974)*bt_g1_53;
    hv_10 = hv_10 + (0.18460094928741455)*bt_g1_54;
    hv_10 = hv_10 + (-0.097219355404376984)*bt_g1_55;
    hv_10 = hv_10 + (-0.039641380310058594)*bt_g1_56;
    hv_10 = hv_10 + (0.016702929511666298)*bt_g1_57;
    hv_10 = hv_10 + (-0.20506367087364197)*bt_g1_58;
    hv_10 = hv_10 + (0.19217170774936676)*bt_g1_59;
    hv_10 = hv_10 + (-0.0446474589407444)*bt_g1_60;
    hv_10 = hv_10 + (-0.058354627341032028)*bt_g1_61;
    hv_10 = hv_10 + (0.032169248908758163)*bt_g1_62;
    hv_10 = hv_10 + (0.060134962201118469)*bt_g1_63;
    hv_11 = -0.0027253415901213884;
    hv_11 = hv_11 + (-0.12299813330173492)*bt_g1_0;
    hv_11 = hv_11 + (-0.19494457542896271)*bt_g1_1;
    hv_11 = hv_11 + (-0.09695880115032196)*bt_g1_2;
    hv_11 = hv_11 + (0.15615084767341614)*bt_g1_3;
    hv_11 = hv_11 + (-0.052019432187080383)*bt_g1_4;
    hv_11 = hv_11 + (0.25010854005813599)*bt_g1_5;
    hv_11 = hv_11 + (0.051469307392835617)*bt_g1_6;
    hv_11 = hv_11 + (-0.30119875073432922)*bt_g1_7;
    hv_11 = hv_11 + (0.26534944772720337)*bt_g1_8;
    hv_11 = hv_11 + (-0.071825981140136719)*bt_g1_9;
    hv_11 = hv_11 + (0.0015959430020302534)*bt_g1_10;
    hv_11 = hv_11 + (0.051927637308835983)*bt_g1_11;
    hv_11 = hv_11 + (-0.20197023451328278)*bt_g1_12;
    hv_11 = hv_11 + (-0.12064224481582642)*bt_g1_13;
    hv_11 = hv_11 + (-0.018030401319265366)*bt_g1_14;
    hv_11 = hv_11 + (0.25598230957984924)*bt_g1_15;
    hv_11 = hv_11 + (-0.090720981359481812)*bt_g1_16;
    hv_11 = hv_11 + (-0.19198000431060791)*bt_g1_17;
    hv_11 = hv_11 + (0.14152440428733826)*bt_g1_18;
    hv_11 = hv_11 + (-0.12490740418434143)*bt_g1_19;
    hv_11 = hv_11 + (0.0088422717526555061)*bt_g1_20;
    hv_11 = hv_11 + (0.079747870564460754)*bt_g1_21;
    hv_11 = hv_11 + (-0.27401518821716309)*bt_g1_22;
    hv_11 = hv_11 + (0.039930164813995361)*bt_g1_23;
    hv_11 = hv_11 + (-0.0082628019154071808)*bt_g1_24;
    hv_11 = hv_11 + (-0.16021229326725006)*bt_g1_25;
    hv_11 = hv_11 + (-0.084678471088409424)*bt_g1_26;
    hv_11 = hv_11 + (0.020698424428701401)*bt_g1_27;
    hv_11 = hv_11 + (-0.12046223878860474)*bt_g1_28;
    hv_11 = hv_11 + (-0.022587692365050316)*bt_g1_29;
    hv_11 = hv_11 + (-0.12232928723096848)*bt_g1_30;
    hv_11 = hv_11 + (-0.024436868727207184)*bt_g1_31;
    hv_11 = hv_11 + (0.19617332518100739)*bt_g1_32;
    hv_11 = hv_11 + (0.094005100429058075)*bt_g1_33;
    hv_11 = hv_11 + (0.12225271761417389)*bt_g1_34;
    hv_11 = hv_11 + (-0.10077320039272308)*bt_g1_35;
    hv_11 = hv_11 + (0.11797976493835449)*bt_g1_36;
    hv_11 = hv_11 + (-0.19687768816947937)*bt_g1_37;
    hv_11 = hv_11 + (0.048280492424964905)*bt_g1_38;
    hv_11 = hv_11 + (-0.091574043035507202)*bt_g1_39;
    hv_11 = hv_11 + (0.15053075551986694)*bt_g1_40;
    hv_11 = hv_11 + (0.094132669270038605)*bt_g1_41;
    hv_11 = hv_11 + (-0.28370046615600586)*bt_g1_42;
    hv_11 = hv_11 + (0.25901874899864197)*bt_g1_43;
    hv_11 = hv_11 + (0.021166754886507988)*bt_g1_44;
    hv_11 = hv_11 + (0.040971901267766953)*bt_g1_45;
    hv_11 = hv_11 + (-0.080717898905277252)*bt_g1_46;
    hv_11 = hv_11 + (0.093663789331912994)*bt_g1_47;
    hv_11 = hv_11 + (0.097841359674930573)*bt_g1_48;
    hv_11 = hv_11 + (-0.067575834691524506)*bt_g1_49;
    hv_11 = hv_11 + (-0.15708304941654205)*bt_g1_50;
    hv_11 = hv_11 + (-0.050967592746019363)*bt_g1_51;
    hv_11 = hv_11 + (0.060334052890539169)*bt_g1_52;
    hv_11 = hv_11 + (0.072060249745845795)*bt_g1_53;
    hv_11 = hv_11 + (-0.13172602653503418)*bt_g1_54;
    hv_11 = hv_11 + (-0.016878709197044373)*bt_g1_55;
    hv_11 = hv_11 + (-0.0047425525262951851)*bt_g1_56;
    hv_11 = hv_11 + (0.0077810585498809814)*bt_g1_57;
    hv_11 = hv_11 + (0.39503774046897888)*bt_g1_58;
    hv_11 = hv_11 + (-0.22536192834377289)*bt_g1_59;
    hv_11 = hv_11 + (-0.061067387461662292)*bt_g1_60;
    hv_11 = hv_11 + (0.0060906214639544487)*bt_g1_61;
    hv_11 = hv_11 + (0.11276405304670334)*bt_g1_62;
    hv_11 = hv_11 + (-0.15027667582035065)*bt_g1_63;
    hv_12 = 0.14130418002605438;
    hv_12 = hv_12 + (-0.19470773637294769)*bt_g1_0;
    hv_12 = hv_12 + (-0.8819878101348877)*bt_g1_1;
    hv_12 = hv_12 + (-0.16442781686782837)*bt_g1_2;
    hv_12 = hv_12 + (0.053004872053861618)*bt_g1_3;
    hv_12 = hv_12 + (0.082666195929050446)*bt_g1_4;
    hv_12 = hv_12 + (0.17206007242202759)*bt_g1_5;
    hv_12 = hv_12 + (-0.0031876552384346724)*bt_g1_6;
    hv_12 = hv_12 + (-0.17262719571590424)*bt_g1_7;
    hv_12 = hv_12 + (0.25358262658119202)*bt_g1_8;
    hv_12 = hv_12 + (-0.16526781022548676)*bt_g1_9;
    hv_12 = hv_12 + (-0.16237951815128326)*bt_g1_10;
    hv_12 = hv_12 + (0.18122370541095734)*bt_g1_11;
    hv_12 = hv_12 + (0.08424791693687439)*bt_g1_12;
    hv_12 = hv_12 + (-0.078935876488685608)*bt_g1_13;
    hv_12 = hv_12 + (0.02767009474337101)*bt_g1_14;
    hv_12 = hv_12 + (-0.0044608744792640209)*bt_g1_15;
    hv_12 = hv_12 + (-0.16507141292095184)*bt_g1_16;
    hv_12 = hv_12 + (-0.8999631404876709)*bt_g1_17;
    hv_12 = hv_12 + (-0.18307480216026306)*bt_g1_18;
    hv_12 = hv_12 + (0.17732895910739899)*bt_g1_19;
    hv_12 = hv_12 + (-0.20134681463241577)*bt_g1_20;
    hv_12 = hv_12 + (-0.094119235873222351)*bt_g1_21;
    hv_12 = hv_12 + (-0.32697075605392456)*bt_g1_22;
    hv_12 = hv_12 + (-0.32291266322135925)*bt_g1_23;
    hv_12 = hv_12 + (-0.028182884678244591)*bt_g1_24;
    hv_12 = hv_12 + (-0.025943784043192863)*bt_g1_25;
    hv_12 = hv_12 + (-0.27538749575614929)*bt_g1_26;
    hv_12 = hv_12 + (-0.096206977963447571)*bt_g1_27;
    hv_12 = hv_12 + (0.1097806990146637)*bt_g1_28;
    hv_12 = hv_12 + (0.12275338172912598)*bt_g1_29;
    hv_12 = hv_12 + (-0.21980299055576324)*bt_g1_30;
    hv_12 = hv_12 + (-0.012233024463057518)*bt_g1_31;
    hv_12 = hv_12 + (0.34186100959777832)*bt_g1_32;
    hv_12 = hv_12 + (-0.6453402042388916)*bt_g1_33;
    hv_12 = hv_12 + (-0.10322938859462738)*bt_g1_34;
    hv_12 = hv_12 + (0.00021016076789237559)*bt_g1_35;
    hv_12 = hv_12 + (-0.067888513207435608)*bt_g1_36;
    hv_12 = hv_12 + (-0.091039285063743591)*bt_g1_37;
    hv_12 = hv_12 + (0.030840586870908737)*bt_g1_38;
    hv_12 = hv_12 + (0.15518151223659515)*bt_g1_39;
    hv_12 = hv_12 + (-0.14511929452419281)*bt_g1_40;
    hv_12 = hv_12 + (0.26897388696670532)*bt_g1_41;
    hv_12 = hv_12 + (-0.56845617294311523)*bt_g1_42;
    hv_12 = hv_12 + (-0.14634943008422852)*bt_g1_43;
    hv_12 = hv_12 + (0.096805296838283539)*bt_g1_44;
    hv_12 = hv_12 + (0.13156893849372864)*bt_g1_45;
    hv_12 = hv_12 + (-0.01986381784081459)*bt_g1_46;
    hv_12 = hv_12 + (0.21094827353954315)*bt_g1_47;
    hv_12 = hv_12 + (0.037300441414117813)*bt_g1_48;
    hv_12 = hv_12 + (-0.19820511341094971)*bt_g1_49;
    hv_12 = hv_12 + (-0.02817155048251152)*bt_g1_50;
    hv_12 = hv_12 + (0.19925065338611603)*bt_g1_51;
    hv_12 = hv_12 + (0.012987686321139336)*bt_g1_52;
    hv_12 = hv_12 + (0.086451888084411621)*bt_g1_53;
    hv_12 = hv_12 + (-0.05328672006726265)*bt_g1_54;
    hv_12 = hv_12 + (0.1767585277557373)*bt_g1_55;
    hv_12 = hv_12 + (0.050711400806903839)*bt_g1_56;
    hv_12 = hv_12 + (-0.23473197221755981)*bt_g1_57;
    hv_12 = hv_12 + (0.082309231162071228)*bt_g1_58;
    hv_12 = hv_12 + (-0.36425366997718811)*bt_g1_59;
    hv_12 = hv_12 + (-0.28631818294525146)*bt_g1_60;
    hv_12 = hv_12 + (-0.046410024166107178)*bt_g1_61;
    hv_12 = hv_12 + (0.161822110414505)*bt_g1_62;
    hv_12 = hv_12 + (-0.25397181510925293)*bt_g1_63;
    hv_13 = -0.013484565541148186;
    hv_13 = hv_13 + (0.097970522940158844)*bt_g1_0;
    hv_13 = hv_13 + (-0.057584933936595917)*bt_g1_1;
    hv_13 = hv_13 + (-0.031012048944830894)*bt_g1_2;
    hv_13 = hv_13 + (-0.029427820816636086)*bt_g1_3;
    hv_13 = hv_13 + (0.057071447372436523)*bt_g1_4;
    hv_13 = hv_13 + (0.1266656368970871)*bt_g1_5;
    hv_13 = hv_13 + (-0.056538399308919907)*bt_g1_6;
    hv_13 = hv_13 + (0.12457159161567688)*bt_g1_7;
    hv_13 = hv_13 + (-0.086409501731395721)*bt_g1_8;
    hv_13 = hv_13 + (-0.027914294973015785)*bt_g1_9;
    hv_13 = hv_13 + (0.043617282062768936)*bt_g1_10;
    hv_13 = hv_13 + (-0.071582667529582977)*bt_g1_11;
    hv_13 = hv_13 + (0.058403287082910538)*bt_g1_12;
    hv_13 = hv_13 + (0.19765236973762512)*bt_g1_13;
    hv_13 = hv_13 + (-0.051121443510055542)*bt_g1_14;
    hv_13 = hv_13 + (0.006138199009001255)*bt_g1_15;
    hv_13 = hv_13 + (-0.016615647822618484)*bt_g1_16;
    hv_13 = hv_13 + (-0.15827333927154541)*bt_g1_17;
    hv_13 = hv_13 + (0.0049333903007209301)*bt_g1_18;
    hv_13 = hv_13 + (0.68533182144165039)*bt_g1_19;
    hv_13 = hv_13 + (0.027436872944235802)*bt_g1_20;
    hv_13 = hv_13 + (-0.029910067096352577)*bt_g1_21;
    hv_13 = hv_13 + (0.0085088983178138733)*bt_g1_22;
    hv_13 = hv_13 + (0.011453793384134769)*bt_g1_23;
    hv_13 = hv_13 + (-0.025912240147590637)*bt_g1_24;
    hv_13 = hv_13 + (-0.15492163598537445)*bt_g1_25;
    hv_13 = hv_13 + (-0.071661598980426788)*bt_g1_26;
    hv_13 = hv_13 + (0.20418255031108856)*bt_g1_27;
    hv_13 = hv_13 + (0.15240956842899323)*bt_g1_28;
    hv_13 = hv_13 + (0.036363828927278519)*bt_g1_29;
    hv_13 = hv_13 + (0.019249053671956062)*bt_g1_30;
    hv_13 = hv_13 + (-0.2005574107170105)*bt_g1_31;
    hv_13 = hv_13 + (-0.22876715660095215)*bt_g1_32;
    hv_13 = hv_13 + (-0.18693476915359497)*bt_g1_33;
    hv_13 = hv_13 + (0.055515982210636139)*bt_g1_34;
    hv_13 = hv_13 + (0.14125502109527588)*bt_g1_35;
    hv_13 = hv_13 + (-0.18956734240055084)*bt_g1_36;
    hv_13 = hv_13 + (-0.096906282007694244)*bt_g1_37;
    hv_13 = hv_13 + (-0.032127801328897476)*bt_g1_38;
    hv_13 = hv_13 + (-0.15661925077438354)*bt_g1_39;
    hv_13 = hv_13 + (-0.061957128345966339)*bt_g1_40;
    hv_13 = hv_13 + (0.44396910071372986)*bt_g1_41;
    hv_13 = hv_13 + (0.091712728142738342)*bt_g1_42;
    hv_13 = hv_13 + (0.28830131888389587)*bt_g1_43;
    hv_13 = hv_13 + (0.028788797557353973)*bt_g1_44;
    hv_13 = hv_13 + (-0.17152808606624603)*bt_g1_45;
    hv_13 = hv_13 + (-0.16029895842075348)*bt_g1_46;
    hv_13 = hv_13 + (-0.134566530585289)*bt_g1_47;
    hv_13 = hv_13 + (-0.087644435465335846)*bt_g1_48;
    hv_13 = hv_13 + (0.071194954216480255)*bt_g1_49;
    hv_13 = hv_13 + (-0.12910419702529907)*bt_g1_50;
    hv_13 = hv_13 + (-0.11270768195390701)*bt_g1_51;
    hv_13 = hv_13 + (-0.065397895872592926)*bt_g1_52;
    hv_13 = hv_13 + (-0.020985674113035202)*bt_g1_53;
    hv_13 = hv_13 + (-0.00059301918372511864)*bt_g1_54;
    hv_13 = hv_13 + (-0.27760687470436096)*bt_g1_55;
    hv_13 = hv_13 + (-0.11767620593309402)*bt_g1_56;
    hv_13 = hv_13 + (-0.051991946995258331)*bt_g1_57;
    hv_13 = hv_13 + (-0.018891759216785431)*bt_g1_58;
    hv_13 = hv_13 + (-0.18930256366729736)*bt_g1_59;
    hv_13 = hv_13 + (-0.19924461841583252)*bt_g1_60;
    hv_13 = hv_13 + (-0.10374649614095688)*bt_g1_61;
    hv_13 = hv_13 + (-0.15123410522937775)*bt_g1_62;
    hv_13 = hv_13 + (-0.04544096440076828)*bt_g1_63;
    hv_14 = 0.12432952970266342;
    hv_14 = hv_14 + (0.025772156193852425)*bt_g1_0;
    hv_14 = hv_14 + (0.01999502070248127)*bt_g1_1;
    hv_14 = hv_14 + (0.06861422210931778)*bt_g1_2;
    hv_14 = hv_14 + (-0.063746929168701172)*bt_g1_3;
    hv_14 = hv_14 + (0.25942489504814148)*bt_g1_4;
    hv_14 = hv_14 + (0.24811959266662598)*bt_g1_5;
    hv_14 = hv_14 + (-0.089905694127082825)*bt_g1_6;
    hv_14 = hv_14 + (0.21893936395645142)*bt_g1_7;
    hv_14 = hv_14 + (-0.10450393706560135)*bt_g1_8;
    hv_14 = hv_14 + (0.17024382948875427)*bt_g1_9;
    hv_14 = hv_14 + (0.24451136589050293)*bt_g1_10;
    hv_14 = hv_14 + (-0.12864726781845093)*bt_g1_11;
    hv_14 = hv_14 + (0.12932698428630829)*bt_g1_12;
    hv_14 = hv_14 + (-0.053663399070501328)*bt_g1_13;
    hv_14 = hv_14 + (-0.12067749351263046)*bt_g1_14;
    hv_14 = hv_14 + (-0.16458728909492493)*bt_g1_15;
    hv_14 = hv_14 + (0.2661680281162262)*bt_g1_16;
    hv_14 = hv_14 + (0.095493681728839874)*bt_g1_17;
    hv_14 = hv_14 + (-0.021211696788668633)*bt_g1_18;
    hv_14 = hv_14 + (0.23070609569549561)*bt_g1_19;
    hv_14 = hv_14 + (0.032068699598312378)*bt_g1_20;
    hv_14 = hv_14 + (-0.14247401058673859)*bt_g1_21;
    hv_14 = hv_14 + (0.29628729820251465)*bt_g1_22;
    hv_14 = hv_14 + (-0.015263739041984081)*bt_g1_23;
    hv_14 = hv_14 + (0.015950668603181839)*bt_g1_24;
    hv_14 = hv_14 + (-0.013700662180781364)*bt_g1_25;
    hv_14 = hv_14 + (0.16461153328418732)*bt_g1_26;
    hv_14 = hv_14 + (0.12968476116657257)*bt_g1_27;
    hv_14 = hv_14 + (0.076010935008525848)*bt_g1_28;
    hv_14 = hv_14 + (-0.14552119374275208)*bt_g1_29;
    hv_14 = hv_14 + (0.46883594989776611)*bt_g1_30;
    hv_14 = hv_14 + (0.13324408233165741)*bt_g1_31;
    hv_14 = hv_14 + (-0.11425751447677612)*bt_g1_32;
    hv_14 = hv_14 + (0.59120273590087891)*bt_g1_33;
    hv_14 = hv_14 + (0.10135809332132339)*bt_g1_34;
    hv_14 = hv_14 + (0.052105683833360672)*bt_g1_35;
    hv_14 = hv_14 + (0.23920692503452301)*bt_g1_36;
    hv_14 = hv_14 + (0.17290158569812775)*bt_g1_37;
    hv_14 = hv_14 + (-0.08459511399269104)*bt_g1_38;
    hv_14 = hv_14 + (0.011693187989294529)*bt_g1_39;
    hv_14 = hv_14 + (0.078486315906047821)*bt_g1_40;
    hv_14 = hv_14 + (-0.33720165491104126)*bt_g1_41;
    hv_14 = hv_14 + (-0.29327848553657532)*bt_g1_42;
    hv_14 = hv_14 + (-0.14475953578948975)*bt_g1_43;
    hv_14 = hv_14 + (-0.13543879985809326)*bt_g1_44;
    hv_14 = hv_14 + (0.01527521014213562)*bt_g1_45;
    hv_14 = hv_14 + (0.11196855455636978)*bt_g1_46;
    hv_14 = hv_14 + (-0.16503261029720306)*bt_g1_47;
    hv_14 = hv_14 + (0.075607888400554657)*bt_g1_48;
    hv_14 = hv_14 + (0.002255110302940011)*bt_g1_49;
    hv_14 = hv_14 + (0.20622642338275909)*bt_g1_50;
    hv_14 = hv_14 + (-0.059779968112707138)*bt_g1_51;
    hv_14 = hv_14 + (-0.083779916167259216)*bt_g1_52;
    hv_14 = hv_14 + (0.090634062886238098)*bt_g1_53;
    hv_14 = hv_14 + (0.12457282096147537)*bt_g1_54;
    hv_14 = hv_14 + (-0.10136368870735168)*bt_g1_55;
    hv_14 = hv_14 + (0.095965556800365448)*bt_g1_56;
    hv_14 = hv_14 + (0.046305019408464432)*bt_g1_57;
    hv_14 = hv_14 + (0.36657226085662842)*bt_g1_58;
    hv_14 = hv_14 + (0.3098013699054718)*bt_g1_59;
    hv_14 = hv_14 + (0.066788293421268463)*bt_g1_60;
    hv_14 = hv_14 + (0.020384302362799644)*bt_g1_61;
    hv_14 = hv_14 + (-0.087979063391685486)*bt_g1_62;
    hv_14 = hv_14 + (0.096626490354537964)*bt_g1_63;
    hv_15 = -0.090778954327106476;
    hv_15 = hv_15 + (0.095973066985607147)*bt_g1_0;
    hv_15 = hv_15 + (0.079686000943183899)*bt_g1_1;
    hv_15 = hv_15 + (0.019796779379248619)*bt_g1_2;
    hv_15 = hv_15 + (0.079562216997146606)*bt_g1_3;
    hv_15 = hv_15 + (-0.13808606564998627)*bt_g1_4;
    hv_15 = hv_15 + (-0.16262099146842957)*bt_g1_5;
    hv_15 = hv_15 + (0.13015227019786835)*bt_g1_6;
    hv_15 = hv_15 + (0.07156246155500412)*bt_g1_7;
    hv_15 = hv_15 + (0.1082928404211998)*bt_g1_8;
    hv_15 = hv_15 + (0.012201020494103432)*bt_g1_9;
    hv_15 = hv_15 + (-0.03489239513874054)*bt_g1_10;
    hv_15 = hv_15 + (-0.010838686488568783)*bt_g1_11;
    hv_15 = hv_15 + (0.11511177569627762)*bt_g1_12;
    hv_15 = hv_15 + (-0.2640322744846344)*bt_g1_13;
    hv_15 = hv_15 + (0.092106178402900696)*bt_g1_14;
    hv_15 = hv_15 + (0.09010026603937149)*bt_g1_15;
    hv_15 = hv_15 + (-0.34140700101852417)*bt_g1_16;
    hv_15 = hv_15 + (0.039822295308113098)*bt_g1_17;
    hv_15 = hv_15 + (-0.031381834298372269)*bt_g1_18;
    hv_15 = hv_15 + (-1.1887668371200562)*bt_g1_19;
    hv_15 = hv_15 + (-0.087001189589500427)*bt_g1_20;
    hv_15 = hv_15 + (0.077915892004966736)*bt_g1_21;
    hv_15 = hv_15 + (-0.13067188858985901)*bt_g1_22;
    hv_15 = hv_15 + (-0.010557333938777447)*bt_g1_23;
    hv_15 = hv_15 + (0.076781809329986572)*bt_g1_24;
    hv_15 = hv_15 + (0.14662562310695648)*bt_g1_25;
    hv_15 = hv_15 + (0.037266161292791367)*bt_g1_26;
    hv_15 = hv_15 + (-0.074330642819404602)*bt_g1_27;
    hv_15 = hv_15 + (0.13985344767570496)*bt_g1_28;
    hv_15 = hv_15 + (0.035545315593481064)*bt_g1_29;
    hv_15 = hv_15 + (0.0029316793661564589)*bt_g1_30;
    hv_15 = hv_15 + (0.052956268191337585)*bt_g1_31;
    hv_15 = hv_15 + (0.13268892467021942)*bt_g1_32;
    hv_15 = hv_15 + (0.1058373749256134)*bt_g1_33;
    hv_15 = hv_15 + (0.16641859710216522)*bt_g1_34;
    hv_15 = hv_15 + (0.028406128287315369)*bt_g1_35;
    hv_15 = hv_15 + (0.155536949634552)*bt_g1_36;
    hv_15 = hv_15 + (0.053985070437192917)*bt_g1_37;
    hv_15 = hv_15 + (0.10600026696920395)*bt_g1_38;
    hv_15 = hv_15 + (-0.034444484859704971)*bt_g1_39;
    hv_15 = hv_15 + (-0.029600078240036964)*bt_g1_40;
    hv_15 = hv_15 + (-0.61324846744537354)*bt_g1_41;
    hv_15 = hv_15 + (-0.23073574900627136)*bt_g1_42;
    hv_15 = hv_15 + (0.044669780880212784)*bt_g1_43;
    hv_15 = hv_15 + (0.16355191171169281)*bt_g1_44;
    hv_15 = hv_15 + (0.11320393532514572)*bt_g1_45;
    hv_15 = hv_15 + (0.11286060512065887)*bt_g1_46;
    hv_15 = hv_15 + (-0.01849941723048687)*bt_g1_47;
    hv_15 = hv_15 + (-0.0076771830208599567)*bt_g1_48;
    hv_15 = hv_15 + (-0.24785083532333374)*bt_g1_49;
    hv_15 = hv_15 + (0.021599747240543365)*bt_g1_50;
    hv_15 = hv_15 + (-0.10426922142505646)*bt_g1_51;
    hv_15 = hv_15 + (0.076013565063476562)*bt_g1_52;
    hv_15 = hv_15 + (-0.075938232243061066)*bt_g1_53;
    hv_15 = hv_15 + (-0.04864179715514183)*bt_g1_54;
    hv_15 = hv_15 + (0.017505025491118431)*bt_g1_55;
    hv_15 = hv_15 + (-0.076072618365287781)*bt_g1_56;
    hv_15 = hv_15 + (0.011741886846721172)*bt_g1_57;
    hv_15 = hv_15 + (-0.043071165680885315)*bt_g1_58;
    hv_15 = hv_15 + (0.021639266982674599)*bt_g1_59;
    hv_15 = hv_15 + (-0.21301570534706116)*bt_g1_60;
    hv_15 = hv_15 + (0.0045700729824602604)*bt_g1_61;
    hv_15 = hv_15 + (0.08129795640707016)*bt_g1_62;
    hv_15 = hv_15 + (-0.0447571761906147)*bt_g1_63;
    // FiLM fusion + output head
    film_0 = -0.36651703715324402;
    film_0 = film_0 + (0.14173345267772675)*hpn_0;
    film_0 = film_0 + (0.17993190884590149)*hpn_1;
    film_0 = film_0 + (-0.16219034790992737)*hpn_2;
    film_0 = film_0 + (0.14729177951812744)*hpn_3;
    film_0 = film_0 + (-0.13924321532249451)*hpn_4;
    film_0 = film_0 + (0.0025432147085666656)*hpn_5;
    film_0 = film_0 + (-0.00074070988921448588)*hpn_6;
    film_0 = film_0 + (0.080696560442447662)*hpn_7;
    film_0 = film_0 + (0.13187021017074585)*hpn_8;
    film_0 = film_0 + (-0.13827699422836304)*hpn_9;
    film_0 = film_0 + (-0.17029000818729401)*hpn_10;
    film_0 = film_0 + (0.17720383405685425)*hpn_11;
    film_0 = film_0 + (0.15338966250419617)*hpn_12;
    film_0 = film_0 + (-0.16963231563568115)*hpn_13;
    film_0 = film_0 + (0.026042433455586433)*hpn_14;
    film_0 = film_0 + (-0.037322748452425003)*hpn_15;
    film_1 = 0.32570883631706238;
    film_1 = film_1 + (-0.33328542113304138)*hpn_0;
    film_1 = film_1 + (-0.2794850766658783)*hpn_1;
    film_1 = film_1 + (0.31533193588256836)*hpn_2;
    film_1 = film_1 + (-0.43337082862854004)*hpn_3;
    film_1 = film_1 + (0.12543611228466034)*hpn_4;
    film_1 = film_1 + (0.1007683277130127)*hpn_5;
    film_1 = film_1 + (-0.11304037272930145)*hpn_6;
    film_1 = film_1 + (0.058507464826107025)*hpn_7;
    film_1 = film_1 + (-0.022917835041880608)*hpn_8;
    film_1 = film_1 + (-0.08907867968082428)*hpn_9;
    film_1 = film_1 + (-0.024211524054408073)*hpn_10;
    film_1 = film_1 + (0.2277241051197052)*hpn_11;
    film_1 = film_1 + (0.014161280356347561)*hpn_12;
    film_1 = film_1 + (-0.12544895708560944)*hpn_13;
    film_1 = film_1 + (-0.10937170684337616)*hpn_14;
    film_1 = film_1 + (-0.07959844172000885)*hpn_15;
    film_2 = 0.038700379431247711;
    film_2 = film_2 + (-0.30577680468559265)*hpn_0;
    film_2 = film_2 + (0.076067641377449036)*hpn_1;
    film_2 = film_2 + (0.43142706155776978)*hpn_2;
    film_2 = film_2 + (-0.5447574257850647)*hpn_3;
    film_2 = film_2 + (0.14928692579269409)*hpn_4;
    film_2 = film_2 + (0.080560065805912018)*hpn_5;
    film_2 = film_2 + (-0.090036347508430481)*hpn_6;
    film_2 = film_2 + (-0.14468051493167877)*hpn_7;
    film_2 = film_2 + (-0.1095498725771904)*hpn_8;
    film_2 = film_2 + (-0.031938403844833374)*hpn_9;
    film_2 = film_2 + (0.2872413694858551)*hpn_10;
    film_2 = film_2 + (0.20081764459609985)*hpn_11;
    film_2 = film_2 + (0.24391573667526245)*hpn_12;
    film_2 = film_2 + (-0.082221522927284241)*hpn_13;
    film_2 = film_2 + (0.37125790119171143)*hpn_14;
    film_2 = film_2 + (-0.039921477437019348)*hpn_15;
    film_3 = 0.11247587949037552;
    film_3 = film_3 + (0.084943592548370361)*hpn_0;
    film_3 = film_3 + (-0.18502822518348694)*hpn_1;
    film_3 = film_3 + (0.087448827922344208)*hpn_2;
    film_3 = film_3 + (-0.15810862183570862)*hpn_3;
    film_3 = film_3 + (0.24717779457569122)*hpn_4;
    film_3 = film_3 + (0.045523479580879211)*hpn_5;
    film_3 = film_3 + (-0.0026152986101806164)*hpn_6;
    film_3 = film_3 + (0.039156496524810791)*hpn_7;
    film_3 = film_3 + (0.2061534970998764)*hpn_8;
    film_3 = film_3 + (0.1902790367603302)*hpn_9;
    film_3 = film_3 + (0.022579913958907127)*hpn_10;
    film_3 = film_3 + (-0.015950102359056473)*hpn_11;
    film_3 = film_3 + (-0.15358193218708038)*hpn_12;
    film_3 = film_3 + (-0.01257715467363596)*hpn_13;
    film_3 = film_3 + (0.23649550974369049)*hpn_14;
    film_3 = film_3 + (0.040113255381584167)*hpn_15;
    film_4 = -0.19670668244361877;
    film_4 = film_4 + (-0.25086095929145813)*hpn_0;
    film_4 = film_4 + (0.013249027542769909)*hpn_1;
    film_4 = film_4 + (0.011390817351639271)*hpn_2;
    film_4 = film_4 + (-0.10938860476016998)*hpn_3;
    film_4 = film_4 + (-0.069406405091285706)*hpn_4;
    film_4 = film_4 + (-0.17795151472091675)*hpn_5;
    film_4 = film_4 + (0.074577212333679199)*hpn_6;
    film_4 = film_4 + (0.0091858748346567154)*hpn_7;
    film_4 = film_4 + (0.23768952488899231)*hpn_8;
    film_4 = film_4 + (-0.14262214303016663)*hpn_9;
    film_4 = film_4 + (-0.10149878263473511)*hpn_10;
    film_4 = film_4 + (0.33800363540649414)*hpn_11;
    film_4 = film_4 + (0.22492697834968567)*hpn_12;
    film_4 = film_4 + (0.12250025570392609)*hpn_13;
    film_4 = film_4 + (-0.073375917971134186)*hpn_14;
    film_4 = film_4 + (-0.097901523113250732)*hpn_15;
    film_5 = 0.079025216400623322;
    film_5 = film_5 + (-0.17453058063983917)*hpn_0;
    film_5 = film_5 + (0.2230229377746582)*hpn_1;
    film_5 = film_5 + (0.092356406152248383)*hpn_2;
    film_5 = film_5 + (0.082942001521587372)*hpn_3;
    film_5 = film_5 + (-0.11687600612640381)*hpn_4;
    film_5 = film_5 + (-0.043044634163379669)*hpn_5;
    film_5 = film_5 + (-0.10419552028179169)*hpn_6;
    film_5 = film_5 + (-0.23065909743309021)*hpn_7;
    film_5 = film_5 + (-0.083092980086803436)*hpn_8;
    film_5 = film_5 + (-0.26394018530845642)*hpn_9;
    film_5 = film_5 + (-0.14981372654438019)*hpn_10;
    film_5 = film_5 + (0.34118479490280151)*hpn_11;
    film_5 = film_5 + (0.14772628247737885)*hpn_12;
    film_5 = film_5 + (0.018268486484885216)*hpn_13;
    film_5 = film_5 + (-0.30922126770019531)*hpn_14;
    film_5 = film_5 + (-0.24745805561542511)*hpn_15;
    film_6 = -0.29366579651832581;
    film_6 = film_6 + (-0.18911132216453552)*hpn_0;
    film_6 = film_6 + (-0.014916694723069668)*hpn_1;
    film_6 = film_6 + (-0.017247708514332771)*hpn_2;
    film_6 = film_6 + (-0.13644334673881531)*hpn_3;
    film_6 = film_6 + (-0.19862736761569977)*hpn_4;
    film_6 = film_6 + (0.1247616708278656)*hpn_5;
    film_6 = film_6 + (-0.14830516278743744)*hpn_6;
    film_6 = film_6 + (-0.077060326933860779)*hpn_7;
    film_6 = film_6 + (-0.045121718198060989)*hpn_8;
    film_6 = film_6 + (-0.15294592082500458)*hpn_9;
    film_6 = film_6 + (0.25408142805099487)*hpn_10;
    film_6 = film_6 + (0.10479876399040222)*hpn_11;
    film_6 = film_6 + (-0.17096723616123199)*hpn_12;
    film_6 = film_6 + (-0.094498910009860992)*hpn_13;
    film_6 = film_6 + (0.11206458508968353)*hpn_14;
    film_6 = film_6 + (0.099387653172016144)*hpn_15;
    film_7 = 0.03786342591047287;
    film_7 = film_7 + (0.13168957829475403)*hpn_0;
    film_7 = film_7 + (0.0027197652962058783)*hpn_1;
    film_7 = film_7 + (-0.23452532291412354)*hpn_2;
    film_7 = film_7 + (0.076279677450656891)*hpn_3;
    film_7 = film_7 + (0.13553923368453979)*hpn_4;
    film_7 = film_7 + (0.028763974085450172)*hpn_5;
    film_7 = film_7 + (-0.23496867716312408)*hpn_6;
    film_7 = film_7 + (-0.24394941329956055)*hpn_7;
    film_7 = film_7 + (0.18941442668437958)*hpn_8;
    film_7 = film_7 + (0.071183249354362488)*hpn_9;
    film_7 = film_7 + (0.10250938683748245)*hpn_10;
    film_7 = film_7 + (-0.070042558014392853)*hpn_11;
    film_7 = film_7 + (-0.034641493111848831)*hpn_12;
    film_7 = film_7 + (-0.01351785846054554)*hpn_13;
    film_7 = film_7 + (0.16640190780162811)*hpn_14;
    film_7 = film_7 + (-0.028534725308418274)*hpn_15;
    film_8 = 0.20597684383392334;
    film_8 = film_8 + (-0.019430818036198616)*hpn_0;
    film_8 = film_8 + (0.17343860864639282)*hpn_1;
    film_8 = film_8 + (0.010155007243156433)*hpn_2;
    film_8 = film_8 + (-0.22669757902622223)*hpn_3;
    film_8 = film_8 + (0.17450883984565735)*hpn_4;
    film_8 = film_8 + (-0.30334126949310303)*hpn_5;
    film_8 = film_8 + (-0.12716855108737946)*hpn_6;
    film_8 = film_8 + (0.3037794828414917)*hpn_7;
    film_8 = film_8 + (-0.13247017562389374)*hpn_8;
    film_8 = film_8 + (-0.089055441319942474)*hpn_9;
    film_8 = film_8 + (0.02656901627779007)*hpn_10;
    film_8 = film_8 + (-0.34396582841873169)*hpn_11;
    film_8 = film_8 + (-0.187967449426651)*hpn_12;
    film_8 = film_8 + (-0.082887746393680573)*hpn_13;
    film_8 = film_8 + (0.090132430195808411)*hpn_14;
    film_8 = film_8 + (0.035078857094049454)*hpn_15;
    film_9 = 0.17448753118515015;
    film_9 = film_9 + (-0.12617433071136475)*hpn_0;
    film_9 = film_9 + (0.36473751068115234)*hpn_1;
    film_9 = film_9 + (0.245953768491745)*hpn_2;
    film_9 = film_9 + (0.05922418087720871)*hpn_3;
    film_9 = film_9 + (0.022184981033205986)*hpn_4;
    film_9 = film_9 + (0.013310958631336689)*hpn_5;
    film_9 = film_9 + (-0.13796453177928925)*hpn_6;
    film_9 = film_9 + (-0.19299331307411194)*hpn_7;
    film_9 = film_9 + (-0.31937727332115173)*hpn_8;
    film_9 = film_9 + (0.0082027800381183624)*hpn_9;
    film_9 = film_9 + (-0.29858550429344177)*hpn_10;
    film_9 = film_9 + (0.046636354178190231)*hpn_11;
    film_9 = film_9 + (0.21365156769752502)*hpn_12;
    film_9 = film_9 + (0.15666539967060089)*hpn_13;
    film_9 = film_9 + (-0.076136529445648193)*hpn_14;
    film_9 = film_9 + (-0.0022163931280374527)*hpn_15;
    film_10 = 0.31275314092636108;
    film_10 = film_10 + (0.25880753993988037)*hpn_0;
    film_10 = film_10 + (0.16363824903964996)*hpn_1;
    film_10 = film_10 + (-0.010036594234406948)*hpn_2;
    film_10 = film_10 + (-0.33127346634864807)*hpn_3;
    film_10 = film_10 + (0.1632852703332901)*hpn_4;
    film_10 = film_10 + (0.073197603225708008)*hpn_5;
    film_10 = film_10 + (0.0065027824603021145)*hpn_6;
    film_10 = film_10 + (0.16144892573356628)*hpn_7;
    film_10 = film_10 + (-0.1182146817445755)*hpn_8;
    film_10 = film_10 + (0.23042668402194977)*hpn_9;
    film_10 = film_10 + (0.10775894671678543)*hpn_10;
    film_10 = film_10 + (-0.068396389484405518)*hpn_11;
    film_10 = film_10 + (-0.040803339332342148)*hpn_12;
    film_10 = film_10 + (-0.10737166553735733)*hpn_13;
    film_10 = film_10 + (0.25838464498519897)*hpn_14;
    film_10 = film_10 + (0.026488400995731354)*hpn_15;
    film_11 = 0.063510216772556305;
    film_11 = film_11 + (0.13206407427787781)*hpn_0;
    film_11 = film_11 + (-0.35097932815551758)*hpn_1;
    film_11 = film_11 + (0.017713930457830429)*hpn_2;
    film_11 = film_11 + (-0.34625682234764099)*hpn_3;
    film_11 = film_11 + (-0.045876931399106979)*hpn_4;
    film_11 = film_11 + (-0.095460474491119385)*hpn_5;
    film_11 = film_11 + (0.032857254147529602)*hpn_6;
    film_11 = film_11 + (0.10691136121749878)*hpn_7;
    film_11 = film_11 + (0.014292524196207523)*hpn_8;
    film_11 = film_11 + (0.038567345589399338)*hpn_9;
    film_11 = film_11 + (0.23507165908813477)*hpn_10;
    film_11 = film_11 + (0.098961867392063141)*hpn_11;
    film_11 = film_11 + (0.0078946417197585106)*hpn_12;
    film_11 = film_11 + (0.064968980848789215)*hpn_13;
    film_11 = film_11 + (-0.29288828372955322)*hpn_14;
    film_11 = film_11 + (-0.11158952862024307)*hpn_15;
    film_12 = -0.27912282943725586;
    film_12 = film_12 + (-0.24984726309776306)*hpn_0;
    film_12 = film_12 + (-0.12053494900465012)*hpn_1;
    film_12 = film_12 + (0.083474904298782349)*hpn_2;
    film_12 = film_12 + (-0.41665256023406982)*hpn_3;
    film_12 = film_12 + (-0.32940316200256348)*hpn_4;
    film_12 = film_12 + (0.019188538193702698)*hpn_5;
    film_12 = film_12 + (-0.018824389204382896)*hpn_6;
    film_12 = film_12 + (0.0088823782280087471)*hpn_7;
    film_12 = film_12 + (-0.14162221550941467)*hpn_8;
    film_12 = film_12 + (-0.26483613252639771)*hpn_9;
    film_12 = film_12 + (0.55260986089706421)*hpn_10;
    film_12 = film_12 + (0.047562673687934875)*hpn_11;
    film_12 = film_12 + (-0.033066604286432266)*hpn_12;
    film_12 = film_12 + (-0.17374084889888763)*hpn_13;
    film_12 = film_12 + (-0.056632637977600098)*hpn_14;
    film_12 = film_12 + (0.26917567849159241)*hpn_15;
    film_13 = 0.076268956065177917;
    film_13 = film_13 + (0.27905845642089844)*hpn_0;
    film_13 = film_13 + (-0.27494814991950989)*hpn_1;
    film_13 = film_13 + (-0.13923212885856628)*hpn_2;
    film_13 = film_13 + (-0.25652238726615906)*hpn_3;
    film_13 = film_13 + (0.34597256779670715)*hpn_4;
    film_13 = film_13 + (0.070969328284263611)*hpn_5;
    film_13 = film_13 + (0.047326643019914627)*hpn_6;
    film_13 = film_13 + (0.25362375378608704)*hpn_7;
    film_13 = film_13 + (0.054599311202764511)*hpn_8;
    film_13 = film_13 + (0.29996466636657715)*hpn_9;
    film_13 = film_13 + (0.22572565078735352)*hpn_10;
    film_13 = film_13 + (-0.38942191004753113)*hpn_11;
    film_13 = film_13 + (0.10320015251636505)*hpn_12;
    film_13 = film_13 + (-0.01487436331808567)*hpn_13;
    film_13 = film_13 + (0.33022955060005188)*hpn_14;
    film_13 = film_13 + (0.23757283389568329)*hpn_15;
    film_14 = -0.067015402019023895;
    film_14 = film_14 + (-0.10446717590093613)*hpn_0;
    film_14 = film_14 + (-0.036318611353635788)*hpn_1;
    film_14 = film_14 + (0.38098862767219543)*hpn_2;
    film_14 = film_14 + (-0.42756432294845581)*hpn_3;
    film_14 = film_14 + (0.1602952778339386)*hpn_4;
    film_14 = film_14 + (0.13157221674919128)*hpn_5;
    film_14 = film_14 + (-0.04218306764960289)*hpn_6;
    film_14 = film_14 + (0.022493321448564529)*hpn_7;
    film_14 = film_14 + (-0.26368767023086548)*hpn_8;
    film_14 = film_14 + (-0.015893904492259026)*hpn_9;
    film_14 = film_14 + (-0.24550072848796844)*hpn_10;
    film_14 = film_14 + (-0.14254641532897949)*hpn_11;
    film_14 = film_14 + (0.036751680076122284)*hpn_12;
    film_14 = film_14 + (0.11685130745172501)*hpn_13;
    film_14 = film_14 + (-0.029595689848065376)*hpn_14;
    film_14 = film_14 + (-0.20399993658065796)*hpn_15;
    film_15 = -0.052531447261571884;
    film_15 = film_15 + (0.13360561430454254)*hpn_0;
    film_15 = film_15 + (-0.16218966245651245)*hpn_1;
    film_15 = film_15 + (-0.094078168272972107)*hpn_2;
    film_15 = film_15 + (0.14092439413070679)*hpn_3;
    film_15 = film_15 + (-0.075388841331005096)*hpn_4;
    film_15 = film_15 + (-0.1796095073223114)*hpn_5;
    film_15 = film_15 + (-0.021727954968810081)*hpn_6;
    film_15 = film_15 + (-0.069941133260726929)*hpn_7;
    film_15 = film_15 + (0.045578029006719589)*hpn_8;
    film_15 = film_15 + (0.063666649162769318)*hpn_9;
    film_15 = film_15 + (0.023077139630913734)*hpn_10;
    film_15 = film_15 + (-0.20663845539093018)*hpn_11;
    film_15 = film_15 + (-0.14582172036170959)*hpn_12;
    film_15 = film_15 + (-0.26472941040992737)*hpn_13;
    film_15 = film_15 + (-0.12684950232505798)*hpn_14;
    film_15 = film_15 + (0.043690036982297897)*hpn_15;
    film_16 = -0.14533652365207672;
    film_16 = film_16 + (0.19754870235919952)*hpn_0;
    film_16 = film_16 + (0.11136313527822495)*hpn_1;
    film_16 = film_16 + (0.34431281685829163)*hpn_2;
    film_16 = film_16 + (-0.44401425123214722)*hpn_3;
    film_16 = film_16 + (0.14322340488433838)*hpn_4;
    film_16 = film_16 + (-0.11121819913387299)*hpn_5;
    film_16 = film_16 + (0.013389469124376774)*hpn_6;
    film_16 = film_16 + (0.23767578601837158)*hpn_7;
    film_16 = film_16 + (-0.27242764830589294)*hpn_8;
    film_16 = film_16 + (-0.12262338399887085)*hpn_9;
    film_16 = film_16 + (0.17059952020645142)*hpn_10;
    film_16 = film_16 + (-0.25461283326148987)*hpn_11;
    film_16 = film_16 + (0.17193008959293365)*hpn_12;
    film_16 = film_16 + (-0.079396449029445648)*hpn_13;
    film_16 = film_16 + (0.23071441054344177)*hpn_14;
    film_16 = film_16 + (-0.20716877281665802)*hpn_15;
    film_17 = -0.058143332600593567;
    film_17 = film_17 + (0.4002220630645752)*hpn_0;
    film_17 = film_17 + (0.020316138863563538)*hpn_1;
    film_17 = film_17 + (-0.249660924077034)*hpn_2;
    film_17 = film_17 + (-0.31482180953025818)*hpn_3;
    film_17 = film_17 + (0.19786810874938965)*hpn_4;
    film_17 = film_17 + (-0.23113664984703064)*hpn_5;
    film_17 = film_17 + (-0.062302935868501663)*hpn_6;
    film_17 = film_17 + (-0.44530212879180908)*hpn_7;
    film_17 = film_17 + (-0.25654929876327515)*hpn_8;
    film_17 = film_17 + (-0.18177562952041626)*hpn_9;
    film_17 = film_17 + (-0.20344352722167969)*hpn_10;
    film_17 = film_17 + (0.32226553559303284)*hpn_11;
    film_17 = film_17 + (-0.16888546943664551)*hpn_12;
    film_17 = film_17 + (0.12771235406398773)*hpn_13;
    film_17 = film_17 + (0.44612160325050354)*hpn_14;
    film_17 = film_17 + (0.0037662286777049303)*hpn_15;
    film_18 = -0.2286093533039093;
    film_18 = film_18 + (0.14882686734199524)*hpn_0;
    film_18 = film_18 + (-0.076938651502132416)*hpn_1;
    film_18 = film_18 + (0.014953076839447021)*hpn_2;
    film_18 = film_18 + (0.28894361853599548)*hpn_3;
    film_18 = film_18 + (-0.058584503829479218)*hpn_4;
    film_18 = film_18 + (0.14185237884521484)*hpn_5;
    film_18 = film_18 + (0.31004685163497925)*hpn_6;
    film_18 = film_18 + (0.024070629850029945)*hpn_7;
    film_18 = film_18 + (-0.089226707816123962)*hpn_8;
    film_18 = film_18 + (0.066836930811405182)*hpn_9;
    film_18 = film_18 + (-0.30374038219451904)*hpn_10;
    film_18 = film_18 + (-0.027160283178091049)*hpn_11;
    film_18 = film_18 + (-0.10635994374752045)*hpn_12;
    film_18 = film_18 + (-0.073321737349033356)*hpn_13;
    film_18 = film_18 + (-0.13546349108219147)*hpn_14;
    film_18 = film_18 + (-0.090826034545898438)*hpn_15;
    film_19 = -0.26431113481521606;
    film_19 = film_19 + (-0.19320304691791534)*hpn_0;
    film_19 = film_19 + (-0.27207055687904358)*hpn_1;
    film_19 = film_19 + (0.079755701124668121)*hpn_2;
    film_19 = film_19 + (0.29476144909858704)*hpn_3;
    film_19 = film_19 + (0.149479940533638)*hpn_4;
    film_19 = film_19 + (-0.18495525419712067)*hpn_5;
    film_19 = film_19 + (0.1487434059381485)*hpn_6;
    film_19 = film_19 + (0.13137723505496979)*hpn_7;
    film_19 = film_19 + (0.20840415358543396)*hpn_8;
    film_19 = film_19 + (0.051854491233825684)*hpn_9;
    film_19 = film_19 + (0.32092192769050598)*hpn_10;
    film_19 = film_19 + (0.1614229828119278)*hpn_11;
    film_19 = film_19 + (-0.063852876424789429)*hpn_12;
    film_19 = film_19 + (-0.22078599035739899)*hpn_13;
    film_19 = film_19 + (-0.10871546715497971)*hpn_14;
    film_19 = film_19 + (-0.22185465693473816)*hpn_15;
    film_20 = -0.19029527902603149;
    film_20 = film_20 + (-0.30452913045883179)*hpn_0;
    film_20 = film_20 + (0.027798725292086601)*hpn_1;
    film_20 = film_20 + (-0.10087761282920837)*hpn_2;
    film_20 = film_20 + (0.014122301712632179)*hpn_3;
    film_20 = film_20 + (-0.20826660096645355)*hpn_4;
    film_20 = film_20 + (0.38542896509170532)*hpn_5;
    film_20 = film_20 + (-0.038924403488636017)*hpn_6;
    film_20 = film_20 + (-0.12840889394283295)*hpn_7;
    film_20 = film_20 + (-0.0028321524150669575)*hpn_8;
    film_20 = film_20 + (-0.054792113602161407)*hpn_9;
    film_20 = film_20 + (0.24800547957420349)*hpn_10;
    film_20 = film_20 + (-0.23913228511810303)*hpn_11;
    film_20 = film_20 + (0.25672200322151184)*hpn_12;
    film_20 = film_20 + (-0.036407697945833206)*hpn_13;
    film_20 = film_20 + (-0.080147773027420044)*hpn_14;
    film_20 = film_20 + (0.13889202475547791)*hpn_15;
    film_21 = -0.16279484331607819;
    film_21 = film_21 + (0.28869295120239258)*hpn_0;
    film_21 = film_21 + (-0.20960670709609985)*hpn_1;
    film_21 = film_21 + (-0.042560894042253494)*hpn_2;
    film_21 = film_21 + (-0.0033680051565170288)*hpn_3;
    film_21 = film_21 + (-0.067772381007671356)*hpn_4;
    film_21 = film_21 + (0.32749626040458679)*hpn_5;
    film_21 = film_21 + (-0.35142782330513)*hpn_6;
    film_21 = film_21 + (-0.16209007799625397)*hpn_7;
    film_21 = film_21 + (0.17724670469760895)*hpn_8;
    film_21 = film_21 + (-0.12327729910612106)*hpn_9;
    film_21 = film_21 + (0.24770113825798035)*hpn_10;
    film_21 = film_21 + (-0.27481740713119507)*hpn_11;
    film_21 = film_21 + (0.013728003017604351)*hpn_12;
    film_21 = film_21 + (-0.084595613181591034)*hpn_13;
    film_21 = film_21 + (0.11297359317541122)*hpn_14;
    film_21 = film_21 + (0.032894227653741837)*hpn_15;
    film_22 = -0.24204349517822266;
    film_22 = film_22 + (0.10718466341495514)*hpn_0;
    film_22 = film_22 + (0.050806470215320587)*hpn_1;
    film_22 = film_22 + (-0.15143406391143799)*hpn_2;
    film_22 = film_22 + (0.15325704216957092)*hpn_3;
    film_22 = film_22 + (0.13230335712432861)*hpn_4;
    film_22 = film_22 + (-0.037509649991989136)*hpn_5;
    film_22 = film_22 + (-0.098979279398918152)*hpn_6;
    film_22 = film_22 + (-0.19574753940105438)*hpn_7;
    film_22 = film_22 + (0.12049812078475952)*hpn_8;
    film_22 = film_22 + (0.22869028151035309)*hpn_9;
    film_22 = film_22 + (0.27338099479675293)*hpn_10;
    film_22 = film_22 + (0.13011902570724487)*hpn_11;
    film_22 = film_22 + (-0.22038187086582184)*hpn_12;
    film_22 = film_22 + (-0.27320316433906555)*hpn_13;
    film_22 = film_22 + (0.087019197642803192)*hpn_14;
    film_22 = film_22 + (-0.019972801208496094)*hpn_15;
    film_23 = 0.043329082429409027;
    film_23 = film_23 + (-0.2766951322555542)*hpn_0;
    film_23 = film_23 + (0.082160279154777527)*hpn_1;
    film_23 = film_23 + (0.37370476126670837)*hpn_2;
    film_23 = film_23 + (0.40117490291595459)*hpn_3;
    film_23 = film_23 + (-0.21216247975826263)*hpn_4;
    film_23 = film_23 + (-0.32392042875289917)*hpn_5;
    film_23 = film_23 + (-0.048668351024389267)*hpn_6;
    film_23 = film_23 + (0.13319313526153564)*hpn_7;
    film_23 = film_23 + (0.15369148552417755)*hpn_8;
    film_23 = film_23 + (-0.039504982531070709)*hpn_9;
    film_23 = film_23 + (-0.32271969318389893)*hpn_10;
    film_23 = film_23 + (-0.30493271350860596)*hpn_11;
    film_23 = film_23 + (0.12852145731449127)*hpn_12;
    film_23 = film_23 + (-0.14489346742630005)*hpn_13;
    film_23 = film_23 + (0.096985496580600739)*hpn_14;
    film_23 = film_23 + (-0.13321080803871155)*hpn_15;
    film_24 = -0.005112434271723032;
    film_24 = film_24 + (0.045572631061077118)*hpn_0;
    film_24 = film_24 + (0.16557541489601135)*hpn_1;
    film_24 = film_24 + (-0.0015241402434185147)*hpn_2;
    film_24 = film_24 + (-0.087363764643669128)*hpn_3;
    film_24 = film_24 + (-0.0089047309011220932)*hpn_4;
    film_24 = film_24 + (-0.049163024872541428)*hpn_5;
    film_24 = film_24 + (-0.0058793183416128159)*hpn_6;
    film_24 = film_24 + (0.13374520838260651)*hpn_7;
    film_24 = film_24 + (-0.31165492534637451)*hpn_8;
    film_24 = film_24 + (0.053708814084529877)*hpn_9;
    film_24 = film_24 + (-0.18904213607311249)*hpn_10;
    film_24 = film_24 + (0.099922813475131989)*hpn_11;
    film_24 = film_24 + (-0.053029779344797134)*hpn_12;
    film_24 = film_24 + (0.073861777782440186)*hpn_13;
    film_24 = film_24 + (-0.16788297891616821)*hpn_14;
    film_24 = film_24 + (-0.16021336615085602)*hpn_15;
    film_25 = -0.05703551322221756;
    film_25 = film_25 + (-0.1048610657453537)*hpn_0;
    film_25 = film_25 + (0.19909954071044922)*hpn_1;
    film_25 = film_25 + (0.15983124077320099)*hpn_2;
    film_25 = film_25 + (-0.14745837450027466)*hpn_3;
    film_25 = film_25 + (-0.14864769577980042)*hpn_4;
    film_25 = film_25 + (0.075002983212471008)*hpn_5;
    film_25 = film_25 + (-0.22981585562229156)*hpn_6;
    film_25 = film_25 + (0.17430329322814941)*hpn_7;
    film_25 = film_25 + (0.091899730265140533)*hpn_8;
    film_25 = film_25 + (-0.13815233111381531)*hpn_9;
    film_25 = film_25 + (-0.27752223610877991)*hpn_10;
    film_25 = film_25 + (0.066590704023838043)*hpn_11;
    film_25 = film_25 + (0.22321179509162903)*hpn_12;
    film_25 = film_25 + (-0.17905621230602264)*hpn_13;
    film_25 = film_25 + (0.019926363602280617)*hpn_14;
    film_25 = film_25 + (-0.0907011479139328)*hpn_15;
    film_26 = 0.084894411265850067;
    film_26 = film_26 + (0.20622633397579193)*hpn_0;
    film_26 = film_26 + (-0.16147030889987946)*hpn_1;
    film_26 = film_26 + (0.11874019354581833)*hpn_2;
    film_26 = film_26 + (0.069414496421813965)*hpn_3;
    film_26 = film_26 + (0.055406726896762848)*hpn_4;
    film_26 = film_26 + (-0.24557700753211975)*hpn_5;
    film_26 = film_26 + (-0.15328924357891083)*hpn_6;
    film_26 = film_26 + (-0.20731818675994873)*hpn_7;
    film_26 = film_26 + (0.11460617929697037)*hpn_8;
    film_26 = film_26 + (0.10182403028011322)*hpn_9;
    film_26 = film_26 + (-0.0035868508275598288)*hpn_10;
    film_26 = film_26 + (0.064934529364109039)*hpn_11;
    film_26 = film_26 + (0.10749258100986481)*hpn_12;
    film_26 = film_26 + (0.0087913358584046364)*hpn_13;
    film_26 = film_26 + (-0.046847853809595108)*hpn_14;
    film_26 = film_26 + (-0.087978087365627289)*hpn_15;
    film_27 = -0.19973756372928619;
    film_27 = film_27 + (0.130020871758461)*hpn_0;
    film_27 = film_27 + (-0.13457018136978149)*hpn_1;
    film_27 = film_27 + (-0.29532620310783386)*hpn_2;
    film_27 = film_27 + (-0.036612071096897125)*hpn_3;
    film_27 = film_27 + (-0.2708771824836731)*hpn_4;
    film_27 = film_27 + (-0.043952848762273788)*hpn_5;
    film_27 = film_27 + (-0.022099638357758522)*hpn_6;
    film_27 = film_27 + (-0.25177013874053955)*hpn_7;
    film_27 = film_27 + (-0.15564067661762238)*hpn_8;
    film_27 = film_27 + (-0.15496622025966644)*hpn_9;
    film_27 = film_27 + (-0.043761376291513443)*hpn_10;
    film_27 = film_27 + (-0.21998919546604156)*hpn_11;
    film_27 = film_27 + (-0.0066356724128127098)*hpn_12;
    film_27 = film_27 + (-0.048404060304164886)*hpn_13;
    film_27 = film_27 + (0.16100442409515381)*hpn_14;
    film_27 = film_27 + (0.032885495573282242)*hpn_15;
    film_28 = -0.046078082174062729;
    film_28 = film_28 + (-0.088062368333339691)*hpn_0;
    film_28 = film_28 + (-0.045262262225151062)*hpn_1;
    film_28 = film_28 + (0.21092909574508667)*hpn_2;
    film_28 = film_28 + (-0.11943542212247849)*hpn_3;
    film_28 = film_28 + (-0.10137996822595596)*hpn_4;
    film_28 = film_28 + (0.043095186352729797)*hpn_5;
    film_28 = film_28 + (0.084596633911132812)*hpn_6;
    film_28 = film_28 + (0.1099570021033287)*hpn_7;
    film_28 = film_28 + (0.13500769436359406)*hpn_8;
    film_28 = film_28 + (0.24131040275096893)*hpn_9;
    film_28 = film_28 + (0.29573899507522583)*hpn_10;
    film_28 = film_28 + (0.15401574969291687)*hpn_11;
    film_28 = film_28 + (0.17406931519508362)*hpn_12;
    film_28 = film_28 + (-0.17821303009986877)*hpn_13;
    film_28 = film_28 + (-0.22920569777488708)*hpn_14;
    film_28 = film_28 + (0.33379945158958435)*hpn_15;
    film_29 = -0.17455647885799408;
    film_29 = film_29 + (-0.23138651251792908)*hpn_0;
    film_29 = film_29 + (-0.15957430005073547)*hpn_1;
    film_29 = film_29 + (-0.09153476357460022)*hpn_2;
    film_29 = film_29 + (0.27242329716682434)*hpn_3;
    film_29 = film_29 + (0.01107436791062355)*hpn_4;
    film_29 = film_29 + (-0.14671412110328674)*hpn_5;
    film_29 = film_29 + (-0.092570185661315918)*hpn_6;
    film_29 = film_29 + (-0.11605330556631088)*hpn_7;
    film_29 = film_29 + (0.095193356275558472)*hpn_8;
    film_29 = film_29 + (-0.1535315066576004)*hpn_9;
    film_29 = film_29 + (0.092873014509677887)*hpn_10;
    film_29 = film_29 + (-0.1139579638838768)*hpn_11;
    film_29 = film_29 + (-0.043119177222251892)*hpn_12;
    film_29 = film_29 + (-0.22035594284534454)*hpn_13;
    film_29 = film_29 + (-0.28597560524940491)*hpn_14;
    film_29 = film_29 + (-0.075859948992729187)*hpn_15;
    film_30 = -0.094875060021877289;
    film_30 = film_30 + (-0.32743018865585327)*hpn_0;
    film_30 = film_30 + (0.18670672178268433)*hpn_1;
    film_30 = film_30 + (0.3553936779499054)*hpn_2;
    film_30 = film_30 + (-0.11933328211307526)*hpn_3;
    film_30 = film_30 + (0.17957653105258942)*hpn_4;
    film_30 = film_30 + (-0.27677780389785767)*hpn_5;
    film_30 = film_30 + (-0.08110925555229187)*hpn_6;
    film_30 = film_30 + (0.33897221088409424)*hpn_7;
    film_30 = film_30 + (-0.057528100907802582)*hpn_8;
    film_30 = film_30 + (-0.26922842860221863)*hpn_9;
    film_30 = film_30 + (0.0075128804892301559)*hpn_10;
    film_30 = film_30 + (-0.098469637334346771)*hpn_11;
    film_30 = film_30 + (-0.015293262898921967)*hpn_12;
    film_30 = film_30 + (-0.018095763400197029)*hpn_13;
    film_30 = film_30 + (-0.11932002007961273)*hpn_14;
    film_30 = film_30 + (0.036210570484399796)*hpn_15;
    film_31 = -0.073388181626796722;
    film_31 = film_31 + (0.46754217147827148)*hpn_0;
    film_31 = film_31 + (0.27970299124717712)*hpn_1;
    film_31 = film_31 + (-0.079779893159866333)*hpn_2;
    film_31 = film_31 + (-0.057505052536725998)*hpn_3;
    film_31 = film_31 + (0.12166927754878998)*hpn_4;
    film_31 = film_31 + (-0.026365123689174652)*hpn_5;
    film_31 = film_31 + (-0.33318960666656494)*hpn_6;
    film_31 = film_31 + (-0.31889933347702026)*hpn_7;
    film_31 = film_31 + (-0.29229274392127991)*hpn_8;
    film_31 = film_31 + (0.10288875550031662)*hpn_9;
    film_31 = film_31 + (0.095463655889034271)*hpn_10;
    film_31 = film_31 + (0.24172842502593994)*hpn_11;
    film_31 = film_31 + (0.17333407700061798)*hpn_12;
    film_31 = film_31 + (-0.14690254628658295)*hpn_13;
    film_31 = film_31 + (-0.15150517225265503)*hpn_14;
    film_31 = film_31 + (0.17482461035251617)*hpn_15;
    hfp_0 = hv_0 * film_0 + film_16;
    hfp_1 = hv_1 * film_1 + film_17;
    hfp_2 = hv_2 * film_2 + film_18;
    hfp_3 = hv_3 * film_3 + film_19;
    hfp_4 = hv_4 * film_4 + film_20;
    hfp_5 = hv_5 * film_5 + film_21;
    hfp_6 = hv_6 * film_6 + film_22;
    hfp_7 = hv_7 * film_7 + film_23;
    hfp_8 = hv_8 * film_8 + film_24;
    hfp_9 = hv_9 * film_9 + film_25;
    hfp_10 = hv_10 * film_10 + film_26;
    hfp_11 = hv_11 * film_11 + film_27;
    hfp_12 = hv_12 * film_12 + film_28;
    hfp_13 = hv_13 * film_13 + film_29;
    hfp_14 = hv_14 * film_14 + film_30;
    hfp_15 = hv_15 * film_15 + film_31;
    hf_mean = (hfp_0 + hfp_1 + hfp_2 + hfp_3 + hfp_4 + hfp_5 + hfp_6 + hfp_7 + hfp_8 + hfp_9 + hfp_10 + hfp_11 + hfp_12 + hfp_13 + hfp_14 + hfp_15) / 16;
    hf_var = (((hfp_0) - hf_mean)*((hfp_0) - hf_mean) + ((hfp_1) - hf_mean)*((hfp_1) - hf_mean) + ((hfp_2) - hf_mean)*((hfp_2) - hf_mean) + ((hfp_3) - hf_mean)*((hfp_3) - hf_mean) + ((hfp_4) - hf_mean)*((hfp_4) - hf_mean) + ((hfp_5) - hf_mean)*((hfp_5) - hf_mean) + ((hfp_6) - hf_mean)*((hfp_6) - hf_mean) + ((hfp_7) - hf_mean)*((hfp_7) - hf_mean) + ((hfp_8) - hf_mean)*((hfp_8) - hf_mean) + ((hfp_9) - hf_mean)*((hfp_9) - hf_mean) + ((hfp_10) - hf_mean)*((hfp_10) - hf_mean) + ((hfp_11) - hf_mean)*((hfp_11) - hf_mean) + ((hfp_12) - hf_mean)*((hfp_12) - hf_mean) + ((hfp_13) - hf_mean)*((hfp_13) - hf_mean) + ((hfp_14) - hf_mean)*((hfp_14) - hf_mean) + ((hfp_15) - hf_mean)*((hfp_15) - hf_mean)) / 16;
    hfn_0 = ((hfp_0) - hf_mean) / sqrt(hf_var + ln_eps);
    hfn_1 = ((hfp_1) - hf_mean) / sqrt(hf_var + ln_eps);
    hfn_2 = ((hfp_2) - hf_mean) / sqrt(hf_var + ln_eps);
    hfn_3 = ((hfp_3) - hf_mean) / sqrt(hf_var + ln_eps);
    hfn_4 = ((hfp_4) - hf_mean) / sqrt(hf_var + ln_eps);
    hfn_5 = ((hfp_5) - hf_mean) / sqrt(hf_var + ln_eps);
    hfn_6 = ((hfp_6) - hf_mean) / sqrt(hf_var + ln_eps);
    hfn_7 = ((hfp_7) - hf_mean) / sqrt(hf_var + ln_eps);
    hfn_8 = ((hfp_8) - hf_mean) / sqrt(hf_var + ln_eps);
    hfn_9 = ((hfp_9) - hf_mean) / sqrt(hf_var + ln_eps);
    hfn_10 = ((hfp_10) - hf_mean) / sqrt(hf_var + ln_eps);
    hfn_11 = ((hfp_11) - hf_mean) / sqrt(hf_var + ln_eps);
    hfn_12 = ((hfp_12) - hf_mean) / sqrt(hf_var + ln_eps);
    hfn_13 = ((hfp_13) - hf_mean) / sqrt(hf_var + ln_eps);
    hfn_14 = ((hfp_14) - hf_mean) / sqrt(hf_var + ln_eps);
    hfn_15 = ((hfp_15) - hf_mean) / sqrt(hf_var + ln_eps);
    fh_l0_0 = 0.10645614564418793;
    fh_l0_0 = fh_l0_0 + (-0.053949743509292603)*hfn_0;
    fh_l0_0 = fh_l0_0 + (-0.28367206454277039)*hfn_1;
    fh_l0_0 = fh_l0_0 + (0.0072679989971220493)*hfn_2;
    fh_l0_0 = fh_l0_0 + (0.19368623197078705)*hfn_3;
    fh_l0_0 = fh_l0_0 + (0.12693023681640625)*hfn_4;
    fh_l0_0 = fh_l0_0 + (-0.22990572452545166)*hfn_5;
    fh_l0_0 = fh_l0_0 + (0.29675513505935669)*hfn_6;
    fh_l0_0 = fh_l0_0 + (0.071916483342647552)*hfn_7;
    fh_l0_0 = fh_l0_0 + (0.16286772489547729)*hfn_8;
    fh_l0_0 = fh_l0_0 + (-0.15928156673908234)*hfn_9;
    fh_l0_0 = fh_l0_0 + (-0.16372179985046387)*hfn_10;
    fh_l0_0 = fh_l0_0 + (0.44125282764434814)*hfn_11;
    fh_l0_0 = fh_l0_0 + (0.31866413354873657)*hfn_12;
    fh_l0_0 = fh_l0_0 + (-0.045760519802570343)*hfn_13;
    fh_l0_0 = fh_l0_0 + (-0.35736677050590515)*hfn_14;
    fh_l0_0 = fh_l0_0 + (-0.030360817909240723)*hfn_15;
    fh_l0_1 = -0.24255800247192383;
    fh_l0_1 = fh_l0_1 + (0.14831671118736267)*hfn_0;
    fh_l0_1 = fh_l0_1 + (-0.2701357901096344)*hfn_1;
    fh_l0_1 = fh_l0_1 + (0.11581114679574966)*hfn_2;
    fh_l0_1 = fh_l0_1 + (0.19199731945991516)*hfn_3;
    fh_l0_1 = fh_l0_1 + (-0.038880020380020142)*hfn_4;
    fh_l0_1 = fh_l0_1 + (-0.053504575043916702)*hfn_5;
    fh_l0_1 = fh_l0_1 + (0.20942509174346924)*hfn_6;
    fh_l0_1 = fh_l0_1 + (0.21036964654922485)*hfn_7;
    fh_l0_1 = fh_l0_1 + (-0.12577991187572479)*hfn_8;
    fh_l0_1 = fh_l0_1 + (-0.15441164374351501)*hfn_9;
    fh_l0_1 = fh_l0_1 + (-0.050453618168830872)*hfn_10;
    fh_l0_1 = fh_l0_1 + (0.027690917253494263)*hfn_11;
    fh_l0_1 = fh_l0_1 + (0.13011984527111053)*hfn_12;
    fh_l0_1 = fh_l0_1 + (-0.18528977036476135)*hfn_13;
    fh_l0_1 = fh_l0_1 + (-0.23522678017616272)*hfn_14;
    fh_l0_1 = fh_l0_1 + (0.078484490513801575)*hfn_15;
    fh_l0_2 = -0.3138124942779541;
    fh_l0_2 = fh_l0_2 + (0.36416390538215637)*hfn_0;
    fh_l0_2 = fh_l0_2 + (0.10424758493900299)*hfn_1;
    fh_l0_2 = fh_l0_2 + (0.14798139035701752)*hfn_2;
    fh_l0_2 = fh_l0_2 + (-0.12323970347642899)*hfn_3;
    fh_l0_2 = fh_l0_2 + (-0.28943699598312378)*hfn_4;
    fh_l0_2 = fh_l0_2 + (-0.19587148725986481)*hfn_5;
    fh_l0_2 = fh_l0_2 + (0.026359580457210541)*hfn_6;
    fh_l0_2 = fh_l0_2 + (0.35255491733551025)*hfn_7;
    fh_l0_2 = fh_l0_2 + (-0.15387006103992462)*hfn_8;
    fh_l0_2 = fh_l0_2 + (0.158916175365448)*hfn_9;
    fh_l0_2 = fh_l0_2 + (0.26169890165328979)*hfn_10;
    fh_l0_2 = fh_l0_2 + (0.074441716074943542)*hfn_11;
    fh_l0_2 = fh_l0_2 + (0.094474375247955322)*hfn_12;
    fh_l0_2 = fh_l0_2 + (-0.0071071828715503216)*hfn_13;
    fh_l0_2 = fh_l0_2 + (0.48490893840789795)*hfn_14;
    fh_l0_2 = fh_l0_2 + (0.1066143661737442)*hfn_15;
    fh_l0_3 = 0.2141331285238266;
    fh_l0_3 = fh_l0_3 + (-0.024795593693852425)*hfn_0;
    fh_l0_3 = fh_l0_3 + (-0.044701401144266129)*hfn_1;
    fh_l0_3 = fh_l0_3 + (0.10825977474451065)*hfn_2;
    fh_l0_3 = fh_l0_3 + (-0.2680402398109436)*hfn_3;
    fh_l0_3 = fh_l0_3 + (-0.011674358509480953)*hfn_4;
    fh_l0_3 = fh_l0_3 + (-0.41767150163650513)*hfn_5;
    fh_l0_3 = fh_l0_3 + (0.086630724370479584)*hfn_6;
    fh_l0_3 = fh_l0_3 + (-0.41934606432914734)*hfn_7;
    fh_l0_3 = fh_l0_3 + (0.20612789690494537)*hfn_8;
    fh_l0_3 = fh_l0_3 + (-0.062916390597820282)*hfn_9;
    fh_l0_3 = fh_l0_3 + (0.29013898968696594)*hfn_10;
    fh_l0_3 = fh_l0_3 + (0.0054747103713452816)*hfn_11;
    fh_l0_3 = fh_l0_3 + (-0.25600844621658325)*hfn_12;
    fh_l0_3 = fh_l0_3 + (0.26023480296134949)*hfn_13;
    fh_l0_3 = fh_l0_3 + (0.27783602476119995)*hfn_14;
    fh_l0_3 = fh_l0_3 + (0.025708269327878952)*hfn_15;
    fh_l0_4 = -0.0011650800006464124;
    fh_l0_4 = fh_l0_4 + (0.12555350363254547)*hfn_0;
    fh_l0_4 = fh_l0_4 + (-0.21887439489364624)*hfn_1;
    fh_l0_4 = fh_l0_4 + (-0.11831182241439819)*hfn_2;
    fh_l0_4 = fh_l0_4 + (0.10239523649215698)*hfn_3;
    fh_l0_4 = fh_l0_4 + (0.22188256680965424)*hfn_4;
    fh_l0_4 = fh_l0_4 + (0.033889561891555786)*hfn_5;
    fh_l0_4 = fh_l0_4 + (0.093881301581859589)*hfn_6;
    fh_l0_4 = fh_l0_4 + (0.27532607316970825)*hfn_7;
    fh_l0_4 = fh_l0_4 + (-0.091744698584079742)*hfn_8;
    fh_l0_4 = fh_l0_4 + (-0.24466617405414581)*hfn_9;
    fh_l0_4 = fh_l0_4 + (0.24988642334938049)*hfn_10;
    fh_l0_4 = fh_l0_4 + (0.042569380253553391)*hfn_11;
    fh_l0_4 = fh_l0_4 + (0.2275422215461731)*hfn_12;
    fh_l0_4 = fh_l0_4 + (-0.068956755101680756)*hfn_13;
    fh_l0_4 = fh_l0_4 + (-0.054771501570940018)*hfn_14;
    fh_l0_4 = fh_l0_4 + (0.25830772519111633)*hfn_15;
    fh_l0_5 = 0.24221411347389221;
    fh_l0_5 = fh_l0_5 + (0.083975449204444885)*hfn_0;
    fh_l0_5 = fh_l0_5 + (0.38049930334091187)*hfn_1;
    fh_l0_5 = fh_l0_5 + (0.45528587698936462)*hfn_2;
    fh_l0_5 = fh_l0_5 + (-0.28291058540344238)*hfn_3;
    fh_l0_5 = fh_l0_5 + (0.040954295545816422)*hfn_4;
    fh_l0_5 = fh_l0_5 + (-0.45355924963951111)*hfn_5;
    fh_l0_5 = fh_l0_5 + (-0.49449566006660461)*hfn_6;
    fh_l0_5 = fh_l0_5 + (0.21617980301380157)*hfn_7;
    fh_l0_5 = fh_l0_5 + (0.050087690353393555)*hfn_8;
    fh_l0_5 = fh_l0_5 + (0.26009261608123779)*hfn_9;
    fh_l0_5 = fh_l0_5 + (0.0087984995916485786)*hfn_10;
    fh_l0_5 = fh_l0_5 + (-0.016314944252371788)*hfn_11;
    fh_l0_5 = fh_l0_5 + (-0.53375440835952759)*hfn_12;
    fh_l0_5 = fh_l0_5 + (0.12095069140195847)*hfn_13;
    fh_l0_5 = fh_l0_5 + (0.30008527636528015)*hfn_14;
    fh_l0_5 = fh_l0_5 + (0.023706762120127678)*hfn_15;
    fh_l0_6 = 0.101873978972435;
    fh_l0_6 = fh_l0_6 + (-0.23543469607830048)*hfn_0;
    fh_l0_6 = fh_l0_6 + (-0.035480659455060959)*hfn_1;
    fh_l0_6 = fh_l0_6 + (-0.21934507787227631)*hfn_2;
    fh_l0_6 = fh_l0_6 + (0.23463456332683563)*hfn_3;
    fh_l0_6 = fh_l0_6 + (0.025306191295385361)*hfn_4;
    fh_l0_6 = fh_l0_6 + (-0.084231190383434296)*hfn_5;
    fh_l0_6 = fh_l0_6 + (-0.05846879631280899)*hfn_6;
    fh_l0_6 = fh_l0_6 + (0.023824827745556831)*hfn_7;
    fh_l0_6 = fh_l0_6 + (0.099672421813011169)*hfn_8;
    fh_l0_6 = fh_l0_6 + (-0.19366642832756042)*hfn_9;
    fh_l0_6 = fh_l0_6 + (-0.023773606866598129)*hfn_10;
    fh_l0_6 = fh_l0_6 + (0.35089373588562012)*hfn_11;
    fh_l0_6 = fh_l0_6 + (0.18182636797428131)*hfn_12;
    fh_l0_6 = fh_l0_6 + (0.12240756303071976)*hfn_13;
    fh_l0_6 = fh_l0_6 + (0.21141767501831055)*hfn_14;
    fh_l0_6 = fh_l0_6 + (0.12234062701463699)*hfn_15;
    fh_l0_7 = 0.032937388867139816;
    fh_l0_7 = fh_l0_7 + (0.19951140880584717)*hfn_0;
    fh_l0_7 = fh_l0_7 + (0.35916513204574585)*hfn_1;
    fh_l0_7 = fh_l0_7 + (-0.21812687814235687)*hfn_2;
    fh_l0_7 = fh_l0_7 + (-0.19925832748413086)*hfn_3;
    fh_l0_7 = fh_l0_7 + (-0.089573338627815247)*hfn_4;
    fh_l0_7 = fh_l0_7 + (-0.12722590565681458)*hfn_5;
    fh_l0_7 = fh_l0_7 + (0.37642562389373779)*hfn_6;
    fh_l0_7 = fh_l0_7 + (-0.32754901051521301)*hfn_7;
    fh_l0_7 = fh_l0_7 + (-0.08952610194683075)*hfn_8;
    fh_l0_7 = fh_l0_7 + (0.082816697657108307)*hfn_9;
    fh_l0_7 = fh_l0_7 + (-0.11873188614845276)*hfn_10;
    fh_l0_7 = fh_l0_7 + (-0.16902957856655121)*hfn_11;
    fh_l0_7 = fh_l0_7 + (0.049017723649740219)*hfn_12;
    fh_l0_7 = fh_l0_7 + (-0.17527425289154053)*hfn_13;
    fh_l0_7 = fh_l0_7 + (-0.097079619765281677)*hfn_14;
    fh_l0_7 = fh_l0_7 + (-0.027745846658945084)*hfn_15;
    fh_l0_8 = 0.15033911168575287;
    fh_l0_8 = fh_l0_8 + (0.11234050989151001)*hfn_0;
    fh_l0_8 = fh_l0_8 + (-0.097704529762268066)*hfn_1;
    fh_l0_8 = fh_l0_8 + (-0.068204522132873535)*hfn_2;
    fh_l0_8 = fh_l0_8 + (0.26234045624732971)*hfn_3;
    fh_l0_8 = fh_l0_8 + (0.19609633088111877)*hfn_4;
    fh_l0_8 = fh_l0_8 + (0.23853647708892822)*hfn_5;
    fh_l0_8 = fh_l0_8 + (0.051758833229541779)*hfn_6;
    fh_l0_8 = fh_l0_8 + (0.01008477620780468)*hfn_7;
    fh_l0_8 = fh_l0_8 + (-0.12455748021602631)*hfn_8;
    fh_l0_8 = fh_l0_8 + (-0.22650539875030518)*hfn_9;
    fh_l0_8 = fh_l0_8 + (-0.1354985386133194)*hfn_10;
    fh_l0_8 = fh_l0_8 + (-0.12752984464168549)*hfn_11;
    fh_l0_8 = fh_l0_8 + (0.1517070084810257)*hfn_12;
    fh_l0_8 = fh_l0_8 + (-0.088272817432880402)*hfn_13;
    fh_l0_8 = fh_l0_8 + (-0.040624182671308517)*hfn_14;
    fh_l0_8 = fh_l0_8 + (-0.29381227493286133)*hfn_15;
    fh_l0_9 = 0.2879101037979126;
    fh_l0_9 = fh_l0_9 + (-0.11164044588804245)*hfn_0;
    fh_l0_9 = fh_l0_9 + (-0.32285472750663757)*hfn_1;
    fh_l0_9 = fh_l0_9 + (-0.067038491368293762)*hfn_2;
    fh_l0_9 = fh_l0_9 + (0.096277549862861633)*hfn_3;
    fh_l0_9 = fh_l0_9 + (-0.15634137392044067)*hfn_4;
    fh_l0_9 = fh_l0_9 + (-0.14433883130550385)*hfn_5;
    fh_l0_9 = fh_l0_9 + (0.20739017426967621)*hfn_6;
    fh_l0_9 = fh_l0_9 + (0.076291345059871674)*hfn_7;
    fh_l0_9 = fh_l0_9 + (0.26302826404571533)*hfn_8;
    fh_l0_9 = fh_l0_9 + (-0.063169941306114197)*hfn_9;
    fh_l0_9 = fh_l0_9 + (0.12157843261957169)*hfn_10;
    fh_l0_9 = fh_l0_9 + (0.16428518295288086)*hfn_11;
    fh_l0_9 = fh_l0_9 + (0.11094081401824951)*hfn_12;
    fh_l0_9 = fh_l0_9 + (-0.0918879434466362)*hfn_13;
    fh_l0_9 = fh_l0_9 + (-0.32609808444976807)*hfn_14;
    fh_l0_9 = fh_l0_9 + (0.28306218981742859)*hfn_15;
    fh_l0_10 = 0.17641918361186981;
    fh_l0_10 = fh_l0_10 + (-0.12923213839530945)*hfn_0;
    fh_l0_10 = fh_l0_10 + (0.21631558239459991)*hfn_1;
    fh_l0_10 = fh_l0_10 + (0.36404120922088623)*hfn_2;
    fh_l0_10 = fh_l0_10 + (-0.20555169880390167)*hfn_3;
    fh_l0_10 = fh_l0_10 + (0.23271197080612183)*hfn_4;
    fh_l0_10 = fh_l0_10 + (-0.69784641265869141)*hfn_5;
    fh_l0_10 = fh_l0_10 + (-0.063381843268871307)*hfn_6;
    fh_l0_10 = fh_l0_10 + (0.023477662354707718)*hfn_7;
    fh_l0_10 = fh_l0_10 + (-0.1703304797410965)*hfn_8;
    fh_l0_10 = fh_l0_10 + (0.048411719501018524)*hfn_9;
    fh_l0_10 = fh_l0_10 + (-0.090640775859355927)*hfn_10;
    fh_l0_10 = fh_l0_10 + (0.10306396335363388)*hfn_11;
    fh_l0_10 = fh_l0_10 + (-0.47738060355186462)*hfn_12;
    fh_l0_10 = fh_l0_10 + (-0.086604036390781403)*hfn_13;
    fh_l0_10 = fh_l0_10 + (0.15333786606788635)*hfn_14;
    fh_l0_10 = fh_l0_10 + (0.24353706836700439)*hfn_15;
    fh_l0_11 = -0.071713335812091827;
    fh_l0_11 = fh_l0_11 + (0.38172066211700439)*hfn_0;
    fh_l0_11 = fh_l0_11 + (0.10072041302919388)*hfn_1;
    fh_l0_11 = fh_l0_11 + (-0.029031690210103989)*hfn_2;
    fh_l0_11 = fh_l0_11 + (0.024124119430780411)*hfn_3;
    fh_l0_11 = fh_l0_11 + (0.25795558094978333)*hfn_4;
    fh_l0_11 = fh_l0_11 + (0.097639799118041992)*hfn_5;
    fh_l0_11 = fh_l0_11 + (-0.036432337015867233)*hfn_6;
    fh_l0_11 = fh_l0_11 + (-0.11014377325773239)*hfn_7;
    fh_l0_11 = fh_l0_11 + (0.1003565713763237)*hfn_8;
    fh_l0_11 = fh_l0_11 + (-0.055351752787828445)*hfn_9;
    fh_l0_11 = fh_l0_11 + (-0.31234651803970337)*hfn_10;
    fh_l0_11 = fh_l0_11 + (-0.043779626488685608)*hfn_11;
    fh_l0_11 = fh_l0_11 + (0.20315323770046234)*hfn_12;
    fh_l0_11 = fh_l0_11 + (-0.072951115667819977)*hfn_13;
    fh_l0_11 = fh_l0_11 + (-0.058885484933853149)*hfn_14;
    fh_l0_11 = fh_l0_11 + (0.19466216862201691)*hfn_15;
    fh_l0_12 = 0.12822975218296051;
    fh_l0_12 = fh_l0_12 + (0.017409732565283775)*hfn_0;
    fh_l0_12 = fh_l0_12 + (-0.13162907958030701)*hfn_1;
    fh_l0_12 = fh_l0_12 + (0.16643700003623962)*hfn_2;
    fh_l0_12 = fh_l0_12 + (0.11846371740102768)*hfn_3;
    fh_l0_12 = fh_l0_12 + (0.19891712069511414)*hfn_4;
    fh_l0_12 = fh_l0_12 + (0.14954248070716858)*hfn_5;
    fh_l0_12 = fh_l0_12 + (0.12109857052564621)*hfn_6;
    fh_l0_12 = fh_l0_12 + (-0.018781265243887901)*hfn_7;
    fh_l0_12 = fh_l0_12 + (0.1407063752412796)*hfn_8;
    fh_l0_12 = fh_l0_12 + (-0.26740092039108276)*hfn_9;
    fh_l0_12 = fh_l0_12 + (-0.050680257380008698)*hfn_10;
    fh_l0_12 = fh_l0_12 + (-0.10447291284799576)*hfn_11;
    fh_l0_12 = fh_l0_12 + (-0.039381653070449829)*hfn_12;
    fh_l0_12 = fh_l0_12 + (-0.061100348830223083)*hfn_13;
    fh_l0_12 = fh_l0_12 + (-0.090403944253921509)*hfn_14;
    fh_l0_12 = fh_l0_12 + (0.11544492095708847)*hfn_15;
    fh_l0_13 = -0.0607338547706604;
    fh_l0_13 = fh_l0_13 + (-0.016539949923753738)*hfn_0;
    fh_l0_13 = fh_l0_13 + (0.15651048719882965)*hfn_1;
    fh_l0_13 = fh_l0_13 + (-0.1433272510766983)*hfn_2;
    fh_l0_13 = fh_l0_13 + (-0.075443863868713379)*hfn_3;
    fh_l0_13 = fh_l0_13 + (0.15395411849021912)*hfn_4;
    fh_l0_13 = fh_l0_13 + (0.21433082222938538)*hfn_5;
    fh_l0_13 = fh_l0_13 + (0.11140865832567215)*hfn_6;
    fh_l0_13 = fh_l0_13 + (-0.25923994183540344)*hfn_7;
    fh_l0_13 = fh_l0_13 + (0.065467894077301025)*hfn_8;
    fh_l0_13 = fh_l0_13 + (-0.20793570578098297)*hfn_9;
    fh_l0_13 = fh_l0_13 + (0.023211497813463211)*hfn_10;
    fh_l0_13 = fh_l0_13 + (0.18972238898277283)*hfn_11;
    fh_l0_13 = fh_l0_13 + (0.17816793918609619)*hfn_12;
    fh_l0_13 = fh_l0_13 + (-0.041035603731870651)*hfn_13;
    fh_l0_13 = fh_l0_13 + (0.0036430784966796637)*hfn_14;
    fh_l0_13 = fh_l0_13 + (0.13979017734527588)*hfn_15;
    fh_l0_14 = 0.14731249213218689;
    fh_l0_14 = fh_l0_14 + (-0.50464707612991333)*hfn_0;
    fh_l0_14 = fh_l0_14 + (-0.10755430161952972)*hfn_1;
    fh_l0_14 = fh_l0_14 + (0.15516923367977142)*hfn_2;
    fh_l0_14 = fh_l0_14 + (0.26676824688911438)*hfn_3;
    fh_l0_14 = fh_l0_14 + (-0.1152997687458992)*hfn_4;
    fh_l0_14 = fh_l0_14 + (-0.1098008006811142)*hfn_5;
    fh_l0_14 = fh_l0_14 + (0.046831730753183365)*hfn_6;
    fh_l0_14 = fh_l0_14 + (0.18708725273609161)*hfn_7;
    fh_l0_14 = fh_l0_14 + (0.37463697791099548)*hfn_8;
    fh_l0_14 = fh_l0_14 + (0.22730058431625366)*hfn_9;
    fh_l0_14 = fh_l0_14 + (-0.40900769829750061)*hfn_10;
    fh_l0_14 = fh_l0_14 + (-0.17166171967983246)*hfn_11;
    fh_l0_14 = fh_l0_14 + (0.22233957052230835)*hfn_12;
    fh_l0_14 = fh_l0_14 + (-0.065455891191959381)*hfn_13;
    fh_l0_14 = fh_l0_14 + (-0.48960387706756592)*hfn_14;
    fh_l0_14 = fh_l0_14 + (-0.065245762467384338)*hfn_15;
    fh_l0_15 = 0.23631034791469574;
    fh_l0_15 = fh_l0_15 + (-0.11676594614982605)*hfn_0;
    fh_l0_15 = fh_l0_15 + (0.062725536525249481)*hfn_1;
    fh_l0_15 = fh_l0_15 + (0.1506323516368866)*hfn_2;
    fh_l0_15 = fh_l0_15 + (-0.070869565010070801)*hfn_3;
    fh_l0_15 = fh_l0_15 + (-0.20957064628601074)*hfn_4;
    fh_l0_15 = fh_l0_15 + (0.018201304599642754)*hfn_5;
    fh_l0_15 = fh_l0_15 + (-0.045217007398605347)*hfn_6;
    fh_l0_15 = fh_l0_15 + (-0.029031001031398773)*hfn_7;
    fh_l0_15 = fh_l0_15 + (-0.079670451581478119)*hfn_8;
    fh_l0_15 = fh_l0_15 + (-0.15746529400348663)*hfn_9;
    fh_l0_15 = fh_l0_15 + (0.039520718157291412)*hfn_10;
    fh_l0_15 = fh_l0_15 + (-0.088710710406303406)*hfn_11;
    fh_l0_15 = fh_l0_15 + (0.15426118671894073)*hfn_12;
    fh_l0_15 = fh_l0_15 + (-0.0018133969279006124)*hfn_13;
    fh_l0_15 = fh_l0_15 + (0.11679398268461227)*hfn_14;
    fh_l0_15 = fh_l0_15 + (-0.17709553241729736)*hfn_15;
    fh_l0_16 = -0.1484372615814209;
    fh_l0_16 = fh_l0_16 + (0.14495763182640076)*hfn_0;
    fh_l0_16 = fh_l0_16 + (0.23251073062419891)*hfn_1;
    fh_l0_16 = fh_l0_16 + (-0.5017092227935791)*hfn_2;
    fh_l0_16 = fh_l0_16 + (-0.14818020164966583)*hfn_3;
    fh_l0_16 = fh_l0_16 + (-0.16464085876941681)*hfn_4;
    fh_l0_16 = fh_l0_16 + (-0.041972346603870392)*hfn_5;
    fh_l0_16 = fh_l0_16 + (-0.059622086584568024)*hfn_6;
    fh_l0_16 = fh_l0_16 + (-0.51078921556472778)*hfn_7;
    fh_l0_16 = fh_l0_16 + (-0.20611035823822021)*hfn_8;
    fh_l0_16 = fh_l0_16 + (-0.048290595412254333)*hfn_9;
    fh_l0_16 = fh_l0_16 + (-0.19838954508304596)*hfn_10;
    fh_l0_16 = fh_l0_16 + (0.52579295635223389)*hfn_11;
    fh_l0_16 = fh_l0_16 + (0.005487415473908186)*hfn_12;
    fh_l0_16 = fh_l0_16 + (-0.077636294066905975)*hfn_13;
    fh_l0_16 = fh_l0_16 + (0.040446888655424118)*hfn_14;
    fh_l0_16 = fh_l0_16 + (0.27229714393615723)*hfn_15;
    fh_l0_17 = -0.17306995391845703;
    fh_l0_17 = fh_l0_17 + (-0.29130017757415771)*hfn_0;
    fh_l0_17 = fh_l0_17 + (0.49626472592353821)*hfn_1;
    fh_l0_17 = fh_l0_17 + (0.25607621669769287)*hfn_2;
    fh_l0_17 = fh_l0_17 + (0.086423695087432861)*hfn_3;
    fh_l0_17 = fh_l0_17 + (-0.03900475800037384)*hfn_4;
    fh_l0_17 = fh_l0_17 + (-0.22897662222385406)*hfn_5;
    fh_l0_17 = fh_l0_17 + (-0.14502568542957306)*hfn_6;
    fh_l0_17 = fh_l0_17 + (-0.12286067008972168)*hfn_7;
    fh_l0_17 = fh_l0_17 + (0.085559584200382233)*hfn_8;
    fh_l0_17 = fh_l0_17 + (-0.017831699922680855)*hfn_9;
    fh_l0_17 = fh_l0_17 + (-0.18707355856895447)*hfn_10;
    fh_l0_17 = fh_l0_17 + (0.067005835473537445)*hfn_11;
    fh_l0_17 = fh_l0_17 + (-0.80339831113815308)*hfn_12;
    fh_l0_17 = fh_l0_17 + (0.13012896478176117)*hfn_13;
    fh_l0_17 = fh_l0_17 + (-0.34491109848022461)*hfn_14;
    fh_l0_17 = fh_l0_17 + (0.11218206584453583)*hfn_15;
    fh_l0_18 = -0.22709463536739349;
    fh_l0_18 = fh_l0_18 + (0.092928163707256317)*hfn_0;
    fh_l0_18 = fh_l0_18 + (-0.24949552118778229)*hfn_1;
    fh_l0_18 = fh_l0_18 + (0.19586259126663208)*hfn_2;
    fh_l0_18 = fh_l0_18 + (0.37304121255874634)*hfn_3;
    fh_l0_18 = fh_l0_18 + (-0.060059752315282822)*hfn_4;
    fh_l0_18 = fh_l0_18 + (0.20359642803668976)*hfn_5;
    fh_l0_18 = fh_l0_18 + (0.016332168132066727)*hfn_6;
    fh_l0_18 = fh_l0_18 + (0.30634734034538269)*hfn_7;
    fh_l0_18 = fh_l0_18 + (-0.099946178495883942)*hfn_8;
    fh_l0_18 = fh_l0_18 + (-0.060202345252037048)*hfn_9;
    fh_l0_18 = fh_l0_18 + (0.22548151016235352)*hfn_10;
    fh_l0_18 = fh_l0_18 + (-0.083801038563251495)*hfn_11;
    fh_l0_18 = fh_l0_18 + (0.16010919213294983)*hfn_12;
    fh_l0_18 = fh_l0_18 + (-0.1893579363822937)*hfn_13;
    fh_l0_18 = fh_l0_18 + (-0.19211603701114655)*hfn_14;
    fh_l0_18 = fh_l0_18 + (-0.1626855880022049)*hfn_15;
    fh_l0_19 = -0.082944080233573914;
    fh_l0_19 = fh_l0_19 + (-0.016353597864508629)*hfn_0;
    fh_l0_19 = fh_l0_19 + (-0.081704519689083099)*hfn_1;
    fh_l0_19 = fh_l0_19 + (-0.069759704172611237)*hfn_2;
    fh_l0_19 = fh_l0_19 + (0.06837046891450882)*hfn_3;
    fh_l0_19 = fh_l0_19 + (0.26641291379928589)*hfn_4;
    fh_l0_19 = fh_l0_19 + (0.26891148090362549)*hfn_5;
    fh_l0_19 = fh_l0_19 + (0.24636872112751007)*hfn_6;
    fh_l0_19 = fh_l0_19 + (-0.19251297414302826)*hfn_7;
    fh_l0_19 = fh_l0_19 + (-0.2363610565662384)*hfn_8;
    fh_l0_19 = fh_l0_19 + (-0.18356746435165405)*hfn_9;
    fh_l0_19 = fh_l0_19 + (-0.073606565594673157)*hfn_10;
    fh_l0_19 = fh_l0_19 + (-0.072462044656276703)*hfn_11;
    fh_l0_19 = fh_l0_19 + (0.13673362135887146)*hfn_12;
    fh_l0_19 = fh_l0_19 + (-0.27079236507415771)*hfn_13;
    fh_l0_19 = fh_l0_19 + (-0.10416515916585922)*hfn_14;
    fh_l0_19 = fh_l0_19 + (-0.058138590306043625)*hfn_15;
    fh_l0_20 = 0.014870046637952328;
    fh_l0_20 = fh_l0_20 + (-0.2060934454202652)*hfn_0;
    fh_l0_20 = fh_l0_20 + (-0.15613488852977753)*hfn_1;
    fh_l0_20 = fh_l0_20 + (0.21696722507476807)*hfn_2;
    fh_l0_20 = fh_l0_20 + (0.010152130387723446)*hfn_3;
    fh_l0_20 = fh_l0_20 + (0.17930322885513306)*hfn_4;
    fh_l0_20 = fh_l0_20 + (-0.098834991455078125)*hfn_5;
    fh_l0_20 = fh_l0_20 + (-0.10491535812616348)*hfn_6;
    fh_l0_20 = fh_l0_20 + (-0.2511821985244751)*hfn_7;
    fh_l0_20 = fh_l0_20 + (-0.13895708322525024)*hfn_8;
    fh_l0_20 = fh_l0_20 + (0.058426860719919205)*hfn_9;
    fh_l0_20 = fh_l0_20 + (-0.13081818819046021)*hfn_10;
    fh_l0_20 = fh_l0_20 + (-0.12586289644241333)*hfn_11;
    fh_l0_20 = fh_l0_20 + (0.01296512596309185)*hfn_12;
    fh_l0_20 = fh_l0_20 + (0.22310137748718262)*hfn_13;
    fh_l0_20 = fh_l0_20 + (0.17844539880752563)*hfn_14;
    fh_l0_20 = fh_l0_20 + (-0.063388645648956299)*hfn_15;
    fh_l0_21 = -0.13454221189022064;
    fh_l0_21 = fh_l0_21 + (-0.53573060035705566)*hfn_0;
    fh_l0_21 = fh_l0_21 + (0.20153254270553589)*hfn_1;
    fh_l0_21 = fh_l0_21 + (0.31347671151161194)*hfn_2;
    fh_l0_21 = fh_l0_21 + (-0.21083404123783112)*hfn_3;
    fh_l0_21 = fh_l0_21 + (0.19919724762439728)*hfn_4;
    fh_l0_21 = fh_l0_21 + (-0.044521424919366837)*hfn_5;
    fh_l0_21 = fh_l0_21 + (-0.47340711951255798)*hfn_6;
    fh_l0_21 = fh_l0_21 + (-0.37194827198982239)*hfn_7;
    fh_l0_21 = fh_l0_21 + (0.30729001760482788)*hfn_8;
    fh_l0_21 = fh_l0_21 + (-0.090833507478237152)*hfn_9;
    fh_l0_21 = fh_l0_21 + (-0.020573491230607033)*hfn_10;
    fh_l0_21 = fh_l0_21 + (-0.12188670784235001)*hfn_11;
    fh_l0_21 = fh_l0_21 + (-0.12916690111160278)*hfn_12;
    fh_l0_21 = fh_l0_21 + (0.19111306965351105)*hfn_13;
    fh_l0_21 = fh_l0_21 + (-0.35240790247917175)*hfn_14;
    fh_l0_21 = fh_l0_21 + (0.076185286045074463)*hfn_15;
    fh_l0_22 = 0.30599150061607361;
    fh_l0_22 = fh_l0_22 + (0.16117089986801147)*hfn_0;
    fh_l0_22 = fh_l0_22 + (-0.16444617509841919)*hfn_1;
    fh_l0_22 = fh_l0_22 + (0.0043759085237979889)*hfn_2;
    fh_l0_22 = fh_l0_22 + (-0.26276075839996338)*hfn_3;
    fh_l0_22 = fh_l0_22 + (0.20152255892753601)*hfn_4;
    fh_l0_22 = fh_l0_22 + (-0.12172005325555801)*hfn_5;
    fh_l0_22 = fh_l0_22 + (-0.054369952529668808)*hfn_6;
    fh_l0_22 = fh_l0_22 + (0.066801995038986206)*hfn_7;
    fh_l0_22 = fh_l0_22 + (0.33694276213645935)*hfn_8;
    fh_l0_22 = fh_l0_22 + (0.12401348352432251)*hfn_9;
    fh_l0_22 = fh_l0_22 + (-0.22892343997955322)*hfn_10;
    fh_l0_22 = fh_l0_22 + (-0.09250892698764801)*hfn_11;
    fh_l0_22 = fh_l0_22 + (0.1753803938627243)*hfn_12;
    fh_l0_22 = fh_l0_22 + (-0.14132371544837952)*hfn_13;
    fh_l0_22 = fh_l0_22 + (0.085404619574546814)*hfn_14;
    fh_l0_22 = fh_l0_22 + (0.19319921731948853)*hfn_15;
    fh_l0_23 = -0.020487334579229355;
    fh_l0_23 = fh_l0_23 + (-0.038215089589357376)*hfn_0;
    fh_l0_23 = fh_l0_23 + (-0.011002341285347939)*hfn_1;
    fh_l0_23 = fh_l0_23 + (0.02192986011505127)*hfn_2;
    fh_l0_23 = fh_l0_23 + (0.19309374690055847)*hfn_3;
    fh_l0_23 = fh_l0_23 + (0.22282347083091736)*hfn_4;
    fh_l0_23 = fh_l0_23 + (0.036404136568307877)*hfn_5;
    fh_l0_23 = fh_l0_23 + (0.22887755930423737)*hfn_6;
    fh_l0_23 = fh_l0_23 + (0.0473332479596138)*hfn_7;
    fh_l0_23 = fh_l0_23 + (0.057273078709840775)*hfn_8;
    fh_l0_23 = fh_l0_23 + (-0.081092230975627899)*hfn_9;
    fh_l0_23 = fh_l0_23 + (-0.03485364094376564)*hfn_10;
    fh_l0_23 = fh_l0_23 + (0.32285246253013611)*hfn_11;
    fh_l0_23 = fh_l0_23 + (0.31605607271194458)*hfn_12;
    fh_l0_23 = fh_l0_23 + (-0.0096016982570290565)*hfn_13;
    fh_l0_23 = fh_l0_23 + (-0.032346673309803009)*hfn_14;
    fh_l0_23 = fh_l0_23 + (0.025786643847823143)*hfn_15;
    fh_l0_24 = -0.0012622162466868758;
    fh_l0_24 = fh_l0_24 + (0.11715155094861984)*hfn_0;
    fh_l0_24 = fh_l0_24 + (-0.046622782945632935)*hfn_1;
    fh_l0_24 = fh_l0_24 + (0.044980235397815704)*hfn_2;
    fh_l0_24 = fh_l0_24 + (-0.34870216250419617)*hfn_3;
    fh_l0_24 = fh_l0_24 + (-0.21173374354839325)*hfn_4;
    fh_l0_24 = fh_l0_24 + (-0.2657107412815094)*hfn_5;
    fh_l0_24 = fh_l0_24 + (0.16361527144908905)*hfn_6;
    fh_l0_24 = fh_l0_24 + (0.12474497407674789)*hfn_7;
    fh_l0_24 = fh_l0_24 + (0.098132386803627014)*hfn_8;
    fh_l0_24 = fh_l0_24 + (-0.0054375310428440571)*hfn_9;
    fh_l0_24 = fh_l0_24 + (0.17795704305171967)*hfn_10;
    fh_l0_24 = fh_l0_24 + (0.13185895979404449)*hfn_11;
    fh_l0_24 = fh_l0_24 + (0.14511796832084656)*hfn_12;
    fh_l0_24 = fh_l0_24 + (-0.32994318008422852)*hfn_13;
    fh_l0_24 = fh_l0_24 + (0.30142486095428467)*hfn_14;
    fh_l0_24 = fh_l0_24 + (-0.1140497550368309)*hfn_15;
    fh_l0_25 = -0.036067482084035873;
    fh_l0_25 = fh_l0_25 + (0.15157544612884521)*hfn_0;
    fh_l0_25 = fh_l0_25 + (-0.061743173748254776)*hfn_1;
    fh_l0_25 = fh_l0_25 + (-0.18753570318222046)*hfn_2;
    fh_l0_25 = fh_l0_25 + (0.20063933730125427)*hfn_3;
    fh_l0_25 = fh_l0_25 + (0.098777204751968384)*hfn_4;
    fh_l0_25 = fh_l0_25 + (-0.10620331019163132)*hfn_5;
    fh_l0_25 = fh_l0_25 + (-0.18655399978160858)*hfn_6;
    fh_l0_25 = fh_l0_25 + (-0.11287859082221985)*hfn_7;
    fh_l0_25 = fh_l0_25 + (0.020368035882711411)*hfn_8;
    fh_l0_25 = fh_l0_25 + (-0.043253429234027863)*hfn_9;
    fh_l0_25 = fh_l0_25 + (-0.055735800415277481)*hfn_10;
    fh_l0_25 = fh_l0_25 + (-0.059545502066612244)*hfn_11;
    fh_l0_25 = fh_l0_25 + (0.16515393555164337)*hfn_12;
    fh_l0_25 = fh_l0_25 + (0.18855229020118713)*hfn_13;
    fh_l0_25 = fh_l0_25 + (-0.076316200196743011)*hfn_14;
    fh_l0_25 = fh_l0_25 + (-0.12424810975790024)*hfn_15;
    fh_l0_26 = -0.13798804581165314;
    fh_l0_26 = fh_l0_26 + (-0.12429849803447723)*hfn_0;
    fh_l0_26 = fh_l0_26 + (0.06851467490196228)*hfn_1;
    fh_l0_26 = fh_l0_26 + (-0.20676915347576141)*hfn_2;
    fh_l0_26 = fh_l0_26 + (0.01702212356030941)*hfn_3;
    fh_l0_26 = fh_l0_26 + (0.34580391645431519)*hfn_4;
    fh_l0_26 = fh_l0_26 + (-0.1262933611869812)*hfn_5;
    fh_l0_26 = fh_l0_26 + (-0.0070686270482838154)*hfn_6;
    fh_l0_26 = fh_l0_26 + (0.36909425258636475)*hfn_7;
    fh_l0_26 = fh_l0_26 + (0.18325608968734741)*hfn_8;
    fh_l0_26 = fh_l0_26 + (-0.038770157843828201)*hfn_9;
    fh_l0_26 = fh_l0_26 + (0.17652302980422974)*hfn_10;
    fh_l0_26 = fh_l0_26 + (-0.49567452073097229)*hfn_11;
    fh_l0_26 = fh_l0_26 + (-0.16491325199604034)*hfn_12;
    fh_l0_26 = fh_l0_26 + (0.21676073968410492)*hfn_13;
    fh_l0_26 = fh_l0_26 + (0.20747572183609009)*hfn_14;
    fh_l0_26 = fh_l0_26 + (0.054347202181816101)*hfn_15;
    fh_l0_27 = 0.029186910018324852;
    fh_l0_27 = fh_l0_27 + (-0.0088371774181723595)*hfn_0;
    fh_l0_27 = fh_l0_27 + (-0.18732933700084686)*hfn_1;
    fh_l0_27 = fh_l0_27 + (-0.097651027143001556)*hfn_2;
    fh_l0_27 = fh_l0_27 + (-0.19882941246032715)*hfn_3;
    fh_l0_27 = fh_l0_27 + (0.090302012860774994)*hfn_4;
    fh_l0_27 = fh_l0_27 + (-0.25564095377922058)*hfn_5;
    fh_l0_27 = fh_l0_27 + (0.19130180776119232)*hfn_6;
    fh_l0_27 = fh_l0_27 + (-0.3758181631565094)*hfn_7;
    fh_l0_27 = fh_l0_27 + (-0.089054621756076813)*hfn_8;
    fh_l0_27 = fh_l0_27 + (0.024731611832976341)*hfn_9;
    fh_l0_27 = fh_l0_27 + (0.043032187968492508)*hfn_10;
    fh_l0_27 = fh_l0_27 + (0.30661273002624512)*hfn_11;
    fh_l0_27 = fh_l0_27 + (-0.3446333110332489)*hfn_12;
    fh_l0_27 = fh_l0_27 + (0.0028187658172100782)*hfn_13;
    fh_l0_27 = fh_l0_27 + (0.039055712521076202)*hfn_14;
    fh_l0_27 = fh_l0_27 + (0.30119404196739197)*hfn_15;
    fh_l0_28 = -0.074226640164852142;
    fh_l0_28 = fh_l0_28 + (-0.29203900694847107)*hfn_0;
    fh_l0_28 = fh_l0_28 + (-0.28060713410377502)*hfn_1;
    fh_l0_28 = fh_l0_28 + (-0.014126398600637913)*hfn_2;
    fh_l0_28 = fh_l0_28 + (0.35536369681358337)*hfn_3;
    fh_l0_28 = fh_l0_28 + (0.39229598641395569)*hfn_4;
    fh_l0_28 = fh_l0_28 + (0.34887674450874329)*hfn_5;
    fh_l0_28 = fh_l0_28 + (0.052771445363759995)*hfn_6;
    fh_l0_28 = fh_l0_28 + (-0.15580601990222931)*hfn_7;
    fh_l0_28 = fh_l0_28 + (0.088320977985858917)*hfn_8;
    fh_l0_28 = fh_l0_28 + (-0.15565942227840424)*hfn_9;
    fh_l0_28 = fh_l0_28 + (0.10675862431526184)*hfn_10;
    fh_l0_28 = fh_l0_28 + (-0.11914712190628052)*hfn_11;
    fh_l0_28 = fh_l0_28 + (0.15580473840236664)*hfn_12;
    fh_l0_28 = fh_l0_28 + (-0.13729226589202881)*hfn_13;
    fh_l0_28 = fh_l0_28 + (-0.10581056028604507)*hfn_14;
    fh_l0_28 = fh_l0_28 + (-0.28018677234649658)*hfn_15;
    fh_l0_29 = 0.071953289210796356;
    fh_l0_29 = fh_l0_29 + (0.15936248004436493)*hfn_0;
    fh_l0_29 = fh_l0_29 + (-0.019244398921728134)*hfn_1;
    fh_l0_29 = fh_l0_29 + (0.10646027326583862)*hfn_2;
    fh_l0_29 = fh_l0_29 + (-0.012875920161604881)*hfn_3;
    fh_l0_29 = fh_l0_29 + (0.23248292505741119)*hfn_4;
    fh_l0_29 = fh_l0_29 + (0.27588850259780884)*hfn_5;
    fh_l0_29 = fh_l0_29 + (0.095062002539634705)*hfn_6;
    fh_l0_29 = fh_l0_29 + (-0.12013509124517441)*hfn_7;
    fh_l0_29 = fh_l0_29 + (-0.16106213629245758)*hfn_8;
    fh_l0_29 = fh_l0_29 + (-0.21198497712612152)*hfn_9;
    fh_l0_29 = fh_l0_29 + (-0.029533298686146736)*hfn_10;
    fh_l0_29 = fh_l0_29 + (0.028303660452365875)*hfn_11;
    fh_l0_29 = fh_l0_29 + (0.084225744009017944)*hfn_12;
    fh_l0_29 = fh_l0_29 + (-0.081605605781078339)*hfn_13;
    fh_l0_29 = fh_l0_29 + (-0.14819033443927765)*hfn_14;
    fh_l0_29 = fh_l0_29 + (0.25116395950317383)*hfn_15;
    fh_l0_30 = -0.10688064992427826;
    fh_l0_30 = fh_l0_30 + (0.15326930582523346)*hfn_0;
    fh_l0_30 = fh_l0_30 + (0.12848632037639618)*hfn_1;
    fh_l0_30 = fh_l0_30 + (-0.11008863151073456)*hfn_2;
    fh_l0_30 = fh_l0_30 + (0.015798766165971756)*hfn_3;
    fh_l0_30 = fh_l0_30 + (-0.10883151739835739)*hfn_4;
    fh_l0_30 = fh_l0_30 + (0.077495142817497253)*hfn_5;
    fh_l0_30 = fh_l0_30 + (0.085230976343154907)*hfn_6;
    fh_l0_30 = fh_l0_30 + (0.028184050694108009)*hfn_7;
    fh_l0_30 = fh_l0_30 + (-0.20550280809402466)*hfn_8;
    fh_l0_30 = fh_l0_30 + (-0.037130996584892273)*hfn_9;
    fh_l0_30 = fh_l0_30 + (-0.02018902450799942)*hfn_10;
    fh_l0_30 = fh_l0_30 + (-0.19618099927902222)*hfn_11;
    fh_l0_30 = fh_l0_30 + (-0.10549940913915634)*hfn_12;
    fh_l0_30 = fh_l0_30 + (0.12143947184085846)*hfn_13;
    fh_l0_30 = fh_l0_30 + (-0.12657518684864044)*hfn_14;
    fh_l0_30 = fh_l0_30 + (-0.12689238786697388)*hfn_15;
    fh_l0_31 = -0.12395009398460388;
    fh_l0_31 = fh_l0_31 + (0.0061621330678462982)*hfn_0;
    fh_l0_31 = fh_l0_31 + (-0.31833142042160034)*hfn_1;
    fh_l0_31 = fh_l0_31 + (-0.17080473899841309)*hfn_2;
    fh_l0_31 = fh_l0_31 + (0.30163830518722534)*hfn_3;
    fh_l0_31 = fh_l0_31 + (0.018930159509181976)*hfn_4;
    fh_l0_31 = fh_l0_31 + (0.19614472985267639)*hfn_5;
    fh_l0_31 = fh_l0_31 + (0.12070716917514801)*hfn_6;
    fh_l0_31 = fh_l0_31 + (0.027062134817242622)*hfn_7;
    fh_l0_31 = fh_l0_31 + (-0.027034705504775047)*hfn_8;
    fh_l0_31 = fh_l0_31 + (-0.21911421418190002)*hfn_9;
    fh_l0_31 = fh_l0_31 + (-0.074959732592105865)*hfn_10;
    fh_l0_31 = fh_l0_31 + (-0.17610973119735718)*hfn_11;
    fh_l0_31 = fh_l0_31 + (0.18067331612110138)*hfn_12;
    fh_l0_31 = fh_l0_31 + (-0.20005118846893311)*hfn_13;
    fh_l0_31 = fh_l0_31 + (0.081776320934295654)*hfn_14;
    fh_l0_31 = fh_l0_31 + (-0.23276039958000183)*hfn_15;
    fh_l0_32 = -0.030708659440279007;
    fh_l0_32 = fh_l0_32 + (-0.10980351269245148)*hfn_0;
    fh_l0_32 = fh_l0_32 + (0.13224966824054718)*hfn_1;
    fh_l0_32 = fh_l0_32 + (0.2853114902973175)*hfn_2;
    fh_l0_32 = fh_l0_32 + (-0.081998936831951141)*hfn_3;
    fh_l0_32 = fh_l0_32 + (-0.36306855082511902)*hfn_4;
    fh_l0_32 = fh_l0_32 + (-0.015004461631178856)*hfn_5;
    fh_l0_32 = fh_l0_32 + (-0.07786165177822113)*hfn_6;
    fh_l0_32 = fh_l0_32 + (-0.070220246911048889)*hfn_7;
    fh_l0_32 = fh_l0_32 + (0.08710932731628418)*hfn_8;
    fh_l0_32 = fh_l0_32 + (-0.25383132696151733)*hfn_9;
    fh_l0_32 = fh_l0_32 + (-0.027083678171038628)*hfn_10;
    fh_l0_32 = fh_l0_32 + (-0.33801504969596863)*hfn_11;
    fh_l0_32 = fh_l0_32 + (0.063407950103282928)*hfn_12;
    fh_l0_32 = fh_l0_32 + (0.23386538028717041)*hfn_13;
    fh_l0_32 = fh_l0_32 + (0.12684625387191772)*hfn_14;
    fh_l0_32 = fh_l0_32 + (0.04273015633225441)*hfn_15;
    fh_l0_33 = 0.051780670881271362;
    fh_l0_33 = fh_l0_33 + (-0.11058831214904785)*hfn_0;
    fh_l0_33 = fh_l0_33 + (0.064980782568454742)*hfn_1;
    fh_l0_33 = fh_l0_33 + (-0.066808499395847321)*hfn_2;
    fh_l0_33 = fh_l0_33 + (-0.18984898924827576)*hfn_3;
    fh_l0_33 = fh_l0_33 + (0.05017591267824173)*hfn_4;
    fh_l0_33 = fh_l0_33 + (0.17620612680912018)*hfn_5;
    fh_l0_33 = fh_l0_33 + (-0.018807616084814072)*hfn_6;
    fh_l0_33 = fh_l0_33 + (0.088600717484951019)*hfn_7;
    fh_l0_33 = fh_l0_33 + (0.048246689140796661)*hfn_8;
    fh_l0_33 = fh_l0_33 + (-0.066750518977642059)*hfn_9;
    fh_l0_33 = fh_l0_33 + (0.26057034730911255)*hfn_10;
    fh_l0_33 = fh_l0_33 + (-0.18892143666744232)*hfn_11;
    fh_l0_33 = fh_l0_33 + (-0.30977392196655273)*hfn_12;
    fh_l0_33 = fh_l0_33 + (-0.016285218298435211)*hfn_13;
    fh_l0_33 = fh_l0_33 + (-0.084281787276268005)*hfn_14;
    fh_l0_33 = fh_l0_33 + (0.21298256516456604)*hfn_15;
    fh_l0_34 = -0.020427772775292397;
    fh_l0_34 = fh_l0_34 + (-0.14090351760387421)*hfn_0;
    fh_l0_34 = fh_l0_34 + (-0.28443384170532227)*hfn_1;
    fh_l0_34 = fh_l0_34 + (-0.22325089573860168)*hfn_2;
    fh_l0_34 = fh_l0_34 + (0.24504047632217407)*hfn_3;
    fh_l0_34 = fh_l0_34 + (-0.09647301584482193)*hfn_4;
    fh_l0_34 = fh_l0_34 + (-0.20557346940040588)*hfn_5;
    fh_l0_34 = fh_l0_34 + (0.060426883399486542)*hfn_6;
    fh_l0_34 = fh_l0_34 + (0.017655305564403534)*hfn_7;
    fh_l0_34 = fh_l0_34 + (0.071463212370872498)*hfn_8;
    fh_l0_34 = fh_l0_34 + (-0.20424282550811768)*hfn_9;
    fh_l0_34 = fh_l0_34 + (-0.21446682512760162)*hfn_10;
    fh_l0_34 = fh_l0_34 + (0.33041003346443176)*hfn_11;
    fh_l0_34 = fh_l0_34 + (0.18721403181552887)*hfn_12;
    fh_l0_34 = fh_l0_34 + (0.00047669786727055907)*hfn_13;
    fh_l0_34 = fh_l0_34 + (0.077378340065479279)*hfn_14;
    fh_l0_34 = fh_l0_34 + (-0.21342919766902924)*hfn_15;
    fh_l0_35 = 0.089878037571907043;
    fh_l0_35 = fh_l0_35 + (-0.068358428776264191)*hfn_0;
    fh_l0_35 = fh_l0_35 + (-0.098056010901927948)*hfn_1;
    fh_l0_35 = fh_l0_35 + (-0.11875707656145096)*hfn_2;
    fh_l0_35 = fh_l0_35 + (0.14677003026008606)*hfn_3;
    fh_l0_35 = fh_l0_35 + (0.13256397843360901)*hfn_4;
    fh_l0_35 = fh_l0_35 + (-0.013060523197054863)*hfn_5;
    fh_l0_35 = fh_l0_35 + (-0.39039859175682068)*hfn_6;
    fh_l0_35 = fh_l0_35 + (0.088249199092388153)*hfn_7;
    fh_l0_35 = fh_l0_35 + (0.4324699342250824)*hfn_8;
    fh_l0_35 = fh_l0_35 + (0.21988116204738617)*hfn_9;
    fh_l0_35 = fh_l0_35 + (0.079646587371826172)*hfn_10;
    fh_l0_35 = fh_l0_35 + (0.043588463217020035)*hfn_11;
    fh_l0_35 = fh_l0_35 + (0.1648000180721283)*hfn_12;
    fh_l0_35 = fh_l0_35 + (0.00073734845500439405)*hfn_13;
    fh_l0_35 = fh_l0_35 + (-0.057256150990724564)*hfn_14;
    fh_l0_35 = fh_l0_35 + (-0.033818069845438004)*hfn_15;
    fh_l0_36 = 0.083793535828590393;
    fh_l0_36 = fh_l0_36 + (0.1545039564371109)*hfn_0;
    fh_l0_36 = fh_l0_36 + (-0.050353109836578369)*hfn_1;
    fh_l0_36 = fh_l0_36 + (-0.11525614559650421)*hfn_2;
    fh_l0_36 = fh_l0_36 + (-0.34825846552848816)*hfn_3;
    fh_l0_36 = fh_l0_36 + (0.11339679360389709)*hfn_4;
    fh_l0_36 = fh_l0_36 + (-0.070938020944595337)*hfn_5;
    fh_l0_36 = fh_l0_36 + (-0.34857499599456787)*hfn_6;
    fh_l0_36 = fh_l0_36 + (0.17692345380783081)*hfn_7;
    fh_l0_36 = fh_l0_36 + (0.36129644513130188)*hfn_8;
    fh_l0_36 = fh_l0_36 + (0.24264855682849884)*hfn_9;
    fh_l0_36 = fh_l0_36 + (0.04019593819975853)*hfn_10;
    fh_l0_36 = fh_l0_36 + (0.0035506119020283222)*hfn_11;
    fh_l0_36 = fh_l0_36 + (0.18207630515098572)*hfn_12;
    fh_l0_36 = fh_l0_36 + (0.065903022885322571)*hfn_13;
    fh_l0_36 = fh_l0_36 + (0.2545856237411499)*hfn_14;
    fh_l0_36 = fh_l0_36 + (0.26477548480033875)*hfn_15;
    fh_l0_37 = 0.23565658926963806;
    fh_l0_37 = fh_l0_37 + (-0.24781510233879089)*hfn_0;
    fh_l0_37 = fh_l0_37 + (-0.29076537489891052)*hfn_1;
    fh_l0_37 = fh_l0_37 + (-0.14305117726325989)*hfn_2;
    fh_l0_37 = fh_l0_37 + (-0.07377789169549942)*hfn_3;
    fh_l0_37 = fh_l0_37 + (-0.31978431344032288)*hfn_4;
    fh_l0_37 = fh_l0_37 + (0.15402008593082428)*hfn_5;
    fh_l0_37 = fh_l0_37 + (-0.010380059480667114)*hfn_6;
    fh_l0_37 = fh_l0_37 + (0.0068317325785756111)*hfn_7;
    fh_l0_37 = fh_l0_37 + (-0.24970979988574982)*hfn_8;
    fh_l0_37 = fh_l0_37 + (0.091983899474143982)*hfn_9;
    fh_l0_37 = fh_l0_37 + (0.19948127865791321)*hfn_10;
    fh_l0_37 = fh_l0_37 + (-0.2579764723777771)*hfn_11;
    fh_l0_37 = fh_l0_37 + (-0.049333542585372925)*hfn_12;
    fh_l0_37 = fh_l0_37 + (0.00066726142540574074)*hfn_13;
    fh_l0_37 = fh_l0_37 + (0.076142154633998871)*hfn_14;
    fh_l0_37 = fh_l0_37 + (-0.22497604787349701)*hfn_15;
    fh_l0_38 = 0.15124295651912689;
    fh_l0_38 = fh_l0_38 + (-0.083509951829910278)*hfn_0;
    fh_l0_38 = fh_l0_38 + (-0.15783560276031494)*hfn_1;
    fh_l0_38 = fh_l0_38 + (0.322816401720047)*hfn_2;
    fh_l0_38 = fh_l0_38 + (-0.24989357590675354)*hfn_3;
    fh_l0_38 = fh_l0_38 + (-0.027773985639214516)*hfn_4;
    fh_l0_38 = fh_l0_38 + (0.10097657144069672)*hfn_5;
    fh_l0_38 = fh_l0_38 + (0.2379014641046524)*hfn_6;
    fh_l0_38 = fh_l0_38 + (-0.092865496873855591)*hfn_7;
    fh_l0_38 = fh_l0_38 + (0.017817327752709389)*hfn_8;
    fh_l0_38 = fh_l0_38 + (0.086467467248439789)*hfn_9;
    fh_l0_38 = fh_l0_38 + (-0.019894853234291077)*hfn_10;
    fh_l0_38 = fh_l0_38 + (0.11315204948186874)*hfn_11;
    fh_l0_38 = fh_l0_38 + (0.091483481228351593)*hfn_12;
    fh_l0_38 = fh_l0_38 + (0.24899157881736755)*hfn_13;
    fh_l0_38 = fh_l0_38 + (0.10692688077688217)*hfn_14;
    fh_l0_38 = fh_l0_38 + (0.22759178280830383)*hfn_15;
    fh_l0_39 = -0.11961124092340469;
    fh_l0_39 = fh_l0_39 + (0.068325355648994446)*hfn_0;
    fh_l0_39 = fh_l0_39 + (-0.23254126310348511)*hfn_1;
    fh_l0_39 = fh_l0_39 + (-0.11201823502779007)*hfn_2;
    fh_l0_39 = fh_l0_39 + (0.088350683450698853)*hfn_3;
    fh_l0_39 = fh_l0_39 + (-0.15644806623458862)*hfn_4;
    fh_l0_39 = fh_l0_39 + (0.21028429269790649)*hfn_5;
    fh_l0_39 = fh_l0_39 + (0.16476547718048096)*hfn_6;
    fh_l0_39 = fh_l0_39 + (-0.16321338713169098)*hfn_7;
    fh_l0_39 = fh_l0_39 + (-0.14452940225601196)*hfn_8;
    fh_l0_39 = fh_l0_39 + (0.022721970453858376)*hfn_9;
    fh_l0_39 = fh_l0_39 + (-0.03327314555644989)*hfn_10;
    fh_l0_39 = fh_l0_39 + (-0.19530703127384186)*hfn_11;
    fh_l0_39 = fh_l0_39 + (-0.039403226226568222)*hfn_12;
    fh_l0_39 = fh_l0_39 + (0.061387207359075546)*hfn_13;
    fh_l0_39 = fh_l0_39 + (-0.20648133754730225)*hfn_14;
    fh_l0_39 = fh_l0_39 + (-0.17196862399578094)*hfn_15;
    fh_l0_40 = -0.063736617565155029;
    fh_l0_40 = fh_l0_40 + (-0.11621887981891632)*hfn_0;
    fh_l0_40 = fh_l0_40 + (0.025595379993319511)*hfn_1;
    fh_l0_40 = fh_l0_40 + (0.24732702970504761)*hfn_2;
    fh_l0_40 = fh_l0_40 + (0.081101343035697937)*hfn_3;
    fh_l0_40 = fh_l0_40 + (-0.10181206464767456)*hfn_4;
    fh_l0_40 = fh_l0_40 + (-0.051640614867210388)*hfn_5;
    fh_l0_40 = fh_l0_40 + (-0.023443982005119324)*hfn_6;
    fh_l0_40 = fh_l0_40 + (-0.14019210636615753)*hfn_7;
    fh_l0_40 = fh_l0_40 + (-0.16537125408649445)*hfn_8;
    fh_l0_40 = fh_l0_40 + (0.22433808445930481)*hfn_9;
    fh_l0_40 = fh_l0_40 + (-0.040410470217466354)*hfn_10;
    fh_l0_40 = fh_l0_40 + (0.074979670345783234)*hfn_11;
    fh_l0_40 = fh_l0_40 + (0.28922170400619507)*hfn_12;
    fh_l0_40 = fh_l0_40 + (0.41495722532272339)*hfn_13;
    fh_l0_40 = fh_l0_40 + (0.012637057341635227)*hfn_14;
    fh_l0_40 = fh_l0_40 + (-0.3087804913520813)*hfn_15;
    fh_l0_41 = 0.10467510670423508;
    fh_l0_41 = fh_l0_41 + (-0.22501030564308167)*hfn_0;
    fh_l0_41 = fh_l0_41 + (0.11104606091976166)*hfn_1;
    fh_l0_41 = fh_l0_41 + (-0.0882086381316185)*hfn_2;
    fh_l0_41 = fh_l0_41 + (0.12070862948894501)*hfn_3;
    fh_l0_41 = fh_l0_41 + (0.38454023003578186)*hfn_4;
    fh_l0_41 = fh_l0_41 + (-0.224076047539711)*hfn_5;
    fh_l0_41 = fh_l0_41 + (0.35510861873626709)*hfn_6;
    fh_l0_41 = fh_l0_41 + (0.035216331481933594)*hfn_7;
    fh_l0_41 = fh_l0_41 + (-0.22356748580932617)*hfn_8;
    fh_l0_41 = fh_l0_41 + (0.10916812717914581)*hfn_9;
    fh_l0_41 = fh_l0_41 + (0.16075229644775391)*hfn_10;
    fh_l0_41 = fh_l0_41 + (0.21520690619945526)*hfn_11;
    fh_l0_41 = fh_l0_41 + (0.12892252206802368)*hfn_12;
    fh_l0_41 = fh_l0_41 + (0.090921215713024139)*hfn_13;
    fh_l0_41 = fh_l0_41 + (-0.016342539340257645)*hfn_14;
    fh_l0_41 = fh_l0_41 + (-0.27012550830841064)*hfn_15;
    fh_l0_42 = -0.16632993519306183;
    fh_l0_42 = fh_l0_42 + (-0.051532186567783356)*hfn_0;
    fh_l0_42 = fh_l0_42 + (-0.047869503498077393)*hfn_1;
    fh_l0_42 = fh_l0_42 + (0.08040764182806015)*hfn_2;
    fh_l0_42 = fh_l0_42 + (0.21816883981227875)*hfn_3;
    fh_l0_42 = fh_l0_42 + (-0.20300985872745514)*hfn_4;
    fh_l0_42 = fh_l0_42 + (0.25902798771858215)*hfn_5;
    fh_l0_42 = fh_l0_42 + (0.20993329584598541)*hfn_6;
    fh_l0_42 = fh_l0_42 + (-0.13852725923061371)*hfn_7;
    fh_l0_42 = fh_l0_42 + (0.066489942371845245)*hfn_8;
    fh_l0_42 = fh_l0_42 + (-0.23436298966407776)*hfn_9;
    fh_l0_42 = fh_l0_42 + (0.0089317187666893005)*hfn_10;
    fh_l0_42 = fh_l0_42 + (-0.033210091292858124)*hfn_11;
    fh_l0_42 = fh_l0_42 + (0.12708787620067596)*hfn_12;
    fh_l0_42 = fh_l0_42 + (-0.011290312744677067)*hfn_13;
    fh_l0_42 = fh_l0_42 + (0.17086499929428101)*hfn_14;
    fh_l0_42 = fh_l0_42 + (0.019641038030385971)*hfn_15;
    fh_l0_43 = -0.044568821787834167;
    fh_l0_43 = fh_l0_43 + (-0.16982401907444)*hfn_0;
    fh_l0_43 = fh_l0_43 + (-0.15602116286754608)*hfn_1;
    fh_l0_43 = fh_l0_43 + (0.074728608131408691)*hfn_2;
    fh_l0_43 = fh_l0_43 + (0.089383229613304138)*hfn_3;
    fh_l0_43 = fh_l0_43 + (-0.22777344286441803)*hfn_4;
    fh_l0_43 = fh_l0_43 + (0.064863532781600952)*hfn_5;
    fh_l0_43 = fh_l0_43 + (-0.17307271063327789)*hfn_6;
    fh_l0_43 = fh_l0_43 + (0.13533379137516022)*hfn_7;
    fh_l0_43 = fh_l0_43 + (-0.18512339890003204)*hfn_8;
    fh_l0_43 = fh_l0_43 + (-0.16504475474357605)*hfn_9;
    fh_l0_43 = fh_l0_43 + (0.056088201701641083)*hfn_10;
    fh_l0_43 = fh_l0_43 + (-0.37555339932441711)*hfn_11;
    fh_l0_43 = fh_l0_43 + (-0.0081459386274218559)*hfn_12;
    fh_l0_43 = fh_l0_43 + (-0.10800017416477203)*hfn_13;
    fh_l0_43 = fh_l0_43 + (-0.13508303463459015)*hfn_14;
    fh_l0_43 = fh_l0_43 + (-0.2006000429391861)*hfn_15;
    fh_l0_44 = -0.022830339148640633;
    fh_l0_44 = fh_l0_44 + (0.0034814868122339249)*hfn_0;
    fh_l0_44 = fh_l0_44 + (0.26134765148162842)*hfn_1;
    fh_l0_44 = fh_l0_44 + (-0.14900730550289154)*hfn_2;
    fh_l0_44 = fh_l0_44 + (-0.22646701335906982)*hfn_3;
    fh_l0_44 = fh_l0_44 + (-0.21350482106208801)*hfn_4;
    fh_l0_44 = fh_l0_44 + (-0.054195314645767212)*hfn_5;
    fh_l0_44 = fh_l0_44 + (-0.38631820678710938)*hfn_6;
    fh_l0_44 = fh_l0_44 + (0.034430436789989471)*hfn_7;
    fh_l0_44 = fh_l0_44 + (0.14538697898387909)*hfn_8;
    fh_l0_44 = fh_l0_44 + (0.086813628673553467)*hfn_9;
    fh_l0_44 = fh_l0_44 + (0.068824872374534607)*hfn_10;
    fh_l0_44 = fh_l0_44 + (0.12367285788059235)*hfn_11;
    fh_l0_44 = fh_l0_44 + (-0.38250917196273804)*hfn_12;
    fh_l0_44 = fh_l0_44 + (0.09165915846824646)*hfn_13;
    fh_l0_44 = fh_l0_44 + (0.27341333031654358)*hfn_14;
    fh_l0_44 = fh_l0_44 + (0.17479774355888367)*hfn_15;
    fh_l0_45 = 0.046569406986236572;
    fh_l0_45 = fh_l0_45 + (0.24307061731815338)*hfn_0;
    fh_l0_45 = fh_l0_45 + (0.098163574934005737)*hfn_1;
    fh_l0_45 = fh_l0_45 + (-0.28234115242958069)*hfn_2;
    fh_l0_45 = fh_l0_45 + (-0.14037859439849854)*hfn_3;
    fh_l0_45 = fh_l0_45 + (-0.082012124359607697)*hfn_4;
    fh_l0_45 = fh_l0_45 + (-0.045317534357309341)*hfn_5;
    fh_l0_45 = fh_l0_45 + (0.034537713974714279)*hfn_6;
    fh_l0_45 = fh_l0_45 + (0.33710664510726929)*hfn_7;
    fh_l0_45 = fh_l0_45 + (-0.34331223368644714)*hfn_8;
    fh_l0_45 = fh_l0_45 + (-0.21613399684429169)*hfn_9;
    fh_l0_45 = fh_l0_45 + (0.2190057635307312)*hfn_10;
    fh_l0_45 = fh_l0_45 + (0.13821624219417572)*hfn_11;
    fh_l0_45 = fh_l0_45 + (0.28575354814529419)*hfn_12;
    fh_l0_45 = fh_l0_45 + (-0.18783186376094818)*hfn_13;
    fh_l0_45 = fh_l0_45 + (0.44994288682937622)*hfn_14;
    fh_l0_45 = fh_l0_45 + (0.20185372233390808)*hfn_15;
    fh_l0_46 = 0.16948392987251282;
    fh_l0_46 = fh_l0_46 + (0.39659979939460754)*hfn_0;
    fh_l0_46 = fh_l0_46 + (0.067510522902011871)*hfn_1;
    fh_l0_46 = fh_l0_46 + (-0.11704623699188232)*hfn_2;
    fh_l0_46 = fh_l0_46 + (-0.173845574259758)*hfn_3;
    fh_l0_46 = fh_l0_46 + (-0.25304773449897766)*hfn_4;
    fh_l0_46 = fh_l0_46 + (0.20717272162437439)*hfn_5;
    fh_l0_46 = fh_l0_46 + (-0.012136604636907578)*hfn_6;
    fh_l0_46 = fh_l0_46 + (-0.31918489933013916)*hfn_7;
    fh_l0_46 = fh_l0_46 + (-0.091817609965801239)*hfn_8;
    fh_l0_46 = fh_l0_46 + (0.21356873214244843)*hfn_9;
    fh_l0_46 = fh_l0_46 + (0.11158429831266403)*hfn_10;
    fh_l0_46 = fh_l0_46 + (-0.1073094978928566)*hfn_11;
    fh_l0_46 = fh_l0_46 + (0.041335839778184891)*hfn_12;
    fh_l0_46 = fh_l0_46 + (0.34837371110916138)*hfn_13;
    fh_l0_46 = fh_l0_46 + (-0.11655368655920029)*hfn_14;
    fh_l0_46 = fh_l0_46 + (-0.42833790183067322)*hfn_15;
    fh_l0_47 = 0.033275943249464035;
    fh_l0_47 = fh_l0_47 + (-0.25822004675865173)*hfn_0;
    fh_l0_47 = fh_l0_47 + (0.050687603652477264)*hfn_1;
    fh_l0_47 = fh_l0_47 + (-0.092885673046112061)*hfn_2;
    fh_l0_47 = fh_l0_47 + (0.062378719449043274)*hfn_3;
    fh_l0_47 = fh_l0_47 + (0.2765268087387085)*hfn_4;
    fh_l0_47 = fh_l0_47 + (-0.49958601593971252)*hfn_5;
    fh_l0_47 = fh_l0_47 + (-0.22413797676563263)*hfn_6;
    fh_l0_47 = fh_l0_47 + (0.24046625196933746)*hfn_7;
    fh_l0_47 = fh_l0_47 + (0.10270712524652481)*hfn_8;
    fh_l0_47 = fh_l0_47 + (-0.036466993391513824)*hfn_9;
    fh_l0_47 = fh_l0_47 + (0.082122847437858582)*hfn_10;
    fh_l0_47 = fh_l0_47 + (0.12111236155033112)*hfn_11;
    fh_l0_47 = fh_l0_47 + (-0.17563268542289734)*hfn_12;
    fh_l0_47 = fh_l0_47 + (0.17189939320087433)*hfn_13;
    fh_l0_47 = fh_l0_47 + (0.25331756472587585)*hfn_14;
    fh_l0_47 = fh_l0_47 + (-0.18874363601207733)*hfn_15;
    fh_l0_48 = 0.25835010409355164;
    fh_l0_48 = fh_l0_48 + (0.11054693162441254)*hfn_0;
    fh_l0_48 = fh_l0_48 + (0.015159067697823048)*hfn_1;
    fh_l0_48 = fh_l0_48 + (0.030073897913098335)*hfn_2;
    fh_l0_48 = fh_l0_48 + (-0.33897677063941956)*hfn_3;
    fh_l0_48 = fh_l0_48 + (0.026941794902086258)*hfn_4;
    fh_l0_48 = fh_l0_48 + (-0.32762128114700317)*hfn_5;
    fh_l0_48 = fh_l0_48 + (0.21383762359619141)*hfn_6;
    fh_l0_48 = fh_l0_48 + (0.17469103634357452)*hfn_7;
    fh_l0_48 = fh_l0_48 + (-0.076948374509811401)*hfn_8;
    fh_l0_48 = fh_l0_48 + (0.34434384107589722)*hfn_9;
    fh_l0_48 = fh_l0_48 + (0.049747440963983536)*hfn_10;
    fh_l0_48 = fh_l0_48 + (0.072717659175395966)*hfn_11;
    fh_l0_48 = fh_l0_48 + (0.1543881893157959)*hfn_12;
    fh_l0_48 = fh_l0_48 + (0.29463031888008118)*hfn_13;
    fh_l0_48 = fh_l0_48 + (-0.032168097794055939)*hfn_14;
    fh_l0_48 = fh_l0_48 + (-0.077368013560771942)*hfn_15;
    fh_l0_49 = -0.1571061760187149;
    fh_l0_49 = fh_l0_49 + (0.10177092254161835)*hfn_0;
    fh_l0_49 = fh_l0_49 + (0.084817387163639069)*hfn_1;
    fh_l0_49 = fh_l0_49 + (0.25677889585494995)*hfn_2;
    fh_l0_49 = fh_l0_49 + (0.22350317239761353)*hfn_3;
    fh_l0_49 = fh_l0_49 + (0.016857268288731575)*hfn_4;
    fh_l0_49 = fh_l0_49 + (-0.18302300572395325)*hfn_5;
    fh_l0_49 = fh_l0_49 + (-0.36708816885948181)*hfn_6;
    fh_l0_49 = fh_l0_49 + (-0.42158409953117371)*hfn_7;
    fh_l0_49 = fh_l0_49 + (0.099811568856239319)*hfn_8;
    fh_l0_49 = fh_l0_49 + (0.072411395609378815)*hfn_9;
    fh_l0_49 = fh_l0_49 + (-0.021915271878242493)*hfn_10;
    fh_l0_49 = fh_l0_49 + (-0.022016365081071854)*hfn_11;
    fh_l0_49 = fh_l0_49 + (-0.14642585813999176)*hfn_12;
    fh_l0_49 = fh_l0_49 + (0.11115819215774536)*hfn_13;
    fh_l0_49 = fh_l0_49 + (-0.38741886615753174)*hfn_14;
    fh_l0_49 = fh_l0_49 + (0.44430169463157654)*hfn_15;
    fh_l0_50 = -0.23784369230270386;
    fh_l0_50 = fh_l0_50 + (-0.31979173421859741)*hfn_0;
    fh_l0_50 = fh_l0_50 + (-0.14276511967182159)*hfn_1;
    fh_l0_50 = fh_l0_50 + (-0.33204606175422668)*hfn_2;
    fh_l0_50 = fh_l0_50 + (0.069537825882434845)*hfn_3;
    fh_l0_50 = fh_l0_50 + (-0.0092526031658053398)*hfn_4;
    fh_l0_50 = fh_l0_50 + (0.048456918448209763)*hfn_5;
    fh_l0_50 = fh_l0_50 + (0.33329159021377563)*hfn_6;
    fh_l0_50 = fh_l0_50 + (0.38186001777648926)*hfn_7;
    fh_l0_50 = fh_l0_50 + (0.2200518399477005)*hfn_8;
    fh_l0_50 = fh_l0_50 + (0.11858209222555161)*hfn_9;
    fh_l0_50 = fh_l0_50 + (0.043366838246583939)*hfn_10;
    fh_l0_50 = fh_l0_50 + (0.16353496909141541)*hfn_11;
    fh_l0_50 = fh_l0_50 + (0.31594908237457275)*hfn_12;
    fh_l0_50 = fh_l0_50 + (0.083259224891662598)*hfn_13;
    fh_l0_50 = fh_l0_50 + (0.13796435296535492)*hfn_14;
    fh_l0_50 = fh_l0_50 + (-0.16738681495189667)*hfn_15;
    fh_l0_51 = 0.077226147055625916;
    fh_l0_51 = fh_l0_51 + (0.11119347810745239)*hfn_0;
    fh_l0_51 = fh_l0_51 + (-0.054346855729818344)*hfn_1;
    fh_l0_51 = fh_l0_51 + (0.0075581450946629047)*hfn_2;
    fh_l0_51 = fh_l0_51 + (0.24724820256233215)*hfn_3;
    fh_l0_51 = fh_l0_51 + (-0.034785643219947815)*hfn_4;
    fh_l0_51 = fh_l0_51 + (-0.29766461253166199)*hfn_5;
    fh_l0_51 = fh_l0_51 + (-0.077251628041267395)*hfn_6;
    fh_l0_51 = fh_l0_51 + (0.40919294953346252)*hfn_7;
    fh_l0_51 = fh_l0_51 + (-0.2145305722951889)*hfn_8;
    fh_l0_51 = fh_l0_51 + (-0.022155458107590675)*hfn_9;
    fh_l0_51 = fh_l0_51 + (0.25608471035957336)*hfn_10;
    fh_l0_51 = fh_l0_51 + (-0.018852882087230682)*hfn_11;
    fh_l0_51 = fh_l0_51 + (0.20633357763290405)*hfn_12;
    fh_l0_51 = fh_l0_51 + (-0.24386729300022125)*hfn_13;
    fh_l0_51 = fh_l0_51 + (-0.21043339371681213)*hfn_14;
    fh_l0_51 = fh_l0_51 + (0.06903926283121109)*hfn_15;
    fh_l0_52 = -0.1249733492732048;
    fh_l0_52 = fh_l0_52 + (0.0080455821007490158)*hfn_0;
    fh_l0_52 = fh_l0_52 + (-0.18494760990142822)*hfn_1;
    fh_l0_52 = fh_l0_52 + (0.056588083505630493)*hfn_2;
    fh_l0_52 = fh_l0_52 + (-0.029375577345490456)*hfn_3;
    fh_l0_52 = fh_l0_52 + (-0.14783100783824921)*hfn_4;
    fh_l0_52 = fh_l0_52 + (0.10722468048334122)*hfn_5;
    fh_l0_52 = fh_l0_52 + (-0.060917377471923828)*hfn_6;
    fh_l0_52 = fh_l0_52 + (0.1209743320941925)*hfn_7;
    fh_l0_52 = fh_l0_52 + (-0.10268431901931763)*hfn_8;
    fh_l0_52 = fh_l0_52 + (-0.27316457033157349)*hfn_9;
    fh_l0_52 = fh_l0_52 + (-0.1332281231880188)*hfn_10;
    fh_l0_52 = fh_l0_52 + (0.15673758089542389)*hfn_11;
    fh_l0_52 = fh_l0_52 + (0.13897255063056946)*hfn_12;
    fh_l0_52 = fh_l0_52 + (-0.088744468986988068)*hfn_13;
    fh_l0_52 = fh_l0_52 + (0.02691495418548584)*hfn_14;
    fh_l0_52 = fh_l0_52 + (0.17626146972179413)*hfn_15;
    fh_l0_53 = 0.21322101354598999;
    fh_l0_53 = fh_l0_53 + (-0.17642100155353546)*hfn_0;
    fh_l0_53 = fh_l0_53 + (0.04850073903799057)*hfn_1;
    fh_l0_53 = fh_l0_53 + (-0.062264580279588699)*hfn_2;
    fh_l0_53 = fh_l0_53 + (0.056022312492132187)*hfn_3;
    fh_l0_53 = fh_l0_53 + (-0.12312420457601547)*hfn_4;
    fh_l0_53 = fh_l0_53 + (-0.17992067337036133)*hfn_5;
    fh_l0_53 = fh_l0_53 + (-0.06198536604642868)*hfn_6;
    fh_l0_53 = fh_l0_53 + (0.086809463798999786)*hfn_7;
    fh_l0_53 = fh_l0_53 + (0.0026116124354302883)*hfn_8;
    fh_l0_53 = fh_l0_53 + (2.479518843756523e-05)*hfn_9;
    fh_l0_53 = fh_l0_53 + (0.046356048434972763)*hfn_10;
    fh_l0_53 = fh_l0_53 + (0.12763717770576477)*hfn_11;
    fh_l0_53 = fh_l0_53 + (0.11466015875339508)*hfn_12;
    fh_l0_53 = fh_l0_53 + (-0.14446300268173218)*hfn_13;
    fh_l0_53 = fh_l0_53 + (0.030946725979447365)*hfn_14;
    fh_l0_53 = fh_l0_53 + (-0.098485007882118225)*hfn_15;
    fh_l0_54 = -0.02493719570338726;
    fh_l0_54 = fh_l0_54 + (-0.08722618967294693)*hfn_0;
    fh_l0_54 = fh_l0_54 + (-0.2773061990737915)*hfn_1;
    fh_l0_54 = fh_l0_54 + (-0.033158596605062485)*hfn_2;
    fh_l0_54 = fh_l0_54 + (0.00018333519983571023)*hfn_3;
    fh_l0_54 = fh_l0_54 + (0.35034048557281494)*hfn_4;
    fh_l0_54 = fh_l0_54 + (0.34097492694854736)*hfn_5;
    fh_l0_54 = fh_l0_54 + (0.00825473852455616)*hfn_6;
    fh_l0_54 = fh_l0_54 + (-0.26104691624641418)*hfn_7;
    fh_l0_54 = fh_l0_54 + (-0.10818912833929062)*hfn_8;
    fh_l0_54 = fh_l0_54 + (-0.31035339832305908)*hfn_9;
    fh_l0_54 = fh_l0_54 + (0.18746334314346313)*hfn_10;
    fh_l0_54 = fh_l0_54 + (0.068450629711151123)*hfn_11;
    fh_l0_54 = fh_l0_54 + (0.21300259232521057)*hfn_12;
    fh_l0_54 = fh_l0_54 + (-0.12191113829612732)*hfn_13;
    fh_l0_54 = fh_l0_54 + (0.060282763093709946)*hfn_14;
    fh_l0_54 = fh_l0_54 + (-0.17583861947059631)*hfn_15;
    fh_l0_55 = 0.017006749287247658;
    fh_l0_55 = fh_l0_55 + (0.2415551096200943)*hfn_0;
    fh_l0_55 = fh_l0_55 + (-0.01656622439622879)*hfn_1;
    fh_l0_55 = fh_l0_55 + (-0.033063575625419617)*hfn_2;
    fh_l0_55 = fh_l0_55 + (-0.011226709000766277)*hfn_3;
    fh_l0_55 = fh_l0_55 + (-0.12730090320110321)*hfn_4;
    fh_l0_55 = fh_l0_55 + (-0.063539363443851471)*hfn_5;
    fh_l0_55 = fh_l0_55 + (-0.24252046644687653)*hfn_6;
    fh_l0_55 = fh_l0_55 + (0.13682521879673004)*hfn_7;
    fh_l0_55 = fh_l0_55 + (-0.029288928955793381)*hfn_8;
    fh_l0_55 = fh_l0_55 + (0.22063794732093811)*hfn_9;
    fh_l0_55 = fh_l0_55 + (-0.065114252269268036)*hfn_10;
    fh_l0_55 = fh_l0_55 + (-0.060375649482011795)*hfn_11;
    fh_l0_55 = fh_l0_55 + (-0.13157293200492859)*hfn_12;
    fh_l0_55 = fh_l0_55 + (-0.12860634922981262)*hfn_13;
    fh_l0_55 = fh_l0_55 + (0.22663424909114838)*hfn_14;
    fh_l0_55 = fh_l0_55 + (-0.069933772087097168)*hfn_15;
    fh_l0_56 = -0.029480617493391037;
    fh_l0_56 = fh_l0_56 + (0.049459103494882584)*hfn_0;
    fh_l0_56 = fh_l0_56 + (-0.053204037249088287)*hfn_1;
    fh_l0_56 = fh_l0_56 + (0.0089072259142994881)*hfn_2;
    fh_l0_56 = fh_l0_56 + (0.29880326986312866)*hfn_3;
    fh_l0_56 = fh_l0_56 + (0.26847469806671143)*hfn_4;
    fh_l0_56 = fh_l0_56 + (0.32813164591789246)*hfn_5;
    fh_l0_56 = fh_l0_56 + (0.41456565260887146)*hfn_6;
    fh_l0_56 = fh_l0_56 + (-0.32732701301574707)*hfn_7;
    fh_l0_56 = fh_l0_56 + (-0.070356450974941254)*hfn_8;
    fh_l0_56 = fh_l0_56 + (-0.042190693318843842)*hfn_9;
    fh_l0_56 = fh_l0_56 + (-0.032541405409574509)*hfn_10;
    fh_l0_56 = fh_l0_56 + (0.098693355917930603)*hfn_11;
    fh_l0_56 = fh_l0_56 + (-0.013251647353172302)*hfn_12;
    fh_l0_56 = fh_l0_56 + (-0.13104620575904846)*hfn_13;
    fh_l0_56 = fh_l0_56 + (0.062181420624256134)*hfn_14;
    fh_l0_56 = fh_l0_56 + (0.019539088010787964)*hfn_15;
    fh_l0_57 = 0.032999288290739059;
    fh_l0_57 = fh_l0_57 + (-0.11502522975206375)*hfn_0;
    fh_l0_57 = fh_l0_57 + (-0.31626555323600769)*hfn_1;
    fh_l0_57 = fh_l0_57 + (0.016772668808698654)*hfn_2;
    fh_l0_57 = fh_l0_57 + (0.020477393642067909)*hfn_3;
    fh_l0_57 = fh_l0_57 + (-0.14521124958992004)*hfn_4;
    fh_l0_57 = fh_l0_57 + (0.10096807777881622)*hfn_5;
    fh_l0_57 = fh_l0_57 + (0.030709998682141304)*hfn_6;
    fh_l0_57 = fh_l0_57 + (-0.19134381413459778)*hfn_7;
    fh_l0_57 = fh_l0_57 + (-0.11394885927438736)*hfn_8;
    fh_l0_57 = fh_l0_57 + (-0.031960926949977875)*hfn_9;
    fh_l0_57 = fh_l0_57 + (0.16114026308059692)*hfn_10;
    fh_l0_57 = fh_l0_57 + (0.021859019994735718)*hfn_11;
    fh_l0_57 = fh_l0_57 + (0.095281295478343964)*hfn_12;
    fh_l0_57 = fh_l0_57 + (0.03593812882900238)*hfn_13;
    fh_l0_57 = fh_l0_57 + (-0.010871358215808868)*hfn_14;
    fh_l0_57 = fh_l0_57 + (-0.2035256028175354)*hfn_15;
    fh_l0_58 = 0.082904070615768433;
    fh_l0_58 = fh_l0_58 + (0.019004181027412415)*hfn_0;
    fh_l0_58 = fh_l0_58 + (-0.14775398373603821)*hfn_1;
    fh_l0_58 = fh_l0_58 + (-0.053289212286472321)*hfn_2;
    fh_l0_58 = fh_l0_58 + (-0.0078542260453104973)*hfn_3;
    fh_l0_58 = fh_l0_58 + (-0.15153230726718903)*hfn_4;
    fh_l0_58 = fh_l0_58 + (0.069755993783473969)*hfn_5;
    fh_l0_58 = fh_l0_58 + (-0.28014740347862244)*hfn_6;
    fh_l0_58 = fh_l0_58 + (-0.057265952229499817)*hfn_7;
    fh_l0_58 = fh_l0_58 + (0.27888330817222595)*hfn_8;
    fh_l0_58 = fh_l0_58 + (-0.18280279636383057)*hfn_9;
    fh_l0_58 = fh_l0_58 + (-0.23035013675689697)*hfn_10;
    fh_l0_58 = fh_l0_58 + (0.2054641991853714)*hfn_11;
    fh_l0_58 = fh_l0_58 + (-0.023586489260196686)*hfn_12;
    fh_l0_58 = fh_l0_58 + (0.20134821534156799)*hfn_13;
    fh_l0_58 = fh_l0_58 + (0.1623864471912384)*hfn_14;
    fh_l0_58 = fh_l0_58 + (0.055412016808986664)*hfn_15;
    fh_l0_59 = 0.15807358920574188;
    fh_l0_59 = fh_l0_59 + (-0.093069091439247131)*hfn_0;
    fh_l0_59 = fh_l0_59 + (-0.090190932154655457)*hfn_1;
    fh_l0_59 = fh_l0_59 + (0.27823549509048462)*hfn_2;
    fh_l0_59 = fh_l0_59 + (-0.090308867394924164)*hfn_3;
    fh_l0_59 = fh_l0_59 + (0.076679378747940063)*hfn_4;
    fh_l0_59 = fh_l0_59 + (0.087952941656112671)*hfn_5;
    fh_l0_59 = fh_l0_59 + (0.088114753365516663)*hfn_6;
    fh_l0_59 = fh_l0_59 + (-0.33174020051956177)*hfn_7;
    fh_l0_59 = fh_l0_59 + (-0.28629061579704285)*hfn_8;
    fh_l0_59 = fh_l0_59 + (0.031262889504432678)*hfn_9;
    fh_l0_59 = fh_l0_59 + (-0.10602174699306488)*hfn_10;
    fh_l0_59 = fh_l0_59 + (-0.12692423164844513)*hfn_11;
    fh_l0_59 = fh_l0_59 + (0.10582674294710159)*hfn_12;
    fh_l0_59 = fh_l0_59 + (0.36259087920188904)*hfn_13;
    fh_l0_59 = fh_l0_59 + (0.11016988754272461)*hfn_14;
    fh_l0_59 = fh_l0_59 + (-0.1846574991941452)*hfn_15;
    fh_l0_60 = 0.11956870555877686;
    fh_l0_60 = fh_l0_60 + (-0.087518453598022461)*hfn_0;
    fh_l0_60 = fh_l0_60 + (0.04936344176530838)*hfn_1;
    fh_l0_60 = fh_l0_60 + (0.086668200790882111)*hfn_2;
    fh_l0_60 = fh_l0_60 + (0.35969525575637817)*hfn_3;
    fh_l0_60 = fh_l0_60 + (0.23972654342651367)*hfn_4;
    fh_l0_60 = fh_l0_60 + (0.096001118421554565)*hfn_5;
    fh_l0_60 = fh_l0_60 + (0.21414265036582947)*hfn_6;
    fh_l0_60 = fh_l0_60 + (0.24699901044368744)*hfn_7;
    fh_l0_60 = fh_l0_60 + (0.11689767986536026)*hfn_8;
    fh_l0_60 = fh_l0_60 + (-0.30654960870742798)*hfn_9;
    fh_l0_60 = fh_l0_60 + (0.094756297767162323)*hfn_10;
    fh_l0_60 = fh_l0_60 + (0.00022404984338209033)*hfn_11;
    fh_l0_60 = fh_l0_60 + (0.27687567472457886)*hfn_12;
    fh_l0_60 = fh_l0_60 + (-0.18052826821804047)*hfn_13;
    fh_l0_60 = fh_l0_60 + (0.08544255793094635)*hfn_14;
    fh_l0_60 = fh_l0_60 + (-0.13799196481704712)*hfn_15;
    fh_l0_61 = -0.22973273694515228;
    fh_l0_61 = fh_l0_61 + (-0.014756661839783192)*hfn_0;
    fh_l0_61 = fh_l0_61 + (0.13591529428958893)*hfn_1;
    fh_l0_61 = fh_l0_61 + (0.061769101768732071)*hfn_2;
    fh_l0_61 = fh_l0_61 + (0.21102377772331238)*hfn_3;
    fh_l0_61 = fh_l0_61 + (-0.088293403387069702)*hfn_4;
    fh_l0_61 = fh_l0_61 + (0.1390414834022522)*hfn_5;
    fh_l0_61 = fh_l0_61 + (0.073308013379573822)*hfn_6;
    fh_l0_61 = fh_l0_61 + (0.16069649159908295)*hfn_7;
    fh_l0_61 = fh_l0_61 + (-0.15590639412403107)*hfn_8;
    fh_l0_61 = fh_l0_61 + (-0.042859684675931931)*hfn_9;
    fh_l0_61 = fh_l0_61 + (-0.11064416915178299)*hfn_10;
    fh_l0_61 = fh_l0_61 + (0.08793012797832489)*hfn_11;
    fh_l0_61 = fh_l0_61 + (0.18893028795719147)*hfn_12;
    fh_l0_61 = fh_l0_61 + (-0.19648845493793488)*hfn_13;
    fh_l0_61 = fh_l0_61 + (0.096432320773601532)*hfn_14;
    fh_l0_61 = fh_l0_61 + (-0.085244141519069672)*hfn_15;
    fh_l0_62 = 0.012594882398843765;
    fh_l0_62 = fh_l0_62 + (-0.01294667087495327)*hfn_0;
    fh_l0_62 = fh_l0_62 + (-0.27163714170455933)*hfn_1;
    fh_l0_62 = fh_l0_62 + (-0.04303552582859993)*hfn_2;
    fh_l0_62 = fh_l0_62 + (-0.26927497982978821)*hfn_3;
    fh_l0_62 = fh_l0_62 + (0.11282677203416824)*hfn_4;
    fh_l0_62 = fh_l0_62 + (-0.21014155447483063)*hfn_5;
    fh_l0_62 = fh_l0_62 + (0.040897354483604431)*hfn_6;
    fh_l0_62 = fh_l0_62 + (0.3331291675567627)*hfn_7;
    fh_l0_62 = fh_l0_62 + (0.21107254922389984)*hfn_8;
    fh_l0_62 = fh_l0_62 + (-0.1913265585899353)*hfn_9;
    fh_l0_62 = fh_l0_62 + (-0.30044674873352051)*hfn_10;
    fh_l0_62 = fh_l0_62 + (0.0067795529030263424)*hfn_11;
    fh_l0_62 = fh_l0_62 + (0.024730222299695015)*hfn_12;
    fh_l0_62 = fh_l0_62 + (0.02831665612757206)*hfn_13;
    fh_l0_62 = fh_l0_62 + (-0.030067332088947296)*hfn_14;
    fh_l0_62 = fh_l0_62 + (0.15481920540332794)*hfn_15;
    fh_l0_63 = -0.31509652733802795;
    fh_l0_63 = fh_l0_63 + (-0.23960098624229431)*hfn_0;
    fh_l0_63 = fh_l0_63 + (-0.23756828904151917)*hfn_1;
    fh_l0_63 = fh_l0_63 + (-0.025680359452962875)*hfn_2;
    fh_l0_63 = fh_l0_63 + (0.18344716727733612)*hfn_3;
    fh_l0_63 = fh_l0_63 + (-0.057824060320854187)*hfn_4;
    fh_l0_63 = fh_l0_63 + (-0.45363873243331909)*hfn_5;
    fh_l0_63 = fh_l0_63 + (0.20265644788742065)*hfn_6;
    fh_l0_63 = fh_l0_63 + (0.33926385641098022)*hfn_7;
    fh_l0_63 = fh_l0_63 + (-0.087213136255741119)*hfn_8;
    fh_l0_63 = fh_l0_63 + (-0.09219273179769516)*hfn_9;
    fh_l0_63 = fh_l0_63 + (-0.040588919073343277)*hfn_10;
    fh_l0_63 = fh_l0_63 + (0.087364412844181061)*hfn_11;
    fh_l0_63 = fh_l0_63 + (0.25564923882484436)*hfn_12;
    fh_l0_63 = fh_l0_63 + (0.38813474774360657)*hfn_13;
    fh_l0_63 = fh_l0_63 + (0.012353258207440376)*hfn_14;
    fh_l0_63 = fh_l0_63 + (-0.070931658148765564)*hfn_15;
    fh0_mean = (fh_l0_0 + fh_l0_1 + fh_l0_2 + fh_l0_3 + fh_l0_4 + fh_l0_5 + fh_l0_6 + fh_l0_7 + fh_l0_8 + fh_l0_9 + fh_l0_10 + fh_l0_11 + fh_l0_12 + fh_l0_13 + fh_l0_14 + fh_l0_15 + fh_l0_16 + fh_l0_17 + fh_l0_18 + fh_l0_19 + fh_l0_20 + fh_l0_21 + fh_l0_22 + fh_l0_23 + fh_l0_24 + fh_l0_25 + fh_l0_26 + fh_l0_27 + fh_l0_28 + fh_l0_29 + fh_l0_30 + fh_l0_31 + fh_l0_32 + fh_l0_33 + fh_l0_34 + fh_l0_35 + fh_l0_36 + fh_l0_37 + fh_l0_38 + fh_l0_39 + fh_l0_40 + fh_l0_41 + fh_l0_42 + fh_l0_43 + fh_l0_44 + fh_l0_45 + fh_l0_46 + fh_l0_47 + fh_l0_48 + fh_l0_49 + fh_l0_50 + fh_l0_51 + fh_l0_52 + fh_l0_53 + fh_l0_54 + fh_l0_55 + fh_l0_56 + fh_l0_57 + fh_l0_58 + fh_l0_59 + fh_l0_60 + fh_l0_61 + fh_l0_62 + fh_l0_63) / 64;
    fh0_var = (((fh_l0_0) - fh0_mean)*((fh_l0_0) - fh0_mean) + ((fh_l0_1) - fh0_mean)*((fh_l0_1) - fh0_mean) + ((fh_l0_2) - fh0_mean)*((fh_l0_2) - fh0_mean) + ((fh_l0_3) - fh0_mean)*((fh_l0_3) - fh0_mean) + ((fh_l0_4) - fh0_mean)*((fh_l0_4) - fh0_mean) + ((fh_l0_5) - fh0_mean)*((fh_l0_5) - fh0_mean) + ((fh_l0_6) - fh0_mean)*((fh_l0_6) - fh0_mean) + ((fh_l0_7) - fh0_mean)*((fh_l0_7) - fh0_mean) + ((fh_l0_8) - fh0_mean)*((fh_l0_8) - fh0_mean) + ((fh_l0_9) - fh0_mean)*((fh_l0_9) - fh0_mean) + ((fh_l0_10) - fh0_mean)*((fh_l0_10) - fh0_mean) + ((fh_l0_11) - fh0_mean)*((fh_l0_11) - fh0_mean) + ((fh_l0_12) - fh0_mean)*((fh_l0_12) - fh0_mean) + ((fh_l0_13) - fh0_mean)*((fh_l0_13) - fh0_mean) + ((fh_l0_14) - fh0_mean)*((fh_l0_14) - fh0_mean) + ((fh_l0_15) - fh0_mean)*((fh_l0_15) - fh0_mean) + ((fh_l0_16) - fh0_mean)*((fh_l0_16) - fh0_mean) + ((fh_l0_17) - fh0_mean)*((fh_l0_17) - fh0_mean) + ((fh_l0_18) - fh0_mean)*((fh_l0_18) - fh0_mean) + ((fh_l0_19) - fh0_mean)*((fh_l0_19) - fh0_mean) + ((fh_l0_20) - fh0_mean)*((fh_l0_20) - fh0_mean) + ((fh_l0_21) - fh0_mean)*((fh_l0_21) - fh0_mean) + ((fh_l0_22) - fh0_mean)*((fh_l0_22) - fh0_mean) + ((fh_l0_23) - fh0_mean)*((fh_l0_23) - fh0_mean) + ((fh_l0_24) - fh0_mean)*((fh_l0_24) - fh0_mean) + ((fh_l0_25) - fh0_mean)*((fh_l0_25) - fh0_mean) + ((fh_l0_26) - fh0_mean)*((fh_l0_26) - fh0_mean) + ((fh_l0_27) - fh0_mean)*((fh_l0_27) - fh0_mean) + ((fh_l0_28) - fh0_mean)*((fh_l0_28) - fh0_mean) + ((fh_l0_29) - fh0_mean)*((fh_l0_29) - fh0_mean) + ((fh_l0_30) - fh0_mean)*((fh_l0_30) - fh0_mean) + ((fh_l0_31) - fh0_mean)*((fh_l0_31) - fh0_mean) + ((fh_l0_32) - fh0_mean)*((fh_l0_32) - fh0_mean) + ((fh_l0_33) - fh0_mean)*((fh_l0_33) - fh0_mean) + ((fh_l0_34) - fh0_mean)*((fh_l0_34) - fh0_mean) + ((fh_l0_35) - fh0_mean)*((fh_l0_35) - fh0_mean) + ((fh_l0_36) - fh0_mean)*((fh_l0_36) - fh0_mean) + ((fh_l0_37) - fh0_mean)*((fh_l0_37) - fh0_mean) + ((fh_l0_38) - fh0_mean)*((fh_l0_38) - fh0_mean) + ((fh_l0_39) - fh0_mean)*((fh_l0_39) - fh0_mean) + ((fh_l0_40) - fh0_mean)*((fh_l0_40) - fh0_mean) + ((fh_l0_41) - fh0_mean)*((fh_l0_41) - fh0_mean) + ((fh_l0_42) - fh0_mean)*((fh_l0_42) - fh0_mean) + ((fh_l0_43) - fh0_mean)*((fh_l0_43) - fh0_mean) + ((fh_l0_44) - fh0_mean)*((fh_l0_44) - fh0_mean) + ((fh_l0_45) - fh0_mean)*((fh_l0_45) - fh0_mean) + ((fh_l0_46) - fh0_mean)*((fh_l0_46) - fh0_mean) + ((fh_l0_47) - fh0_mean)*((fh_l0_47) - fh0_mean) + ((fh_l0_48) - fh0_mean)*((fh_l0_48) - fh0_mean) + ((fh_l0_49) - fh0_mean)*((fh_l0_49) - fh0_mean) + ((fh_l0_50) - fh0_mean)*((fh_l0_50) - fh0_mean) + ((fh_l0_51) - fh0_mean)*((fh_l0_51) - fh0_mean) + ((fh_l0_52) - fh0_mean)*((fh_l0_52) - fh0_mean) + ((fh_l0_53) - fh0_mean)*((fh_l0_53) - fh0_mean) + ((fh_l0_54) - fh0_mean)*((fh_l0_54) - fh0_mean) + ((fh_l0_55) - fh0_mean)*((fh_l0_55) - fh0_mean) + ((fh_l0_56) - fh0_mean)*((fh_l0_56) - fh0_mean) + ((fh_l0_57) - fh0_mean)*((fh_l0_57) - fh0_mean) + ((fh_l0_58) - fh0_mean)*((fh_l0_58) - fh0_mean) + ((fh_l0_59) - fh0_mean)*((fh_l0_59) - fh0_mean) + ((fh_l0_60) - fh0_mean)*((fh_l0_60) - fh0_mean) + ((fh_l0_61) - fh0_mean)*((fh_l0_61) - fh0_mean) + ((fh_l0_62) - fh0_mean)*((fh_l0_62) - fh0_mean) + ((fh_l0_63) - fh0_mean)*((fh_l0_63) - fh0_mean)) / 64;
    fh_n0_0 = (((fh_l0_0) - fh0_mean) / sqrt(fh0_var + ln_eps)) * (0.92273211479187012) + (-0.075384311378002167);
    fh_g0_0 = gelu_approx(fh_n0_0);
    fh_n0_1 = (((fh_l0_1) - fh0_mean) / sqrt(fh0_var + ln_eps)) * (0.75623273849487305) + (-0.15652143955230713);
    fh_g0_1 = gelu_approx(fh_n0_1);
    fh_n0_2 = (((fh_l0_2) - fh0_mean) / sqrt(fh0_var + ln_eps)) * (1.1673529148101807) + (-0.054579626768827438);
    fh_g0_2 = gelu_approx(fh_n0_2);
    fh_n0_3 = (((fh_l0_3) - fh0_mean) / sqrt(fh0_var + ln_eps)) * (1.2757148742675781) + (0.1123163178563118);
    fh_g0_3 = gelu_approx(fh_n0_3);
    fh_n0_4 = (((fh_l0_4) - fh0_mean) / sqrt(fh0_var + ln_eps)) * (0.28521841764450073) + (-0.15130995213985443);
    fh_g0_4 = gelu_approx(fh_n0_4);
    fh_n0_5 = (((fh_l0_5) - fh0_mean) / sqrt(fh0_var + ln_eps)) * (1.4342805147171021) + (0.20964883267879486);
    fh_g0_5 = gelu_approx(fh_n0_5);
    fh_n0_6 = (((fh_l0_6) - fh0_mean) / sqrt(fh0_var + ln_eps)) * (0.77881091833114624) + (-0.14284294843673706);
    fh_g0_6 = gelu_approx(fh_n0_6);
    fh_n0_7 = (((fh_l0_7) - fh0_mean) / sqrt(fh0_var + ln_eps)) * (1.4151934385299683) + (0.11882998049259186);
    fh_g0_7 = gelu_approx(fh_n0_7);
    fh_n0_8 = (((fh_l0_8) - fh0_mean) / sqrt(fh0_var + ln_eps)) * (1.0735459327697754) + (0.052203558385372162);
    fh_g0_8 = gelu_approx(fh_n0_8);
    fh_n0_9 = (((fh_l0_9) - fh0_mean) / sqrt(fh0_var + ln_eps)) * (0.97814607620239258) + (0.013649147935211658);
    fh_g0_9 = gelu_approx(fh_n0_9);
    fh_n0_10 = (((fh_l0_10) - fh0_mean) / sqrt(fh0_var + ln_eps)) * (1.4455010890960693) + (-0.055654328316450119);
    fh_g0_10 = gelu_approx(fh_n0_10);
    fh_n0_11 = (((fh_l0_11) - fh0_mean) / sqrt(fh0_var + ln_eps)) * (1.1733779907226562) + (0.042123638093471527);
    fh_g0_11 = gelu_approx(fh_n0_11);
    fh_n0_12 = (((fh_l0_12) - fh0_mean) / sqrt(fh0_var + ln_eps)) * (0.94531124830245972) + (0.047394908964633942);
    fh_g0_12 = gelu_approx(fh_n0_12);
    fh_n0_13 = (((fh_l0_13) - fh0_mean) / sqrt(fh0_var + ln_eps)) * (0.91350936889648438) + (-0.11430345475673676);
    fh_g0_13 = gelu_approx(fh_n0_13);
    fh_n0_14 = (((fh_l0_14) - fh0_mean) / sqrt(fh0_var + ln_eps)) * (1.1550122499465942) + (-0.093939222395420074);
    fh_g0_14 = gelu_approx(fh_n0_14);
    fh_n0_15 = (((fh_l0_15) - fh0_mean) / sqrt(fh0_var + ln_eps)) * (0.97230708599090576) + (0.0032462258823215961);
    fh_g0_15 = gelu_approx(fh_n0_15);
    fh_n0_16 = (((fh_l0_16) - fh0_mean) / sqrt(fh0_var + ln_eps)) * (1.6718636751174927) + (-0.28960481286048889);
    fh_g0_16 = gelu_approx(fh_n0_16);
    fh_n0_17 = (((fh_l0_17) - fh0_mean) / sqrt(fh0_var + ln_eps)) * (1.6163785457611084) + (-0.12629590928554535);
    fh_g0_17 = gelu_approx(fh_n0_17);
    fh_n0_18 = (((fh_l0_18) - fh0_mean) / sqrt(fh0_var + ln_eps)) * (0.69074505567550659) + (-0.24759335815906525);
    fh_g0_18 = gelu_approx(fh_n0_18);
    fh_n0_19 = (((fh_l0_19) - fh0_mean) / sqrt(fh0_var + ln_eps)) * (0.70206594467163086) + (-0.2148449569940567);
    fh_g0_19 = gelu_approx(fh_n0_19);
    fh_n0_20 = (((fh_l0_20) - fh0_mean) / sqrt(fh0_var + ln_eps)) * (1.0602606534957886) + (0.041256964206695557);
    fh_g0_20 = gelu_approx(fh_n0_20);
    fh_n0_21 = (((fh_l0_21) - fh0_mean) / sqrt(fh0_var + ln_eps)) * (1.4967447519302368) + (-0.11097338050603867);
    fh_g0_21 = gelu_approx(fh_n0_21);
    fh_n0_22 = (((fh_l0_22) - fh0_mean) / sqrt(fh0_var + ln_eps)) * (1.3457249402999878) + (0.081637799739837646);
    fh_g0_22 = gelu_approx(fh_n0_22);
    fh_n0_23 = (((fh_l0_23) - fh0_mean) / sqrt(fh0_var + ln_eps)) * (0.82734495401382446) + (-0.11644012480974197);
    fh_g0_23 = gelu_approx(fh_n0_23);
    fh_n0_24 = (((fh_l0_24) - fh0_mean) / sqrt(fh0_var + ln_eps)) * (1.0784659385681152) + (-0.10011728852987289);
    fh_g0_24 = gelu_approx(fh_n0_24);
    fh_n0_25 = (((fh_l0_25) - fh0_mean) / sqrt(fh0_var + ln_eps)) * (1.0715597867965698) + (0.10503613948822021);
    fh_g0_25 = gelu_approx(fh_n0_25);
    fh_n0_26 = (((fh_l0_26) - fh0_mean) / sqrt(fh0_var + ln_eps)) * (1.4911150932312012) + (-0.13321121037006378);
    fh_g0_26 = gelu_approx(fh_n0_26);
    fh_n0_27 = (((fh_l0_27) - fh0_mean) / sqrt(fh0_var + ln_eps)) * (1.094230055809021) + (-0.076889537274837494);
    fh_g0_27 = gelu_approx(fh_n0_27);
    fh_n0_28 = (((fh_l0_28) - fh0_mean) / sqrt(fh0_var + ln_eps)) * (0.80938154458999634) + (-0.18821141123771667);
    fh_g0_28 = gelu_approx(fh_n0_28);
    fh_n0_29 = (((fh_l0_29) - fh0_mean) / sqrt(fh0_var + ln_eps)) * (0.68245846033096313) + (-0.22079126536846161);
    fh_g0_29 = gelu_approx(fh_n0_29);
    fh_n0_30 = (((fh_l0_30) - fh0_mean) / sqrt(fh0_var + ln_eps)) * (0.98193830251693726) + (-0.028305402025580406);
    fh_g0_30 = gelu_approx(fh_n0_30);
    fh_n0_31 = (((fh_l0_31) - fh0_mean) / sqrt(fh0_var + ln_eps)) * (1.0873785018920898) + (0.068154104053974152);
    fh_g0_31 = gelu_approx(fh_n0_31);
    fh_n0_32 = (((fh_l0_32) - fh0_mean) / sqrt(fh0_var + ln_eps)) * (1.1888352632522583) + (0.081753522157669067);
    fh_g0_32 = gelu_approx(fh_n0_32);
    fh_n0_33 = (((fh_l0_33) - fh0_mean) / sqrt(fh0_var + ln_eps)) * (1.0571403503417969) + (-0.0088525209575891495);
    fh_g0_33 = gelu_approx(fh_n0_33);
    fh_n0_34 = (((fh_l0_34) - fh0_mean) / sqrt(fh0_var + ln_eps)) * (1.0577207803726196) + (0.06537812203168869);
    fh_g0_34 = gelu_approx(fh_n0_34);
    fh_n0_35 = (((fh_l0_35) - fh0_mean) / sqrt(fh0_var + ln_eps)) * (1.2404310703277588) + (-0.035012204200029373);
    fh_g0_35 = gelu_approx(fh_n0_35);
    fh_n0_36 = (((fh_l0_36) - fh0_mean) / sqrt(fh0_var + ln_eps)) * (1.7469834089279175) + (0.053361941128969193);
    fh_g0_36 = gelu_approx(fh_n0_36);
    fh_n0_37 = (((fh_l0_37) - fh0_mean) / sqrt(fh0_var + ln_eps)) * (1.0270363092422485) + (0.011388646438717842);
    fh_g0_37 = gelu_approx(fh_n0_37);
    fh_n0_38 = (((fh_l0_38) - fh0_mean) / sqrt(fh0_var + ln_eps)) * (1.0982824563980103) + (0.042966771870851517);
    fh_g0_38 = gelu_approx(fh_n0_38);
    fh_n0_39 = (((fh_l0_39) - fh0_mean) / sqrt(fh0_var + ln_eps)) * (1.0033426284790039) + (-0.06024932861328125);
    fh_g0_39 = gelu_approx(fh_n0_39);
    fh_n0_40 = (((fh_l0_40) - fh0_mean) / sqrt(fh0_var + ln_eps)) * (1.2498924732208252) + (0.056624229997396469);
    fh_g0_40 = gelu_approx(fh_n0_40);
    fh_n0_41 = (((fh_l0_41) - fh0_mean) / sqrt(fh0_var + ln_eps)) * (1.3336095809936523) + (-0.076779544353485107);
    fh_g0_41 = gelu_approx(fh_n0_41);
    fh_n0_42 = (((fh_l0_42) - fh0_mean) / sqrt(fh0_var + ln_eps)) * (0.95370519161224365) + (-0.021234527230262756);
    fh_g0_42 = gelu_approx(fh_n0_42);
    fh_n0_43 = (((fh_l0_43) - fh0_mean) / sqrt(fh0_var + ln_eps)) * (0.94995963573455811) + (0.033839240670204163);
    fh_g0_43 = gelu_approx(fh_n0_43);
    fh_n0_44 = (((fh_l0_44) - fh0_mean) / sqrt(fh0_var + ln_eps)) * (1.2884488105773926) + (-0.011607090011239052);
    fh_g0_44 = gelu_approx(fh_n0_44);
    fh_n0_45 = (((fh_l0_45) - fh0_mean) / sqrt(fh0_var + ln_eps)) * (0.98967784643173218) + (-8.8697808678261936e-05);
    fh_g0_45 = gelu_approx(fh_n0_45);
    fh_n0_46 = (((fh_l0_46) - fh0_mean) / sqrt(fh0_var + ln_eps)) * (1.1687712669372559) + (0.029860243201255798);
    fh_g0_46 = gelu_approx(fh_n0_46);
    fh_n0_47 = (((fh_l0_47) - fh0_mean) / sqrt(fh0_var + ln_eps)) * (1.1580895185470581) + (-0.16642829775810242);
    fh_g0_47 = gelu_approx(fh_n0_47);
    fh_n0_48 = (((fh_l0_48) - fh0_mean) / sqrt(fh0_var + ln_eps)) * (1.2301026582717896) + (0.069390527904033661);
    fh_g0_48 = gelu_approx(fh_n0_48);
    fh_n0_49 = (((fh_l0_49) - fh0_mean) / sqrt(fh0_var + ln_eps)) * (1.4816598892211914) + (-0.039649643003940582);
    fh_g0_49 = gelu_approx(fh_n0_49);
    fh_n0_50 = (((fh_l0_50) - fh0_mean) / sqrt(fh0_var + ln_eps)) * (1.2589733600616455) + (-0.17149417102336884);
    fh_g0_50 = gelu_approx(fh_n0_50);
    fh_n0_51 = (((fh_l0_51) - fh0_mean) / sqrt(fh0_var + ln_eps)) * (0.86037349700927734) + (-0.056778978556394577);
    fh_g0_51 = gelu_approx(fh_n0_51);
    fh_n0_52 = (((fh_l0_52) - fh0_mean) / sqrt(fh0_var + ln_eps)) * (0.64497792720794678) + (-0.24234537780284882);
    fh_g0_52 = gelu_approx(fh_n0_52);
    fh_n0_53 = (((fh_l0_53) - fh0_mean) / sqrt(fh0_var + ln_eps)) * (0.81152981519699097) + (-0.059459630399942398);
    fh_g0_53 = gelu_approx(fh_n0_53);
    fh_n0_54 = (((fh_l0_54) - fh0_mean) / sqrt(fh0_var + ln_eps)) * (0.66351395845413208) + (-0.25486457347869873);
    fh_g0_54 = gelu_approx(fh_n0_54);
    fh_n0_55 = (((fh_l0_55) - fh0_mean) / sqrt(fh0_var + ln_eps)) * (1.2356535196304321) + (-0.0075461026281118393);
    fh_g0_55 = gelu_approx(fh_n0_55);
    fh_n0_56 = (((fh_l0_56) - fh0_mean) / sqrt(fh0_var + ln_eps)) * (0.77143597602844238) + (-0.109648197889328);
    fh_g0_56 = gelu_approx(fh_n0_56);
    fh_n0_57 = (((fh_l0_57) - fh0_mean) / sqrt(fh0_var + ln_eps)) * (0.98005431890487671) + (0.00091630656970664859);
    fh_g0_57 = gelu_approx(fh_n0_57);
    fh_n0_58 = (((fh_l0_58) - fh0_mean) / sqrt(fh0_var + ln_eps)) * (1.13515305519104) + (-0.033042490482330322);
    fh_g0_58 = gelu_approx(fh_n0_58);
    fh_n0_59 = (((fh_l0_59) - fh0_mean) / sqrt(fh0_var + ln_eps)) * (1.1224907636642456) + (-0.015746055170893669);
    fh_g0_59 = gelu_approx(fh_n0_59);
    fh_n0_60 = (((fh_l0_60) - fh0_mean) / sqrt(fh0_var + ln_eps)) * (0.94664043188095093) + (-0.0015331433387473226);
    fh_g0_60 = gelu_approx(fh_n0_60);
    fh_n0_61 = (((fh_l0_61) - fh0_mean) / sqrt(fh0_var + ln_eps)) * (0.81965065002441406) + (-0.13386929035186768);
    fh_g0_61 = gelu_approx(fh_n0_61);
    fh_n0_62 = (((fh_l0_62) - fh0_mean) / sqrt(fh0_var + ln_eps)) * (1.1347672939300537) + (0.013749122619628906);
    fh_g0_62 = gelu_approx(fh_n0_62);
    fh_n0_63 = (((fh_l0_63) - fh0_mean) / sqrt(fh0_var + ln_eps)) * (1.3926067352294922) + (-0.2448495477437973);
    fh_g0_63 = gelu_approx(fh_n0_63);
    fh_l1_0 = 0.09040474146604538;
    fh_l1_0 = fh_l1_0 + (0.055013347417116165)*fh_g0_0;
    fh_l1_0 = fh_l1_0 + (0.039222437888383865)*fh_g0_1;
    fh_l1_0 = fh_l1_0 + (-0.04579365998506546)*fh_g0_2;
    fh_l1_0 = fh_l1_0 + (-0.12135271728038788)*fh_g0_3;
    fh_l1_0 = fh_l1_0 + (0.048201590776443481)*fh_g0_4;
    fh_l1_0 = fh_l1_0 + (0.25569593906402588)*fh_g0_5;
    fh_l1_0 = fh_l1_0 + (0.044190075248479843)*fh_g0_6;
    fh_l1_0 = fh_l1_0 + (0.023119090124964714)*fh_g0_7;
    fh_l1_0 = fh_l1_0 + (0.04513685405254364)*fh_g0_8;
    fh_l1_0 = fh_l1_0 + (0.11864303052425385)*fh_g0_9;
    fh_l1_0 = fh_l1_0 + (-0.16438986361026764)*fh_g0_10;
    fh_l1_0 = fh_l1_0 + (0.0047558876685798168)*fh_g0_11;
    fh_l1_0 = fh_l1_0 + (0.081126980483531952)*fh_g0_12;
    fh_l1_0 = fh_l1_0 + (0.093892723321914673)*fh_g0_13;
    fh_l1_0 = fh_l1_0 + (0.14399977028369904)*fh_g0_14;
    fh_l1_0 = fh_l1_0 + (-0.046702258288860321)*fh_g0_15;
    fh_l1_0 = fh_l1_0 + (-0.027635885402560234)*fh_g0_16;
    fh_l1_0 = fh_l1_0 + (0.023357084020972252)*fh_g0_17;
    fh_l1_0 = fh_l1_0 + (0.02312767319381237)*fh_g0_18;
    fh_l1_0 = fh_l1_0 + (0.044943943619728088)*fh_g0_19;
    fh_l1_0 = fh_l1_0 + (-0.11640696227550507)*fh_g0_20;
    fh_l1_0 = fh_l1_0 + (0.21664062142372131)*fh_g0_21;
    fh_l1_0 = fh_l1_0 + (-0.0015447471523657441)*fh_g0_22;
    fh_l1_0 = fh_l1_0 + (0.029527774080634117)*fh_g0_23;
    fh_l1_0 = fh_l1_0 + (0.054413091391324997)*fh_g0_24;
    fh_l1_0 = fh_l1_0 + (-0.016802562400698662)*fh_g0_25;
    fh_l1_0 = fh_l1_0 + (-0.22150972485542297)*fh_g0_26;
    fh_l1_0 = fh_l1_0 + (0.082746587693691254)*fh_g0_27;
    fh_l1_0 = fh_l1_0 + (0.017229042947292328)*fh_g0_28;
    fh_l1_0 = fh_l1_0 + (0.035107091069221497)*fh_g0_29;
    fh_l1_0 = fh_l1_0 + (-0.1195531040430069)*fh_g0_30;
    fh_l1_0 = fh_l1_0 + (0.089748166501522064)*fh_g0_31;
    fh_l1_0 = fh_l1_0 + (-0.064365573227405548)*fh_g0_32;
    fh_l1_0 = fh_l1_0 + (0.16041459143161774)*fh_g0_33;
    fh_l1_0 = fh_l1_0 + (0.062216702848672867)*fh_g0_34;
    fh_l1_0 = fh_l1_0 + (-0.025343067944049835)*fh_g0_35;
    fh_l1_0 = fh_l1_0 + (0.015815841034054756)*fh_g0_36;
    fh_l1_0 = fh_l1_0 + (-0.1248004287481308)*fh_g0_37;
    fh_l1_0 = fh_l1_0 + (-0.10503855347633362)*fh_g0_38;
    fh_l1_0 = fh_l1_0 + (-0.10706830769777298)*fh_g0_39;
    fh_l1_0 = fh_l1_0 + (-0.26381644606590271)*fh_g0_40;
    fh_l1_0 = fh_l1_0 + (0.037313710898160934)*fh_g0_41;
    fh_l1_0 = fh_l1_0 + (0.058650404214859009)*fh_g0_42;
    fh_l1_0 = fh_l1_0 + (-0.035640105605125427)*fh_g0_43;
    fh_l1_0 = fh_l1_0 + (-0.14193592965602875)*fh_g0_44;
    fh_l1_0 = fh_l1_0 + (0.091434434056282043)*fh_g0_45;
    fh_l1_0 = fh_l1_0 + (-0.25056672096252441)*fh_g0_46;
    fh_l1_0 = fh_l1_0 + (0.15211476385593414)*fh_g0_47;
    fh_l1_0 = fh_l1_0 + (-0.46575373411178589)*fh_g0_48;
    fh_l1_0 = fh_l1_0 + (0.092879451811313629)*fh_g0_49;
    fh_l1_0 = fh_l1_0 + (0.018234388902783394)*fh_g0_50;
    fh_l1_0 = fh_l1_0 + (0.021587317809462547)*fh_g0_51;
    fh_l1_0 = fh_l1_0 + (0.020493514835834503)*fh_g0_52;
    fh_l1_0 = fh_l1_0 + (0.046937711536884308)*fh_g0_53;
    fh_l1_0 = fh_l1_0 + (-0.0078964140266180038)*fh_g0_54;
    fh_l1_0 = fh_l1_0 + (0.15315845608711243)*fh_g0_55;
    fh_l1_0 = fh_l1_0 + (0.045242846012115479)*fh_g0_56;
    fh_l1_0 = fh_l1_0 + (-0.094466015696525574)*fh_g0_57;
    fh_l1_0 = fh_l1_0 + (-0.084558792412281036)*fh_g0_58;
    fh_l1_0 = fh_l1_0 + (-0.1754428893327713)*fh_g0_59;
    fh_l1_0 = fh_l1_0 + (0.057749584317207336)*fh_g0_60;
    fh_l1_0 = fh_l1_0 + (0.043744470924139023)*fh_g0_61;
    fh_l1_0 = fh_l1_0 + (0.074358314275741577)*fh_g0_62;
    fh_l1_0 = fh_l1_0 + (0.16606761515140533)*fh_g0_63;
    fh_l1_1 = -0.05295233428478241;
    fh_l1_1 = fh_l1_1 + (0.029872789978981018)*fh_g0_0;
    fh_l1_1 = fh_l1_1 + (0.022330312058329582)*fh_g0_1;
    fh_l1_1 = fh_l1_1 + (-0.17672279477119446)*fh_g0_2;
    fh_l1_1 = fh_l1_1 + (-0.35998687148094177)*fh_g0_3;
    fh_l1_1 = fh_l1_1 + (0.038511402904987335)*fh_g0_4;
    fh_l1_1 = fh_l1_1 + (0.35016921162605286)*fh_g0_5;
    fh_l1_1 = fh_l1_1 + (0.057533916085958481)*fh_g0_6;
    fh_l1_1 = fh_l1_1 + (-0.41314363479614258)*fh_g0_7;
    fh_l1_1 = fh_l1_1 + (0.20066468417644501)*fh_g0_8;
    fh_l1_1 = fh_l1_1 + (-0.058163173496723175)*fh_g0_9;
    fh_l1_1 = fh_l1_1 + (-0.0025703555438667536)*fh_g0_10;
    fh_l1_1 = fh_l1_1 + (0.26537966728210449)*fh_g0_11;
    fh_l1_1 = fh_l1_1 + (0.11138464510440826)*fh_g0_12;
    fh_l1_1 = fh_l1_1 + (0.00027410004986450076)*fh_g0_13;
    fh_l1_1 = fh_l1_1 + (-0.052921012043952942)*fh_g0_14;
    fh_l1_1 = fh_l1_1 + (-0.10061400383710861)*fh_g0_15;
    fh_l1_1 = fh_l1_1 + (0.19793854653835297)*fh_g0_16;
    fh_l1_1 = fh_l1_1 + (-0.24911557137966156)*fh_g0_17;
    fh_l1_1 = fh_l1_1 + (0.020346013829112053)*fh_g0_18;
    fh_l1_1 = fh_l1_1 + (0.0061373715288937092)*fh_g0_19;
    fh_l1_1 = fh_l1_1 + (0.20341946184635162)*fh_g0_20;
    fh_l1_1 = fh_l1_1 + (-0.092039003968238831)*fh_g0_21;
    fh_l1_1 = fh_l1_1 + (0.40813529491424561)*fh_g0_22;
    fh_l1_1 = fh_l1_1 + (0.036254994571208954)*fh_g0_23;
    fh_l1_1 = fh_l1_1 + (0.10395321249961853)*fh_g0_24;
    fh_l1_1 = fh_l1_1 + (0.2691483199596405)*fh_g0_25;
    fh_l1_1 = fh_l1_1 + (-0.054592233151197433)*fh_g0_26;
    fh_l1_1 = fh_l1_1 + (0.013989855535328388)*fh_g0_27;
    fh_l1_1 = fh_l1_1 + (0.032056551426649094)*fh_g0_28;
    fh_l1_1 = fh_l1_1 + (0.00090402550995349884)*fh_g0_29;
    fh_l1_1 = fh_l1_1 + (-0.1117042601108551)*fh_g0_30;
    fh_l1_1 = fh_l1_1 + (0.19736731052398682)*fh_g0_31;
    fh_l1_1 = fh_l1_1 + (-0.22654549777507782)*fh_g0_32;
    fh_l1_1 = fh_l1_1 + (-0.058370482176542282)*fh_g0_33;
    fh_l1_1 = fh_l1_1 + (0.16327224671840668)*fh_g0_34;
    fh_l1_1 = fh_l1_1 + (0.27583339810371399)*fh_g0_35;
    fh_l1_1 = fh_l1_1 + (0.86648428440093994)*fh_g0_36;
    fh_l1_1 = fh_l1_1 + (-0.11277098208665848)*fh_g0_37;
    fh_l1_1 = fh_l1_1 + (-0.19665203988552094)*fh_g0_38;
    fh_l1_1 = fh_l1_1 + (-0.090219959616661072)*fh_g0_39;
    fh_l1_1 = fh_l1_1 + (-0.048923667520284653)*fh_g0_40;
    fh_l1_1 = fh_l1_1 + (0.1656755656003952)*fh_g0_41;
    fh_l1_1 = fh_l1_1 + (-0.090100489556789398)*fh_g0_42;
    fh_l1_1 = fh_l1_1 + (-0.10329727828502655)*fh_g0_43;
    fh_l1_1 = fh_l1_1 + (-0.11886399239301682)*fh_g0_44;
    fh_l1_1 = fh_l1_1 + (-0.0069587519392371178)*fh_g0_45;
    fh_l1_1 = fh_l1_1 + (0.0029000933282077312)*fh_g0_46;
    fh_l1_1 = fh_l1_1 + (-0.067359596490859985)*fh_g0_47;
    fh_l1_1 = fh_l1_1 + (-0.082110978662967682)*fh_g0_48;
    fh_l1_1 = fh_l1_1 + (0.3064253032207489)*fh_g0_49;
    fh_l1_1 = fh_l1_1 + (-0.14075721800327301)*fh_g0_50;
    fh_l1_1 = fh_l1_1 + (0.025869544595479965)*fh_g0_51;
    fh_l1_1 = fh_l1_1 + (0.021816249936819077)*fh_g0_52;
    fh_l1_1 = fh_l1_1 + (-0.006342926062643528)*fh_g0_53;
    fh_l1_1 = fh_l1_1 + (0.0049147899262607098)*fh_g0_54;
    fh_l1_1 = fh_l1_1 + (0.43424028158187866)*fh_g0_55;
    fh_l1_1 = fh_l1_1 + (0.0065427855588495731)*fh_g0_56;
    fh_l1_1 = fh_l1_1 + (-0.11513571441173553)*fh_g0_57;
    fh_l1_1 = fh_l1_1 + (0.1317707747220993)*fh_g0_58;
    fh_l1_1 = fh_l1_1 + (0.12835080921649933)*fh_g0_59;
    fh_l1_1 = fh_l1_1 + (0.038010727614164352)*fh_g0_60;
    fh_l1_1 = fh_l1_1 + (-0.0092123923823237419)*fh_g0_61;
    fh_l1_1 = fh_l1_1 + (0.13356071710586548)*fh_g0_62;
    fh_l1_1 = fh_l1_1 + (0.063994571566581726)*fh_g0_63;

    // Inverse target scaling, then inverse Id log10 transform.
    id_scaled = fh_l1_0;
    id_log10 = id_scaled * (2.4103356499999999) + (0.57211904800000002);
    id_log10_lim = 0.5*(id_log10 + log10_id_max - sqrt((id_log10 - log10_id_max)*(id_log10 - log10_id_max) + smooth_delta));
    id_log10_lim = 0.5*(id_log10_lim + log10_id_min + sqrt((id_log10_lim - log10_id_min)*(id_log10_lim - log10_id_min) + smooth_delta));
    ids_mag = smooth_pos(limexp(ln(10.0) * id_log10_lim) - id_log_eps, smooth_delta);
    ids = sign_vds * Wid * ids_mag;

    q_scaled = fh_l1_1;
    q_ml_raw = q_scaled * (1.16392593e-10) + (-6.9849972900000004e-11);
    qg = Wid * q_scale * q_ml_raw;
    qs = -2.0/3.0 * qg;
    qd = -1.0/3.0 * qg;

    I(d,s) <+ ids;
    I(d,s) <+ gmin_ds * V(d,s);
    I(g) <+ ddt(qg);
    I(s) <+ ddt(qs);
    I(d) <+ ddt(qd);
  end
endmodule
