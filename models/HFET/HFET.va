// Automatically generated Verilog-A HFET drain-current model
`include "constants.vams"
`include "disciplines.vams"

module HFETVA(d, g, s);
  inout d, g, s;
  electrical d, g, s;

  // Geometry parameters in um, matching the ML backend inputs.
  parameter real Lsg = 1.0;
  parameter real Lgd = 6.0;
  parameter real Lg = 1.4;
  parameter real hpas = 0.2;
  parameter real hAlGaN = 0.02;
  parameter real hch = 0.01;
  parameter real hg = 0.11;
  // 0: blended current, 1: Id-Vd surface only, 2: Id-Vg surface only
  parameter integer current_mode = 0;
  parameter real gmin_ds = 1e-12 from [0:inf);
  parameter real vds_sign_delta = 1e-4 from [0:inf);

  real idvd_poly_w[0:116333];
  real idvd_poly_b[0:17];
  real idvd_ae_w0[0:1007];
  real idvd_ae_b0[0:55];
  real idvd_ae_w1[0:12599];
  real idvd_ae_b1[0:224];
  real idvd_ae_w2[0:101249];
  real idvd_ae_b2[0:449];
  real idvd_ae_w3[0:404999];
  real idvd_ae_b3[0:899];
  real idvg_poly_w[0:16819];
  real idvg_poly_b[0:19];
  real idvg_ae_w0[0:2239];
  real idvg_ae_b0[0:111];
  real idvg_ae_w1[0:49951];
  real idvg_ae_b1[0:445];
  real idvg_ae_w2[0:397831];
  real idvg_ae_b2[0:891];
  real idvg_ae_w3[0:795663];
  real idvg_ae_b3[0:891];
  real idvd_sx_mul[0:6];
  real idvd_sx_add[0:6];
  real idvd_sl_mul[0:17];
  real idvd_sl_add[0:17];
  real idvd_siv_mul[0:899];
  real idvd_siv_add[0:899];
  real idvg_sx_mul[0:6];
  real idvg_sx_add[0:6];
  real idvg_sl_mul[0:19];
  real idvg_sl_add[0:19];
  real idvg_siv_mul[0:891];
  real idvg_siv_add[0:891];

  // Temporary buffers
  real input_x[0:6];
  real idvd_poly_feat[0:6462];
  real idvd_z[0:17];
  real idvd_h0[0:55];
  real idvd_h1[0:224];
  real idvd_h2[0:449];
  real idvd_out[0:899];
  real idvg_poly_feat[0:840];
  real idvg_z[0:19];
  real idvg_h0[0:111];
  real idvg_h1[0:445];
  real idvg_h2[0:891];
  real idvg_out[0:891];
  integer i, j, fd, count_tmp;
  integer idvd_vg0_idx, idvd_vg1_idx, idvd_vd0_idx, idvd_vd1_idx;
  integer idvg_vg0_idx, idvg_vg1_idx, idvg_vd0_idx, idvg_vd1_idx;
  real tmp, val_vg, val_vd, vd_mag, sign_vd, res_id_mag;
  real safe_halg;
  real idvd_vg_pos, idvd_vg_frac, idvd_vd_pos, idvd_vd_frac;
  real idvg_vg_pos, idvg_vg_frac, idvg_vd_frac;
  real idvd_i00, idvd_i01, idvd_i10, idvd_i11, idvd_interp;
  real idvg_i00, idvg_i01, idvg_i10, idvg_i11, idvg_interp;
  real idvd_vg_dist, idvg_vd_dist, idvd_excess, idvg_excess;
  real w_idvd, w_idvg, w_sum;

  analog begin
    @(initial_step) begin
      fd = $fopen("C:/Users/ta688/UF Dropbox/PC/VerilogA/verilogA_v2/SEMLDB_veriloga_converter/outputs/HFET/hfetva_idvd_poly_w.txt", "r");
      for(i=0; i<116334; i=i+1) count_tmp = $fscanf(fd, "%e", idvd_poly_w[i]);
      $fclose(fd);
      fd = $fopen("C:/Users/ta688/UF Dropbox/PC/VerilogA/verilogA_v2/SEMLDB_veriloga_converter/outputs/HFET/hfetva_idvd_poly_b.txt", "r");
      for(i=0; i<18; i=i+1) count_tmp = $fscanf(fd, "%e", idvd_poly_b[i]);
      $fclose(fd);
      fd = $fopen("C:/Users/ta688/UF Dropbox/PC/VerilogA/verilogA_v2/SEMLDB_veriloga_converter/outputs/HFET/hfetva_idvd_ae_w0.txt", "r");
      for(i=0; i<1008; i=i+1) count_tmp = $fscanf(fd, "%e", idvd_ae_w0[i]);
      $fclose(fd);
      fd = $fopen("C:/Users/ta688/UF Dropbox/PC/VerilogA/verilogA_v2/SEMLDB_veriloga_converter/outputs/HFET/hfetva_idvd_ae_b0.txt", "r");
      for(i=0; i<56; i=i+1) count_tmp = $fscanf(fd, "%e", idvd_ae_b0[i]);
      $fclose(fd);
      fd = $fopen("C:/Users/ta688/UF Dropbox/PC/VerilogA/verilogA_v2/SEMLDB_veriloga_converter/outputs/HFET/hfetva_idvd_ae_w1.txt", "r");
      for(i=0; i<12600; i=i+1) count_tmp = $fscanf(fd, "%e", idvd_ae_w1[i]);
      $fclose(fd);
      fd = $fopen("C:/Users/ta688/UF Dropbox/PC/VerilogA/verilogA_v2/SEMLDB_veriloga_converter/outputs/HFET/hfetva_idvd_ae_b1.txt", "r");
      for(i=0; i<225; i=i+1) count_tmp = $fscanf(fd, "%e", idvd_ae_b1[i]);
      $fclose(fd);
      fd = $fopen("C:/Users/ta688/UF Dropbox/PC/VerilogA/verilogA_v2/SEMLDB_veriloga_converter/outputs/HFET/hfetva_idvd_ae_w2.txt", "r");
      for(i=0; i<101250; i=i+1) count_tmp = $fscanf(fd, "%e", idvd_ae_w2[i]);
      $fclose(fd);
      fd = $fopen("C:/Users/ta688/UF Dropbox/PC/VerilogA/verilogA_v2/SEMLDB_veriloga_converter/outputs/HFET/hfetva_idvd_ae_b2.txt", "r");
      for(i=0; i<450; i=i+1) count_tmp = $fscanf(fd, "%e", idvd_ae_b2[i]);
      $fclose(fd);
      fd = $fopen("C:/Users/ta688/UF Dropbox/PC/VerilogA/verilogA_v2/SEMLDB_veriloga_converter/outputs/HFET/hfetva_idvd_ae_w3.txt", "r");
      for(i=0; i<405000; i=i+1) count_tmp = $fscanf(fd, "%e", idvd_ae_w3[i]);
      $fclose(fd);
      fd = $fopen("C:/Users/ta688/UF Dropbox/PC/VerilogA/verilogA_v2/SEMLDB_veriloga_converter/outputs/HFET/hfetva_idvd_ae_b3.txt", "r");
      for(i=0; i<900; i=i+1) count_tmp = $fscanf(fd, "%e", idvd_ae_b3[i]);
      $fclose(fd);
      fd = $fopen("C:/Users/ta688/UF Dropbox/PC/VerilogA/verilogA_v2/SEMLDB_veriloga_converter/outputs/HFET/hfetva_idvg_poly_w.txt", "r");
      for(i=0; i<16820; i=i+1) count_tmp = $fscanf(fd, "%e", idvg_poly_w[i]);
      $fclose(fd);
      fd = $fopen("C:/Users/ta688/UF Dropbox/PC/VerilogA/verilogA_v2/SEMLDB_veriloga_converter/outputs/HFET/hfetva_idvg_poly_b.txt", "r");
      for(i=0; i<20; i=i+1) count_tmp = $fscanf(fd, "%e", idvg_poly_b[i]);
      $fclose(fd);
      fd = $fopen("C:/Users/ta688/UF Dropbox/PC/VerilogA/verilogA_v2/SEMLDB_veriloga_converter/outputs/HFET/hfetva_idvg_ae_w0.txt", "r");
      for(i=0; i<2240; i=i+1) count_tmp = $fscanf(fd, "%e", idvg_ae_w0[i]);
      $fclose(fd);
      fd = $fopen("C:/Users/ta688/UF Dropbox/PC/VerilogA/verilogA_v2/SEMLDB_veriloga_converter/outputs/HFET/hfetva_idvg_ae_b0.txt", "r");
      for(i=0; i<112; i=i+1) count_tmp = $fscanf(fd, "%e", idvg_ae_b0[i]);
      $fclose(fd);
      fd = $fopen("C:/Users/ta688/UF Dropbox/PC/VerilogA/verilogA_v2/SEMLDB_veriloga_converter/outputs/HFET/hfetva_idvg_ae_w1.txt", "r");
      for(i=0; i<49952; i=i+1) count_tmp = $fscanf(fd, "%e", idvg_ae_w1[i]);
      $fclose(fd);
      fd = $fopen("C:/Users/ta688/UF Dropbox/PC/VerilogA/verilogA_v2/SEMLDB_veriloga_converter/outputs/HFET/hfetva_idvg_ae_b1.txt", "r");
      for(i=0; i<446; i=i+1) count_tmp = $fscanf(fd, "%e", idvg_ae_b1[i]);
      $fclose(fd);
      fd = $fopen("C:/Users/ta688/UF Dropbox/PC/VerilogA/verilogA_v2/SEMLDB_veriloga_converter/outputs/HFET/hfetva_idvg_ae_w2.txt", "r");
      for(i=0; i<397832; i=i+1) count_tmp = $fscanf(fd, "%e", idvg_ae_w2[i]);
      $fclose(fd);
      fd = $fopen("C:/Users/ta688/UF Dropbox/PC/VerilogA/verilogA_v2/SEMLDB_veriloga_converter/outputs/HFET/hfetva_idvg_ae_b2.txt", "r");
      for(i=0; i<892; i=i+1) count_tmp = $fscanf(fd, "%e", idvg_ae_b2[i]);
      $fclose(fd);
      fd = $fopen("C:/Users/ta688/UF Dropbox/PC/VerilogA/verilogA_v2/SEMLDB_veriloga_converter/outputs/HFET/hfetva_idvg_ae_w3.txt", "r");
      for(i=0; i<795664; i=i+1) count_tmp = $fscanf(fd, "%e", idvg_ae_w3[i]);
      $fclose(fd);
      fd = $fopen("C:/Users/ta688/UF Dropbox/PC/VerilogA/verilogA_v2/SEMLDB_veriloga_converter/outputs/HFET/hfetva_idvg_ae_b3.txt", "r");
      for(i=0; i<892; i=i+1) count_tmp = $fscanf(fd, "%e", idvg_ae_b3[i]);
      $fclose(fd);
      fd = $fopen("C:/Users/ta688/UF Dropbox/PC/VerilogA/verilogA_v2/SEMLDB_veriloga_converter/outputs/HFET/hfetva_idvd_sx_mul.txt", "r");
      for(i=0; i<7; i=i+1) count_tmp = $fscanf(fd, "%e", idvd_sx_mul[i]);
      $fclose(fd);
      fd = $fopen("C:/Users/ta688/UF Dropbox/PC/VerilogA/verilogA_v2/SEMLDB_veriloga_converter/outputs/HFET/hfetva_idvd_sx_add.txt", "r");
      for(i=0; i<7; i=i+1) count_tmp = $fscanf(fd, "%e", idvd_sx_add[i]);
      $fclose(fd);
      fd = $fopen("C:/Users/ta688/UF Dropbox/PC/VerilogA/verilogA_v2/SEMLDB_veriloga_converter/outputs/HFET/hfetva_idvd_sl_mul.txt", "r");
      for(i=0; i<18; i=i+1) count_tmp = $fscanf(fd, "%e", idvd_sl_mul[i]);
      $fclose(fd);
      fd = $fopen("C:/Users/ta688/UF Dropbox/PC/VerilogA/verilogA_v2/SEMLDB_veriloga_converter/outputs/HFET/hfetva_idvd_sl_add.txt", "r");
      for(i=0; i<18; i=i+1) count_tmp = $fscanf(fd, "%e", idvd_sl_add[i]);
      $fclose(fd);
      fd = $fopen("C:/Users/ta688/UF Dropbox/PC/VerilogA/verilogA_v2/SEMLDB_veriloga_converter/outputs/HFET/hfetva_idvd_siv_mul.txt", "r");
      for(i=0; i<900; i=i+1) count_tmp = $fscanf(fd, "%e", idvd_siv_mul[i]);
      $fclose(fd);
      fd = $fopen("C:/Users/ta688/UF Dropbox/PC/VerilogA/verilogA_v2/SEMLDB_veriloga_converter/outputs/HFET/hfetva_idvd_siv_add.txt", "r");
      for(i=0; i<900; i=i+1) count_tmp = $fscanf(fd, "%e", idvd_siv_add[i]);
      $fclose(fd);
      fd = $fopen("C:/Users/ta688/UF Dropbox/PC/VerilogA/verilogA_v2/SEMLDB_veriloga_converter/outputs/HFET/hfetva_idvg_sx_mul.txt", "r");
      for(i=0; i<7; i=i+1) count_tmp = $fscanf(fd, "%e", idvg_sx_mul[i]);
      $fclose(fd);
      fd = $fopen("C:/Users/ta688/UF Dropbox/PC/VerilogA/verilogA_v2/SEMLDB_veriloga_converter/outputs/HFET/hfetva_idvg_sx_add.txt", "r");
      for(i=0; i<7; i=i+1) count_tmp = $fscanf(fd, "%e", idvg_sx_add[i]);
      $fclose(fd);
      fd = $fopen("C:/Users/ta688/UF Dropbox/PC/VerilogA/verilogA_v2/SEMLDB_veriloga_converter/outputs/HFET/hfetva_idvg_sl_mul.txt", "r");
      for(i=0; i<20; i=i+1) count_tmp = $fscanf(fd, "%e", idvg_sl_mul[i]);
      $fclose(fd);
      fd = $fopen("C:/Users/ta688/UF Dropbox/PC/VerilogA/verilogA_v2/SEMLDB_veriloga_converter/outputs/HFET/hfetva_idvg_sl_add.txt", "r");
      for(i=0; i<20; i=i+1) count_tmp = $fscanf(fd, "%e", idvg_sl_add[i]);
      $fclose(fd);
      fd = $fopen("C:/Users/ta688/UF Dropbox/PC/VerilogA/verilogA_v2/SEMLDB_veriloga_converter/outputs/HFET/hfetva_idvg_siv_mul.txt", "r");
      for(i=0; i<892; i=i+1) count_tmp = $fscanf(fd, "%e", idvg_siv_mul[i]);
      $fclose(fd);
      fd = $fopen("C:/Users/ta688/UF Dropbox/PC/VerilogA/verilogA_v2/SEMLDB_veriloga_converter/outputs/HFET/hfetva_idvg_siv_add.txt", "r");
      for(i=0; i<892; i=i+1) count_tmp = $fscanf(fd, "%e", idvg_siv_add[i]);
      $fclose(fd);

      safe_halg = (hAlGaN > 1.0e-12) ? hAlGaN : 1.0e-12;
      if(hch > 0.019 * hch / safe_halg - 0.002) begin
        input_x[0] = Lsg * idvd_sx_mul[0] + idvd_sx_add[0];
        input_x[1] = Lgd * idvd_sx_mul[1] + idvd_sx_add[1];
        input_x[2] = Lg * idvd_sx_mul[2] + idvd_sx_add[2];
        input_x[3] = hpas * idvd_sx_mul[3] + idvd_sx_add[3];
        input_x[4] = hAlGaN * idvd_sx_mul[4] + idvd_sx_add[4];
        input_x[5] = hch * idvd_sx_mul[5] + idvd_sx_add[5];
        input_x[6] = hg * idvd_sx_mul[6] + idvd_sx_add[6];
        idvd_poly_feat[0] = 1.0;
        idvd_poly_feat[1] = pow(input_x[0], 1);
        idvd_poly_feat[2] = pow(input_x[1], 1);
        idvd_poly_feat[3] = pow(input_x[2], 1);
        idvd_poly_feat[4] = pow(input_x[3], 1);
        idvd_poly_feat[5] = pow(input_x[4], 1);
        idvd_poly_feat[6] = pow(input_x[5], 1);
        idvd_poly_feat[7] = pow(input_x[6], 1);
        idvd_poly_feat[8] = pow(input_x[0], 2);
        idvd_poly_feat[9] = pow(input_x[0], 1) * pow(input_x[1], 1);
        idvd_poly_feat[10] = pow(input_x[0], 1) * pow(input_x[2], 1);
        idvd_poly_feat[11] = pow(input_x[0], 1) * pow(input_x[3], 1);
        idvd_poly_feat[12] = pow(input_x[0], 1) * pow(input_x[4], 1);
        idvd_poly_feat[13] = pow(input_x[0], 1) * pow(input_x[5], 1);
        idvd_poly_feat[14] = pow(input_x[0], 1) * pow(input_x[6], 1);
        idvd_poly_feat[15] = pow(input_x[1], 2);
        idvd_poly_feat[16] = pow(input_x[1], 1) * pow(input_x[2], 1);
        idvd_poly_feat[17] = pow(input_x[1], 1) * pow(input_x[3], 1);
        idvd_poly_feat[18] = pow(input_x[1], 1) * pow(input_x[4], 1);
        idvd_poly_feat[19] = pow(input_x[1], 1) * pow(input_x[5], 1);
        idvd_poly_feat[20] = pow(input_x[1], 1) * pow(input_x[6], 1);
        idvd_poly_feat[21] = pow(input_x[2], 2);
        idvd_poly_feat[22] = pow(input_x[2], 1) * pow(input_x[3], 1);
        idvd_poly_feat[23] = pow(input_x[2], 1) * pow(input_x[4], 1);
        idvd_poly_feat[24] = pow(input_x[2], 1) * pow(input_x[5], 1);
        idvd_poly_feat[25] = pow(input_x[2], 1) * pow(input_x[6], 1);
        idvd_poly_feat[26] = pow(input_x[3], 2);
        idvd_poly_feat[27] = pow(input_x[3], 1) * pow(input_x[4], 1);
        idvd_poly_feat[28] = pow(input_x[3], 1) * pow(input_x[5], 1);
        idvd_poly_feat[29] = pow(input_x[3], 1) * pow(input_x[6], 1);
        idvd_poly_feat[30] = pow(input_x[4], 2);
        idvd_poly_feat[31] = pow(input_x[4], 1) * pow(input_x[5], 1);
        idvd_poly_feat[32] = pow(input_x[4], 1) * pow(input_x[6], 1);
        idvd_poly_feat[33] = pow(input_x[5], 2);
        idvd_poly_feat[34] = pow(input_x[5], 1) * pow(input_x[6], 1);
        idvd_poly_feat[35] = pow(input_x[6], 2);
        idvd_poly_feat[36] = pow(input_x[0], 3);
        idvd_poly_feat[37] = pow(input_x[0], 2) * pow(input_x[1], 1);
        idvd_poly_feat[38] = pow(input_x[0], 2) * pow(input_x[2], 1);
        idvd_poly_feat[39] = pow(input_x[0], 2) * pow(input_x[3], 1);
        idvd_poly_feat[40] = pow(input_x[0], 2) * pow(input_x[4], 1);
        idvd_poly_feat[41] = pow(input_x[0], 2) * pow(input_x[5], 1);
        idvd_poly_feat[42] = pow(input_x[0], 2) * pow(input_x[6], 1);
        idvd_poly_feat[43] = pow(input_x[0], 1) * pow(input_x[1], 2);
        idvd_poly_feat[44] = pow(input_x[0], 1) * pow(input_x[1], 1) * pow(input_x[2], 1);
        idvd_poly_feat[45] = pow(input_x[0], 1) * pow(input_x[1], 1) * pow(input_x[3], 1);
        idvd_poly_feat[46] = pow(input_x[0], 1) * pow(input_x[1], 1) * pow(input_x[4], 1);
        idvd_poly_feat[47] = pow(input_x[0], 1) * pow(input_x[1], 1) * pow(input_x[5], 1);
        idvd_poly_feat[48] = pow(input_x[0], 1) * pow(input_x[1], 1) * pow(input_x[6], 1);
        idvd_poly_feat[49] = pow(input_x[0], 1) * pow(input_x[2], 2);
        idvd_poly_feat[50] = pow(input_x[0], 1) * pow(input_x[2], 1) * pow(input_x[3], 1);
        idvd_poly_feat[51] = pow(input_x[0], 1) * pow(input_x[2], 1) * pow(input_x[4], 1);
        idvd_poly_feat[52] = pow(input_x[0], 1) * pow(input_x[2], 1) * pow(input_x[5], 1);
        idvd_poly_feat[53] = pow(input_x[0], 1) * pow(input_x[2], 1) * pow(input_x[6], 1);
        idvd_poly_feat[54] = pow(input_x[0], 1) * pow(input_x[3], 2);
        idvd_poly_feat[55] = pow(input_x[0], 1) * pow(input_x[3], 1) * pow(input_x[4], 1);
        idvd_poly_feat[56] = pow(input_x[0], 1) * pow(input_x[3], 1) * pow(input_x[5], 1);
        idvd_poly_feat[57] = pow(input_x[0], 1) * pow(input_x[3], 1) * pow(input_x[6], 1);
        idvd_poly_feat[58] = pow(input_x[0], 1) * pow(input_x[4], 2);
        idvd_poly_feat[59] = pow(input_x[0], 1) * pow(input_x[4], 1) * pow(input_x[5], 1);
        idvd_poly_feat[60] = pow(input_x[0], 1) * pow(input_x[4], 1) * pow(input_x[6], 1);
        idvd_poly_feat[61] = pow(input_x[0], 1) * pow(input_x[5], 2);
        idvd_poly_feat[62] = pow(input_x[0], 1) * pow(input_x[5], 1) * pow(input_x[6], 1);
        idvd_poly_feat[63] = pow(input_x[0], 1) * pow(input_x[6], 2);
        idvd_poly_feat[64] = pow(input_x[1], 3);
        idvd_poly_feat[65] = pow(input_x[1], 2) * pow(input_x[2], 1);
        idvd_poly_feat[66] = pow(input_x[1], 2) * pow(input_x[3], 1);
        idvd_poly_feat[67] = pow(input_x[1], 2) * pow(input_x[4], 1);
        idvd_poly_feat[68] = pow(input_x[1], 2) * pow(input_x[5], 1);
        idvd_poly_feat[69] = pow(input_x[1], 2) * pow(input_x[6], 1);
        idvd_poly_feat[70] = pow(input_x[1], 1) * pow(input_x[2], 2);
        idvd_poly_feat[71] = pow(input_x[1], 1) * pow(input_x[2], 1) * pow(input_x[3], 1);
        idvd_poly_feat[72] = pow(input_x[1], 1) * pow(input_x[2], 1) * pow(input_x[4], 1);
        idvd_poly_feat[73] = pow(input_x[1], 1) * pow(input_x[2], 1) * pow(input_x[5], 1);
        idvd_poly_feat[74] = pow(input_x[1], 1) * pow(input_x[2], 1) * pow(input_x[6], 1);
        idvd_poly_feat[75] = pow(input_x[1], 1) * pow(input_x[3], 2);
        idvd_poly_feat[76] = pow(input_x[1], 1) * pow(input_x[3], 1) * pow(input_x[4], 1);
        idvd_poly_feat[77] = pow(input_x[1], 1) * pow(input_x[3], 1) * pow(input_x[5], 1);
        idvd_poly_feat[78] = pow(input_x[1], 1) * pow(input_x[3], 1) * pow(input_x[6], 1);
        idvd_poly_feat[79] = pow(input_x[1], 1) * pow(input_x[4], 2);
        idvd_poly_feat[80] = pow(input_x[1], 1) * pow(input_x[4], 1) * pow(input_x[5], 1);
        idvd_poly_feat[81] = pow(input_x[1], 1) * pow(input_x[4], 1) * pow(input_x[6], 1);
        idvd_poly_feat[82] = pow(input_x[1], 1) * pow(input_x[5], 2);
        idvd_poly_feat[83] = pow(input_x[1], 1) * pow(input_x[5], 1) * pow(input_x[6], 1);
        idvd_poly_feat[84] = pow(input_x[1], 1) * pow(input_x[6], 2);
        idvd_poly_feat[85] = pow(input_x[2], 3);
        idvd_poly_feat[86] = pow(input_x[2], 2) * pow(input_x[3], 1);
        idvd_poly_feat[87] = pow(input_x[2], 2) * pow(input_x[4], 1);
        idvd_poly_feat[88] = pow(input_x[2], 2) * pow(input_x[5], 1);
        idvd_poly_feat[89] = pow(input_x[2], 2) * pow(input_x[6], 1);
        idvd_poly_feat[90] = pow(input_x[2], 1) * pow(input_x[3], 2);
        idvd_poly_feat[91] = pow(input_x[2], 1) * pow(input_x[3], 1) * pow(input_x[4], 1);
        idvd_poly_feat[92] = pow(input_x[2], 1) * pow(input_x[3], 1) * pow(input_x[5], 1);
        idvd_poly_feat[93] = pow(input_x[2], 1) * pow(input_x[3], 1) * pow(input_x[6], 1);
        idvd_poly_feat[94] = pow(input_x[2], 1) * pow(input_x[4], 2);
        idvd_poly_feat[95] = pow(input_x[2], 1) * pow(input_x[4], 1) * pow(input_x[5], 1);
        idvd_poly_feat[96] = pow(input_x[2], 1) * pow(input_x[4], 1) * pow(input_x[6], 1);
        idvd_poly_feat[97] = pow(input_x[2], 1) * pow(input_x[5], 2);
        idvd_poly_feat[98] = pow(input_x[2], 1) * pow(input_x[5], 1) * pow(input_x[6], 1);
        idvd_poly_feat[99] = pow(input_x[2], 1) * pow(input_x[6], 2);
        idvd_poly_feat[100] = pow(input_x[3], 3);
        idvd_poly_feat[101] = pow(input_x[3], 2) * pow(input_x[4], 1);
        idvd_poly_feat[102] = pow(input_x[3], 2) * pow(input_x[5], 1);
        idvd_poly_feat[103] = pow(input_x[3], 2) * pow(input_x[6], 1);
        idvd_poly_feat[104] = pow(input_x[3], 1) * pow(input_x[4], 2);
        idvd_poly_feat[105] = pow(input_x[3], 1) * pow(input_x[4], 1) * pow(input_x[5], 1);
        idvd_poly_feat[106] = pow(input_x[3], 1) * pow(input_x[4], 1) * pow(input_x[6], 1);
        idvd_poly_feat[107] = pow(input_x[3], 1) * pow(input_x[5], 2);
        idvd_poly_feat[108] = pow(input_x[3], 1) * pow(input_x[5], 1) * pow(input_x[6], 1);
        idvd_poly_feat[109] = pow(input_x[3], 1) * pow(input_x[6], 2);
        idvd_poly_feat[110] = pow(input_x[4], 3);
        idvd_poly_feat[111] = pow(input_x[4], 2) * pow(input_x[5], 1);
        idvd_poly_feat[112] = pow(input_x[4], 2) * pow(input_x[6], 1);
        idvd_poly_feat[113] = pow(input_x[4], 1) * pow(input_x[5], 2);
        idvd_poly_feat[114] = pow(input_x[4], 1) * pow(input_x[5], 1) * pow(input_x[6], 1);
        idvd_poly_feat[115] = pow(input_x[4], 1) * pow(input_x[6], 2);
        idvd_poly_feat[116] = pow(input_x[5], 3);
        idvd_poly_feat[117] = pow(input_x[5], 2) * pow(input_x[6], 1);
        idvd_poly_feat[118] = pow(input_x[5], 1) * pow(input_x[6], 2);
        idvd_poly_feat[119] = pow(input_x[6], 3);
        idvd_poly_feat[120] = pow(input_x[0], 4);
        idvd_poly_feat[121] = pow(input_x[0], 3) * pow(input_x[1], 1);
        idvd_poly_feat[122] = pow(input_x[0], 3) * pow(input_x[2], 1);
        idvd_poly_feat[123] = pow(input_x[0], 3) * pow(input_x[3], 1);
        idvd_poly_feat[124] = pow(input_x[0], 3) * pow(input_x[4], 1);
        idvd_poly_feat[125] = pow(input_x[0], 3) * pow(input_x[5], 1);
        idvd_poly_feat[126] = pow(input_x[0], 3) * pow(input_x[6], 1);
        idvd_poly_feat[127] = pow(input_x[0], 2) * pow(input_x[1], 2);
        idvd_poly_feat[128] = pow(input_x[0], 2) * pow(input_x[1], 1) * pow(input_x[2], 1);
        idvd_poly_feat[129] = pow(input_x[0], 2) * pow(input_x[1], 1) * pow(input_x[3], 1);
        idvd_poly_feat[130] = pow(input_x[0], 2) * pow(input_x[1], 1) * pow(input_x[4], 1);
        idvd_poly_feat[131] = pow(input_x[0], 2) * pow(input_x[1], 1) * pow(input_x[5], 1);
        idvd_poly_feat[132] = pow(input_x[0], 2) * pow(input_x[1], 1) * pow(input_x[6], 1);
        idvd_poly_feat[133] = pow(input_x[0], 2) * pow(input_x[2], 2);
        idvd_poly_feat[134] = pow(input_x[0], 2) * pow(input_x[2], 1) * pow(input_x[3], 1);
        idvd_poly_feat[135] = pow(input_x[0], 2) * pow(input_x[2], 1) * pow(input_x[4], 1);
        idvd_poly_feat[136] = pow(input_x[0], 2) * pow(input_x[2], 1) * pow(input_x[5], 1);
        idvd_poly_feat[137] = pow(input_x[0], 2) * pow(input_x[2], 1) * pow(input_x[6], 1);
        idvd_poly_feat[138] = pow(input_x[0], 2) * pow(input_x[3], 2);
        idvd_poly_feat[139] = pow(input_x[0], 2) * pow(input_x[3], 1) * pow(input_x[4], 1);
        idvd_poly_feat[140] = pow(input_x[0], 2) * pow(input_x[3], 1) * pow(input_x[5], 1);
        idvd_poly_feat[141] = pow(input_x[0], 2) * pow(input_x[3], 1) * pow(input_x[6], 1);
        idvd_poly_feat[142] = pow(input_x[0], 2) * pow(input_x[4], 2);
        idvd_poly_feat[143] = pow(input_x[0], 2) * pow(input_x[4], 1) * pow(input_x[5], 1);
        idvd_poly_feat[144] = pow(input_x[0], 2) * pow(input_x[4], 1) * pow(input_x[6], 1);
        idvd_poly_feat[145] = pow(input_x[0], 2) * pow(input_x[5], 2);
        idvd_poly_feat[146] = pow(input_x[0], 2) * pow(input_x[5], 1) * pow(input_x[6], 1);
        idvd_poly_feat[147] = pow(input_x[0], 2) * pow(input_x[6], 2);
        idvd_poly_feat[148] = pow(input_x[0], 1) * pow(input_x[1], 3);
        idvd_poly_feat[149] = pow(input_x[0], 1) * pow(input_x[1], 2) * pow(input_x[2], 1);
        idvd_poly_feat[150] = pow(input_x[0], 1) * pow(input_x[1], 2) * pow(input_x[3], 1);
        idvd_poly_feat[151] = pow(input_x[0], 1) * pow(input_x[1], 2) * pow(input_x[4], 1);
        idvd_poly_feat[152] = pow(input_x[0], 1) * pow(input_x[1], 2) * pow(input_x[5], 1);
        idvd_poly_feat[153] = pow(input_x[0], 1) * pow(input_x[1], 2) * pow(input_x[6], 1);
        idvd_poly_feat[154] = pow(input_x[0], 1) * pow(input_x[1], 1) * pow(input_x[2], 2);
        idvd_poly_feat[155] = pow(input_x[0], 1) * pow(input_x[1], 1) * pow(input_x[2], 1) * pow(input_x[3], 1);
        idvd_poly_feat[156] = pow(input_x[0], 1) * pow(input_x[1], 1) * pow(input_x[2], 1) * pow(input_x[4], 1);
        idvd_poly_feat[157] = pow(input_x[0], 1) * pow(input_x[1], 1) * pow(input_x[2], 1) * pow(input_x[5], 1);
        idvd_poly_feat[158] = pow(input_x[0], 1) * pow(input_x[1], 1) * pow(input_x[2], 1) * pow(input_x[6], 1);
        idvd_poly_feat[159] = pow(input_x[0], 1) * pow(input_x[1], 1) * pow(input_x[3], 2);
        idvd_poly_feat[160] = pow(input_x[0], 1) * pow(input_x[1], 1) * pow(input_x[3], 1) * pow(input_x[4], 1);
        idvd_poly_feat[161] = pow(input_x[0], 1) * pow(input_x[1], 1) * pow(input_x[3], 1) * pow(input_x[5], 1);
        idvd_poly_feat[162] = pow(input_x[0], 1) * pow(input_x[1], 1) * pow(input_x[3], 1) * pow(input_x[6], 1);
        idvd_poly_feat[163] = pow(input_x[0], 1) * pow(input_x[1], 1) * pow(input_x[4], 2);
        idvd_poly_feat[164] = pow(input_x[0], 1) * pow(input_x[1], 1) * pow(input_x[4], 1) * pow(input_x[5], 1);
        idvd_poly_feat[165] = pow(input_x[0], 1) * pow(input_x[1], 1) * pow(input_x[4], 1) * pow(input_x[6], 1);
        idvd_poly_feat[166] = pow(input_x[0], 1) * pow(input_x[1], 1) * pow(input_x[5], 2);
        idvd_poly_feat[167] = pow(input_x[0], 1) * pow(input_x[1], 1) * pow(input_x[5], 1) * pow(input_x[6], 1);
        idvd_poly_feat[168] = pow(input_x[0], 1) * pow(input_x[1], 1) * pow(input_x[6], 2);
        idvd_poly_feat[169] = pow(input_x[0], 1) * pow(input_x[2], 3);
        idvd_poly_feat[170] = pow(input_x[0], 1) * pow(input_x[2], 2) * pow(input_x[3], 1);
        idvd_poly_feat[171] = pow(input_x[0], 1) * pow(input_x[2], 2) * pow(input_x[4], 1);
        idvd_poly_feat[172] = pow(input_x[0], 1) * pow(input_x[2], 2) * pow(input_x[5], 1);
        idvd_poly_feat[173] = pow(input_x[0], 1) * pow(input_x[2], 2) * pow(input_x[6], 1);
        idvd_poly_feat[174] = pow(input_x[0], 1) * pow(input_x[2], 1) * pow(input_x[3], 2);
        idvd_poly_feat[175] = pow(input_x[0], 1) * pow(input_x[2], 1) * pow(input_x[3], 1) * pow(input_x[4], 1);
        idvd_poly_feat[176] = pow(input_x[0], 1) * pow(input_x[2], 1) * pow(input_x[3], 1) * pow(input_x[5], 1);
        idvd_poly_feat[177] = pow(input_x[0], 1) * pow(input_x[2], 1) * pow(input_x[3], 1) * pow(input_x[6], 1);
        idvd_poly_feat[178] = pow(input_x[0], 1) * pow(input_x[2], 1) * pow(input_x[4], 2);
        idvd_poly_feat[179] = pow(input_x[0], 1) * pow(input_x[2], 1) * pow(input_x[4], 1) * pow(input_x[5], 1);
        idvd_poly_feat[180] = pow(input_x[0], 1) * pow(input_x[2], 1) * pow(input_x[4], 1) * pow(input_x[6], 1);
        idvd_poly_feat[181] = pow(input_x[0], 1) * pow(input_x[2], 1) * pow(input_x[5], 2);
        idvd_poly_feat[182] = pow(input_x[0], 1) * pow(input_x[2], 1) * pow(input_x[5], 1) * pow(input_x[6], 1);
        idvd_poly_feat[183] = pow(input_x[0], 1) * pow(input_x[2], 1) * pow(input_x[6], 2);
        idvd_poly_feat[184] = pow(input_x[0], 1) * pow(input_x[3], 3);
        idvd_poly_feat[185] = pow(input_x[0], 1) * pow(input_x[3], 2) * pow(input_x[4], 1);
        idvd_poly_feat[186] = pow(input_x[0], 1) * pow(input_x[3], 2) * pow(input_x[5], 1);
        idvd_poly_feat[187] = pow(input_x[0], 1) * pow(input_x[3], 2) * pow(input_x[6], 1);
        idvd_poly_feat[188] = pow(input_x[0], 1) * pow(input_x[3], 1) * pow(input_x[4], 2);
        idvd_poly_feat[189] = pow(input_x[0], 1) * pow(input_x[3], 1) * pow(input_x[4], 1) * pow(input_x[5], 1);
        idvd_poly_feat[190] = pow(input_x[0], 1) * pow(input_x[3], 1) * pow(input_x[4], 1) * pow(input_x[6], 1);
        idvd_poly_feat[191] = pow(input_x[0], 1) * pow(input_x[3], 1) * pow(input_x[5], 2);
        idvd_poly_feat[192] = pow(input_x[0], 1) * pow(input_x[3], 1) * pow(input_x[5], 1) * pow(input_x[6], 1);
        idvd_poly_feat[193] = pow(input_x[0], 1) * pow(input_x[3], 1) * pow(input_x[6], 2);
        idvd_poly_feat[194] = pow(input_x[0], 1) * pow(input_x[4], 3);
        idvd_poly_feat[195] = pow(input_x[0], 1) * pow(input_x[4], 2) * pow(input_x[5], 1);
        idvd_poly_feat[196] = pow(input_x[0], 1) * pow(input_x[4], 2) * pow(input_x[6], 1);
        idvd_poly_feat[197] = pow(input_x[0], 1) * pow(input_x[4], 1) * pow(input_x[5], 2);
        idvd_poly_feat[198] = pow(input_x[0], 1) * pow(input_x[4], 1) * pow(input_x[5], 1) * pow(input_x[6], 1);
        idvd_poly_feat[199] = pow(input_x[0], 1) * pow(input_x[4], 1) * pow(input_x[6], 2);
        idvd_poly_feat[200] = pow(input_x[0], 1) * pow(input_x[5], 3);
        idvd_poly_feat[201] = pow(input_x[0], 1) * pow(input_x[5], 2) * pow(input_x[6], 1);
        idvd_poly_feat[202] = pow(input_x[0], 1) * pow(input_x[5], 1) * pow(input_x[6], 2);
        idvd_poly_feat[203] = pow(input_x[0], 1) * pow(input_x[6], 3);
        idvd_poly_feat[204] = pow(input_x[1], 4);
        idvd_poly_feat[205] = pow(input_x[1], 3) * pow(input_x[2], 1);
        idvd_poly_feat[206] = pow(input_x[1], 3) * pow(input_x[3], 1);
        idvd_poly_feat[207] = pow(input_x[1], 3) * pow(input_x[4], 1);
        idvd_poly_feat[208] = pow(input_x[1], 3) * pow(input_x[5], 1);
        idvd_poly_feat[209] = pow(input_x[1], 3) * pow(input_x[6], 1);
        idvd_poly_feat[210] = pow(input_x[1], 2) * pow(input_x[2], 2);
        idvd_poly_feat[211] = pow(input_x[1], 2) * pow(input_x[2], 1) * pow(input_x[3], 1);
        idvd_poly_feat[212] = pow(input_x[1], 2) * pow(input_x[2], 1) * pow(input_x[4], 1);
        idvd_poly_feat[213] = pow(input_x[1], 2) * pow(input_x[2], 1) * pow(input_x[5], 1);
        idvd_poly_feat[214] = pow(input_x[1], 2) * pow(input_x[2], 1) * pow(input_x[6], 1);
        idvd_poly_feat[215] = pow(input_x[1], 2) * pow(input_x[3], 2);
        idvd_poly_feat[216] = pow(input_x[1], 2) * pow(input_x[3], 1) * pow(input_x[4], 1);
        idvd_poly_feat[217] = pow(input_x[1], 2) * pow(input_x[3], 1) * pow(input_x[5], 1);
        idvd_poly_feat[218] = pow(input_x[1], 2) * pow(input_x[3], 1) * pow(input_x[6], 1);
        idvd_poly_feat[219] = pow(input_x[1], 2) * pow(input_x[4], 2);
        idvd_poly_feat[220] = pow(input_x[1], 2) * pow(input_x[4], 1) * pow(input_x[5], 1);
        idvd_poly_feat[221] = pow(input_x[1], 2) * pow(input_x[4], 1) * pow(input_x[6], 1);
        idvd_poly_feat[222] = pow(input_x[1], 2) * pow(input_x[5], 2);
        idvd_poly_feat[223] = pow(input_x[1], 2) * pow(input_x[5], 1) * pow(input_x[6], 1);
        idvd_poly_feat[224] = pow(input_x[1], 2) * pow(input_x[6], 2);
        idvd_poly_feat[225] = pow(input_x[1], 1) * pow(input_x[2], 3);
        idvd_poly_feat[226] = pow(input_x[1], 1) * pow(input_x[2], 2) * pow(input_x[3], 1);
        idvd_poly_feat[227] = pow(input_x[1], 1) * pow(input_x[2], 2) * pow(input_x[4], 1);
        idvd_poly_feat[228] = pow(input_x[1], 1) * pow(input_x[2], 2) * pow(input_x[5], 1);
        idvd_poly_feat[229] = pow(input_x[1], 1) * pow(input_x[2], 2) * pow(input_x[6], 1);
        idvd_poly_feat[230] = pow(input_x[1], 1) * pow(input_x[2], 1) * pow(input_x[3], 2);
        idvd_poly_feat[231] = pow(input_x[1], 1) * pow(input_x[2], 1) * pow(input_x[3], 1) * pow(input_x[4], 1);
        idvd_poly_feat[232] = pow(input_x[1], 1) * pow(input_x[2], 1) * pow(input_x[3], 1) * pow(input_x[5], 1);
        idvd_poly_feat[233] = pow(input_x[1], 1) * pow(input_x[2], 1) * pow(input_x[3], 1) * pow(input_x[6], 1);
        idvd_poly_feat[234] = pow(input_x[1], 1) * pow(input_x[2], 1) * pow(input_x[4], 2);
        idvd_poly_feat[235] = pow(input_x[1], 1) * pow(input_x[2], 1) * pow(input_x[4], 1) * pow(input_x[5], 1);
        idvd_poly_feat[236] = pow(input_x[1], 1) * pow(input_x[2], 1) * pow(input_x[4], 1) * pow(input_x[6], 1);
        idvd_poly_feat[237] = pow(input_x[1], 1) * pow(input_x[2], 1) * pow(input_x[5], 2);
        idvd_poly_feat[238] = pow(input_x[1], 1) * pow(input_x[2], 1) * pow(input_x[5], 1) * pow(input_x[6], 1);
        idvd_poly_feat[239] = pow(input_x[1], 1) * pow(input_x[2], 1) * pow(input_x[6], 2);
        idvd_poly_feat[240] = pow(input_x[1], 1) * pow(input_x[3], 3);
        idvd_poly_feat[241] = pow(input_x[1], 1) * pow(input_x[3], 2) * pow(input_x[4], 1);
        idvd_poly_feat[242] = pow(input_x[1], 1) * pow(input_x[3], 2) * pow(input_x[5], 1);
        idvd_poly_feat[243] = pow(input_x[1], 1) * pow(input_x[3], 2) * pow(input_x[6], 1);
        idvd_poly_feat[244] = pow(input_x[1], 1) * pow(input_x[3], 1) * pow(input_x[4], 2);
        idvd_poly_feat[245] = pow(input_x[1], 1) * pow(input_x[3], 1) * pow(input_x[4], 1) * pow(input_x[5], 1);
        idvd_poly_feat[246] = pow(input_x[1], 1) * pow(input_x[3], 1) * pow(input_x[4], 1) * pow(input_x[6], 1);
        idvd_poly_feat[247] = pow(input_x[1], 1) * pow(input_x[3], 1) * pow(input_x[5], 2);
        idvd_poly_feat[248] = pow(input_x[1], 1) * pow(input_x[3], 1) * pow(input_x[5], 1) * pow(input_x[6], 1);
        idvd_poly_feat[249] = pow(input_x[1], 1) * pow(input_x[3], 1) * pow(input_x[6], 2);
        idvd_poly_feat[250] = pow(input_x[1], 1) * pow(input_x[4], 3);
        idvd_poly_feat[251] = pow(input_x[1], 1) * pow(input_x[4], 2) * pow(input_x[5], 1);
        idvd_poly_feat[252] = pow(input_x[1], 1) * pow(input_x[4], 2) * pow(input_x[6], 1);
        idvd_poly_feat[253] = pow(input_x[1], 1) * pow(input_x[4], 1) * pow(input_x[5], 2);
        idvd_poly_feat[254] = pow(input_x[1], 1) * pow(input_x[4], 1) * pow(input_x[5], 1) * pow(input_x[6], 1);
        idvd_poly_feat[255] = pow(input_x[1], 1) * pow(input_x[4], 1) * pow(input_x[6], 2);
        idvd_poly_feat[256] = pow(input_x[1], 1) * pow(input_x[5], 3);
        idvd_poly_feat[257] = pow(input_x[1], 1) * pow(input_x[5], 2) * pow(input_x[6], 1);
        idvd_poly_feat[258] = pow(input_x[1], 1) * pow(input_x[5], 1) * pow(input_x[6], 2);
        idvd_poly_feat[259] = pow(input_x[1], 1) * pow(input_x[6], 3);
        idvd_poly_feat[260] = pow(input_x[2], 4);
        idvd_poly_feat[261] = pow(input_x[2], 3) * pow(input_x[3], 1);
        idvd_poly_feat[262] = pow(input_x[2], 3) * pow(input_x[4], 1);
        idvd_poly_feat[263] = pow(input_x[2], 3) * pow(input_x[5], 1);
        idvd_poly_feat[264] = pow(input_x[2], 3) * pow(input_x[6], 1);
        idvd_poly_feat[265] = pow(input_x[2], 2) * pow(input_x[3], 2);
        idvd_poly_feat[266] = pow(input_x[2], 2) * pow(input_x[3], 1) * pow(input_x[4], 1);
        idvd_poly_feat[267] = pow(input_x[2], 2) * pow(input_x[3], 1) * pow(input_x[5], 1);
        idvd_poly_feat[268] = pow(input_x[2], 2) * pow(input_x[3], 1) * pow(input_x[6], 1);
        idvd_poly_feat[269] = pow(input_x[2], 2) * pow(input_x[4], 2);
        idvd_poly_feat[270] = pow(input_x[2], 2) * pow(input_x[4], 1) * pow(input_x[5], 1);
        idvd_poly_feat[271] = pow(input_x[2], 2) * pow(input_x[4], 1) * pow(input_x[6], 1);
        idvd_poly_feat[272] = pow(input_x[2], 2) * pow(input_x[5], 2);
        idvd_poly_feat[273] = pow(input_x[2], 2) * pow(input_x[5], 1) * pow(input_x[6], 1);
        idvd_poly_feat[274] = pow(input_x[2], 2) * pow(input_x[6], 2);
        idvd_poly_feat[275] = pow(input_x[2], 1) * pow(input_x[3], 3);
        idvd_poly_feat[276] = pow(input_x[2], 1) * pow(input_x[3], 2) * pow(input_x[4], 1);
        idvd_poly_feat[277] = pow(input_x[2], 1) * pow(input_x[3], 2) * pow(input_x[5], 1);
        idvd_poly_feat[278] = pow(input_x[2], 1) * pow(input_x[3], 2) * pow(input_x[6], 1);
        idvd_poly_feat[279] = pow(input_x[2], 1) * pow(input_x[3], 1) * pow(input_x[4], 2);
        idvd_poly_feat[280] = pow(input_x[2], 1) * pow(input_x[3], 1) * pow(input_x[4], 1) * pow(input_x[5], 1);
        idvd_poly_feat[281] = pow(input_x[2], 1) * pow(input_x[3], 1) * pow(input_x[4], 1) * pow(input_x[6], 1);
        idvd_poly_feat[282] = pow(input_x[2], 1) * pow(input_x[3], 1) * pow(input_x[5], 2);
        idvd_poly_feat[283] = pow(input_x[2], 1) * pow(input_x[3], 1) * pow(input_x[5], 1) * pow(input_x[6], 1);
        idvd_poly_feat[284] = pow(input_x[2], 1) * pow(input_x[3], 1) * pow(input_x[6], 2);
        idvd_poly_feat[285] = pow(input_x[2], 1) * pow(input_x[4], 3);
        idvd_poly_feat[286] = pow(input_x[2], 1) * pow(input_x[4], 2) * pow(input_x[5], 1);
        idvd_poly_feat[287] = pow(input_x[2], 1) * pow(input_x[4], 2) * pow(input_x[6], 1);
        idvd_poly_feat[288] = pow(input_x[2], 1) * pow(input_x[4], 1) * pow(input_x[5], 2);
        idvd_poly_feat[289] = pow(input_x[2], 1) * pow(input_x[4], 1) * pow(input_x[5], 1) * pow(input_x[6], 1);
        idvd_poly_feat[290] = pow(input_x[2], 1) * pow(input_x[4], 1) * pow(input_x[6], 2);
        idvd_poly_feat[291] = pow(input_x[2], 1) * pow(input_x[5], 3);
        idvd_poly_feat[292] = pow(input_x[2], 1) * pow(input_x[5], 2) * pow(input_x[6], 1);
        idvd_poly_feat[293] = pow(input_x[2], 1) * pow(input_x[5], 1) * pow(input_x[6], 2);
        idvd_poly_feat[294] = pow(input_x[2], 1) * pow(input_x[6], 3);
        idvd_poly_feat[295] = pow(input_x[3], 4);
        idvd_poly_feat[296] = pow(input_x[3], 3) * pow(input_x[4], 1);
        idvd_poly_feat[297] = pow(input_x[3], 3) * pow(input_x[5], 1);
        idvd_poly_feat[298] = pow(input_x[3], 3) * pow(input_x[6], 1);
        idvd_poly_feat[299] = pow(input_x[3], 2) * pow(input_x[4], 2);
        idvd_poly_feat[300] = pow(input_x[3], 2) * pow(input_x[4], 1) * pow(input_x[5], 1);
        idvd_poly_feat[301] = pow(input_x[3], 2) * pow(input_x[4], 1) * pow(input_x[6], 1);
        idvd_poly_feat[302] = pow(input_x[3], 2) * pow(input_x[5], 2);
        idvd_poly_feat[303] = pow(input_x[3], 2) * pow(input_x[5], 1) * pow(input_x[6], 1);
        idvd_poly_feat[304] = pow(input_x[3], 2) * pow(input_x[6], 2);
        idvd_poly_feat[305] = pow(input_x[3], 1) * pow(input_x[4], 3);
        idvd_poly_feat[306] = pow(input_x[3], 1) * pow(input_x[4], 2) * pow(input_x[5], 1);
        idvd_poly_feat[307] = pow(input_x[3], 1) * pow(input_x[4], 2) * pow(input_x[6], 1);
        idvd_poly_feat[308] = pow(input_x[3], 1) * pow(input_x[4], 1) * pow(input_x[5], 2);
        idvd_poly_feat[309] = pow(input_x[3], 1) * pow(input_x[4], 1) * pow(input_x[5], 1) * pow(input_x[6], 1);
        idvd_poly_feat[310] = pow(input_x[3], 1) * pow(input_x[4], 1) * pow(input_x[6], 2);
        idvd_poly_feat[311] = pow(input_x[3], 1) * pow(input_x[5], 3);
        idvd_poly_feat[312] = pow(input_x[3], 1) * pow(input_x[5], 2) * pow(input_x[6], 1);
        idvd_poly_feat[313] = pow(input_x[3], 1) * pow(input_x[5], 1) * pow(input_x[6], 2);
        idvd_poly_feat[314] = pow(input_x[3], 1) * pow(input_x[6], 3);
        idvd_poly_feat[315] = pow(input_x[4], 4);
        idvd_poly_feat[316] = pow(input_x[4], 3) * pow(input_x[5], 1);
        idvd_poly_feat[317] = pow(input_x[4], 3) * pow(input_x[6], 1);
        idvd_poly_feat[318] = pow(input_x[4], 2) * pow(input_x[5], 2);
        idvd_poly_feat[319] = pow(input_x[4], 2) * pow(input_x[5], 1) * pow(input_x[6], 1);
        idvd_poly_feat[320] = pow(input_x[4], 2) * pow(input_x[6], 2);
        idvd_poly_feat[321] = pow(input_x[4], 1) * pow(input_x[5], 3);
        idvd_poly_feat[322] = pow(input_x[4], 1) * pow(input_x[5], 2) * pow(input_x[6], 1);
        idvd_poly_feat[323] = pow(input_x[4], 1) * pow(input_x[5], 1) * pow(input_x[6], 2);
        idvd_poly_feat[324] = pow(input_x[4], 1) * pow(input_x[6], 3);
        idvd_poly_feat[325] = pow(input_x[5], 4);
        idvd_poly_feat[326] = pow(input_x[5], 3) * pow(input_x[6], 1);
        idvd_poly_feat[327] = pow(input_x[5], 2) * pow(input_x[6], 2);
        idvd_poly_feat[328] = pow(input_x[5], 1) * pow(input_x[6], 3);
        idvd_poly_feat[329] = pow(input_x[6], 4);
        idvd_poly_feat[330] = pow(input_x[0], 5);
        idvd_poly_feat[331] = pow(input_x[0], 4) * pow(input_x[1], 1);
        idvd_poly_feat[332] = pow(input_x[0], 4) * pow(input_x[2], 1);
        idvd_poly_feat[333] = pow(input_x[0], 4) * pow(input_x[3], 1);
        idvd_poly_feat[334] = pow(input_x[0], 4) * pow(input_x[4], 1);
        idvd_poly_feat[335] = pow(input_x[0], 4) * pow(input_x[5], 1);
        idvd_poly_feat[336] = pow(input_x[0], 4) * pow(input_x[6], 1);
        idvd_poly_feat[337] = pow(input_x[0], 3) * pow(input_x[1], 2);
        idvd_poly_feat[338] = pow(input_x[0], 3) * pow(input_x[1], 1) * pow(input_x[2], 1);
        idvd_poly_feat[339] = pow(input_x[0], 3) * pow(input_x[1], 1) * pow(input_x[3], 1);
        idvd_poly_feat[340] = pow(input_x[0], 3) * pow(input_x[1], 1) * pow(input_x[4], 1);
        idvd_poly_feat[341] = pow(input_x[0], 3) * pow(input_x[1], 1) * pow(input_x[5], 1);
        idvd_poly_feat[342] = pow(input_x[0], 3) * pow(input_x[1], 1) * pow(input_x[6], 1);
        idvd_poly_feat[343] = pow(input_x[0], 3) * pow(input_x[2], 2);
        idvd_poly_feat[344] = pow(input_x[0], 3) * pow(input_x[2], 1) * pow(input_x[3], 1);
        idvd_poly_feat[345] = pow(input_x[0], 3) * pow(input_x[2], 1) * pow(input_x[4], 1);
        idvd_poly_feat[346] = pow(input_x[0], 3) * pow(input_x[2], 1) * pow(input_x[5], 1);
        idvd_poly_feat[347] = pow(input_x[0], 3) * pow(input_x[2], 1) * pow(input_x[6], 1);
        idvd_poly_feat[348] = pow(input_x[0], 3) * pow(input_x[3], 2);
        idvd_poly_feat[349] = pow(input_x[0], 3) * pow(input_x[3], 1) * pow(input_x[4], 1);
        idvd_poly_feat[350] = pow(input_x[0], 3) * pow(input_x[3], 1) * pow(input_x[5], 1);
        idvd_poly_feat[351] = pow(input_x[0], 3) * pow(input_x[3], 1) * pow(input_x[6], 1);
        idvd_poly_feat[352] = pow(input_x[0], 3) * pow(input_x[4], 2);
        idvd_poly_feat[353] = pow(input_x[0], 3) * pow(input_x[4], 1) * pow(input_x[5], 1);
        idvd_poly_feat[354] = pow(input_x[0], 3) * pow(input_x[4], 1) * pow(input_x[6], 1);
        idvd_poly_feat[355] = pow(input_x[0], 3) * pow(input_x[5], 2);
        idvd_poly_feat[356] = pow(input_x[0], 3) * pow(input_x[5], 1) * pow(input_x[6], 1);
        idvd_poly_feat[357] = pow(input_x[0], 3) * pow(input_x[6], 2);
        idvd_poly_feat[358] = pow(input_x[0], 2) * pow(input_x[1], 3);
        idvd_poly_feat[359] = pow(input_x[0], 2) * pow(input_x[1], 2) * pow(input_x[2], 1);
        idvd_poly_feat[360] = pow(input_x[0], 2) * pow(input_x[1], 2) * pow(input_x[3], 1);
        idvd_poly_feat[361] = pow(input_x[0], 2) * pow(input_x[1], 2) * pow(input_x[4], 1);
        idvd_poly_feat[362] = pow(input_x[0], 2) * pow(input_x[1], 2) * pow(input_x[5], 1);
        idvd_poly_feat[363] = pow(input_x[0], 2) * pow(input_x[1], 2) * pow(input_x[6], 1);
        idvd_poly_feat[364] = pow(input_x[0], 2) * pow(input_x[1], 1) * pow(input_x[2], 2);
        idvd_poly_feat[365] = pow(input_x[0], 2) * pow(input_x[1], 1) * pow(input_x[2], 1) * pow(input_x[3], 1);
        idvd_poly_feat[366] = pow(input_x[0], 2) * pow(input_x[1], 1) * pow(input_x[2], 1) * pow(input_x[4], 1);
        idvd_poly_feat[367] = pow(input_x[0], 2) * pow(input_x[1], 1) * pow(input_x[2], 1) * pow(input_x[5], 1);
        idvd_poly_feat[368] = pow(input_x[0], 2) * pow(input_x[1], 1) * pow(input_x[2], 1) * pow(input_x[6], 1);
        idvd_poly_feat[369] = pow(input_x[0], 2) * pow(input_x[1], 1) * pow(input_x[3], 2);
        idvd_poly_feat[370] = pow(input_x[0], 2) * pow(input_x[1], 1) * pow(input_x[3], 1) * pow(input_x[4], 1);
        idvd_poly_feat[371] = pow(input_x[0], 2) * pow(input_x[1], 1) * pow(input_x[3], 1) * pow(input_x[5], 1);
        idvd_poly_feat[372] = pow(input_x[0], 2) * pow(input_x[1], 1) * pow(input_x[3], 1) * pow(input_x[6], 1);
        idvd_poly_feat[373] = pow(input_x[0], 2) * pow(input_x[1], 1) * pow(input_x[4], 2);
        idvd_poly_feat[374] = pow(input_x[0], 2) * pow(input_x[1], 1) * pow(input_x[4], 1) * pow(input_x[5], 1);
        idvd_poly_feat[375] = pow(input_x[0], 2) * pow(input_x[1], 1) * pow(input_x[4], 1) * pow(input_x[6], 1);
        idvd_poly_feat[376] = pow(input_x[0], 2) * pow(input_x[1], 1) * pow(input_x[5], 2);
        idvd_poly_feat[377] = pow(input_x[0], 2) * pow(input_x[1], 1) * pow(input_x[5], 1) * pow(input_x[6], 1);
        idvd_poly_feat[378] = pow(input_x[0], 2) * pow(input_x[1], 1) * pow(input_x[6], 2);
        idvd_poly_feat[379] = pow(input_x[0], 2) * pow(input_x[2], 3);
        idvd_poly_feat[380] = pow(input_x[0], 2) * pow(input_x[2], 2) * pow(input_x[3], 1);
        idvd_poly_feat[381] = pow(input_x[0], 2) * pow(input_x[2], 2) * pow(input_x[4], 1);
        idvd_poly_feat[382] = pow(input_x[0], 2) * pow(input_x[2], 2) * pow(input_x[5], 1);
        idvd_poly_feat[383] = pow(input_x[0], 2) * pow(input_x[2], 2) * pow(input_x[6], 1);
        idvd_poly_feat[384] = pow(input_x[0], 2) * pow(input_x[2], 1) * pow(input_x[3], 2);
        idvd_poly_feat[385] = pow(input_x[0], 2) * pow(input_x[2], 1) * pow(input_x[3], 1) * pow(input_x[4], 1);
        idvd_poly_feat[386] = pow(input_x[0], 2) * pow(input_x[2], 1) * pow(input_x[3], 1) * pow(input_x[5], 1);
        idvd_poly_feat[387] = pow(input_x[0], 2) * pow(input_x[2], 1) * pow(input_x[3], 1) * pow(input_x[6], 1);
        idvd_poly_feat[388] = pow(input_x[0], 2) * pow(input_x[2], 1) * pow(input_x[4], 2);
        idvd_poly_feat[389] = pow(input_x[0], 2) * pow(input_x[2], 1) * pow(input_x[4], 1) * pow(input_x[5], 1);
        idvd_poly_feat[390] = pow(input_x[0], 2) * pow(input_x[2], 1) * pow(input_x[4], 1) * pow(input_x[6], 1);
        idvd_poly_feat[391] = pow(input_x[0], 2) * pow(input_x[2], 1) * pow(input_x[5], 2);
        idvd_poly_feat[392] = pow(input_x[0], 2) * pow(input_x[2], 1) * pow(input_x[5], 1) * pow(input_x[6], 1);
        idvd_poly_feat[393] = pow(input_x[0], 2) * pow(input_x[2], 1) * pow(input_x[6], 2);
        idvd_poly_feat[394] = pow(input_x[0], 2) * pow(input_x[3], 3);
        idvd_poly_feat[395] = pow(input_x[0], 2) * pow(input_x[3], 2) * pow(input_x[4], 1);
        idvd_poly_feat[396] = pow(input_x[0], 2) * pow(input_x[3], 2) * pow(input_x[5], 1);
        idvd_poly_feat[397] = pow(input_x[0], 2) * pow(input_x[3], 2) * pow(input_x[6], 1);
        idvd_poly_feat[398] = pow(input_x[0], 2) * pow(input_x[3], 1) * pow(input_x[4], 2);
        idvd_poly_feat[399] = pow(input_x[0], 2) * pow(input_x[3], 1) * pow(input_x[4], 1) * pow(input_x[5], 1);
        idvd_poly_feat[400] = pow(input_x[0], 2) * pow(input_x[3], 1) * pow(input_x[4], 1) * pow(input_x[6], 1);
        idvd_poly_feat[401] = pow(input_x[0], 2) * pow(input_x[3], 1) * pow(input_x[5], 2);
        idvd_poly_feat[402] = pow(input_x[0], 2) * pow(input_x[3], 1) * pow(input_x[5], 1) * pow(input_x[6], 1);
        idvd_poly_feat[403] = pow(input_x[0], 2) * pow(input_x[3], 1) * pow(input_x[6], 2);
        idvd_poly_feat[404] = pow(input_x[0], 2) * pow(input_x[4], 3);
        idvd_poly_feat[405] = pow(input_x[0], 2) * pow(input_x[4], 2) * pow(input_x[5], 1);
        idvd_poly_feat[406] = pow(input_x[0], 2) * pow(input_x[4], 2) * pow(input_x[6], 1);
        idvd_poly_feat[407] = pow(input_x[0], 2) * pow(input_x[4], 1) * pow(input_x[5], 2);
        idvd_poly_feat[408] = pow(input_x[0], 2) * pow(input_x[4], 1) * pow(input_x[5], 1) * pow(input_x[6], 1);
        idvd_poly_feat[409] = pow(input_x[0], 2) * pow(input_x[4], 1) * pow(input_x[6], 2);
        idvd_poly_feat[410] = pow(input_x[0], 2) * pow(input_x[5], 3);
        idvd_poly_feat[411] = pow(input_x[0], 2) * pow(input_x[5], 2) * pow(input_x[6], 1);
        idvd_poly_feat[412] = pow(input_x[0], 2) * pow(input_x[5], 1) * pow(input_x[6], 2);
        idvd_poly_feat[413] = pow(input_x[0], 2) * pow(input_x[6], 3);
        idvd_poly_feat[414] = pow(input_x[0], 1) * pow(input_x[1], 4);
        idvd_poly_feat[415] = pow(input_x[0], 1) * pow(input_x[1], 3) * pow(input_x[2], 1);
        idvd_poly_feat[416] = pow(input_x[0], 1) * pow(input_x[1], 3) * pow(input_x[3], 1);
        idvd_poly_feat[417] = pow(input_x[0], 1) * pow(input_x[1], 3) * pow(input_x[4], 1);
        idvd_poly_feat[418] = pow(input_x[0], 1) * pow(input_x[1], 3) * pow(input_x[5], 1);
        idvd_poly_feat[419] = pow(input_x[0], 1) * pow(input_x[1], 3) * pow(input_x[6], 1);
        idvd_poly_feat[420] = pow(input_x[0], 1) * pow(input_x[1], 2) * pow(input_x[2], 2);
        idvd_poly_feat[421] = pow(input_x[0], 1) * pow(input_x[1], 2) * pow(input_x[2], 1) * pow(input_x[3], 1);
        idvd_poly_feat[422] = pow(input_x[0], 1) * pow(input_x[1], 2) * pow(input_x[2], 1) * pow(input_x[4], 1);
        idvd_poly_feat[423] = pow(input_x[0], 1) * pow(input_x[1], 2) * pow(input_x[2], 1) * pow(input_x[5], 1);
        idvd_poly_feat[424] = pow(input_x[0], 1) * pow(input_x[1], 2) * pow(input_x[2], 1) * pow(input_x[6], 1);
        idvd_poly_feat[425] = pow(input_x[0], 1) * pow(input_x[1], 2) * pow(input_x[3], 2);
        idvd_poly_feat[426] = pow(input_x[0], 1) * pow(input_x[1], 2) * pow(input_x[3], 1) * pow(input_x[4], 1);
        idvd_poly_feat[427] = pow(input_x[0], 1) * pow(input_x[1], 2) * pow(input_x[3], 1) * pow(input_x[5], 1);
        idvd_poly_feat[428] = pow(input_x[0], 1) * pow(input_x[1], 2) * pow(input_x[3], 1) * pow(input_x[6], 1);
        idvd_poly_feat[429] = pow(input_x[0], 1) * pow(input_x[1], 2) * pow(input_x[4], 2);
        idvd_poly_feat[430] = pow(input_x[0], 1) * pow(input_x[1], 2) * pow(input_x[4], 1) * pow(input_x[5], 1);
        idvd_poly_feat[431] = pow(input_x[0], 1) * pow(input_x[1], 2) * pow(input_x[4], 1) * pow(input_x[6], 1);
        idvd_poly_feat[432] = pow(input_x[0], 1) * pow(input_x[1], 2) * pow(input_x[5], 2);
        idvd_poly_feat[433] = pow(input_x[0], 1) * pow(input_x[1], 2) * pow(input_x[5], 1) * pow(input_x[6], 1);
        idvd_poly_feat[434] = pow(input_x[0], 1) * pow(input_x[1], 2) * pow(input_x[6], 2);
        idvd_poly_feat[435] = pow(input_x[0], 1) * pow(input_x[1], 1) * pow(input_x[2], 3);
        idvd_poly_feat[436] = pow(input_x[0], 1) * pow(input_x[1], 1) * pow(input_x[2], 2) * pow(input_x[3], 1);
        idvd_poly_feat[437] = pow(input_x[0], 1) * pow(input_x[1], 1) * pow(input_x[2], 2) * pow(input_x[4], 1);
        idvd_poly_feat[438] = pow(input_x[0], 1) * pow(input_x[1], 1) * pow(input_x[2], 2) * pow(input_x[5], 1);
        idvd_poly_feat[439] = pow(input_x[0], 1) * pow(input_x[1], 1) * pow(input_x[2], 2) * pow(input_x[6], 1);
        idvd_poly_feat[440] = pow(input_x[0], 1) * pow(input_x[1], 1) * pow(input_x[2], 1) * pow(input_x[3], 2);
        idvd_poly_feat[441] = pow(input_x[0], 1) * pow(input_x[1], 1) * pow(input_x[2], 1) * pow(input_x[3], 1) * pow(input_x[4], 1);
        idvd_poly_feat[442] = pow(input_x[0], 1) * pow(input_x[1], 1) * pow(input_x[2], 1) * pow(input_x[3], 1) * pow(input_x[5], 1);
        idvd_poly_feat[443] = pow(input_x[0], 1) * pow(input_x[1], 1) * pow(input_x[2], 1) * pow(input_x[3], 1) * pow(input_x[6], 1);
        idvd_poly_feat[444] = pow(input_x[0], 1) * pow(input_x[1], 1) * pow(input_x[2], 1) * pow(input_x[4], 2);
        idvd_poly_feat[445] = pow(input_x[0], 1) * pow(input_x[1], 1) * pow(input_x[2], 1) * pow(input_x[4], 1) * pow(input_x[5], 1);
        idvd_poly_feat[446] = pow(input_x[0], 1) * pow(input_x[1], 1) * pow(input_x[2], 1) * pow(input_x[4], 1) * pow(input_x[6], 1);
        idvd_poly_feat[447] = pow(input_x[0], 1) * pow(input_x[1], 1) * pow(input_x[2], 1) * pow(input_x[5], 2);
        idvd_poly_feat[448] = pow(input_x[0], 1) * pow(input_x[1], 1) * pow(input_x[2], 1) * pow(input_x[5], 1) * pow(input_x[6], 1);
        idvd_poly_feat[449] = pow(input_x[0], 1) * pow(input_x[1], 1) * pow(input_x[2], 1) * pow(input_x[6], 2);
        idvd_poly_feat[450] = pow(input_x[0], 1) * pow(input_x[1], 1) * pow(input_x[3], 3);
        idvd_poly_feat[451] = pow(input_x[0], 1) * pow(input_x[1], 1) * pow(input_x[3], 2) * pow(input_x[4], 1);
        idvd_poly_feat[452] = pow(input_x[0], 1) * pow(input_x[1], 1) * pow(input_x[3], 2) * pow(input_x[5], 1);
        idvd_poly_feat[453] = pow(input_x[0], 1) * pow(input_x[1], 1) * pow(input_x[3], 2) * pow(input_x[6], 1);
        idvd_poly_feat[454] = pow(input_x[0], 1) * pow(input_x[1], 1) * pow(input_x[3], 1) * pow(input_x[4], 2);
        idvd_poly_feat[455] = pow(input_x[0], 1) * pow(input_x[1], 1) * pow(input_x[3], 1) * pow(input_x[4], 1) * pow(input_x[5], 1);
        idvd_poly_feat[456] = pow(input_x[0], 1) * pow(input_x[1], 1) * pow(input_x[3], 1) * pow(input_x[4], 1) * pow(input_x[6], 1);
        idvd_poly_feat[457] = pow(input_x[0], 1) * pow(input_x[1], 1) * pow(input_x[3], 1) * pow(input_x[5], 2);
        idvd_poly_feat[458] = pow(input_x[0], 1) * pow(input_x[1], 1) * pow(input_x[3], 1) * pow(input_x[5], 1) * pow(input_x[6], 1);
        idvd_poly_feat[459] = pow(input_x[0], 1) * pow(input_x[1], 1) * pow(input_x[3], 1) * pow(input_x[6], 2);
        idvd_poly_feat[460] = pow(input_x[0], 1) * pow(input_x[1], 1) * pow(input_x[4], 3);
        idvd_poly_feat[461] = pow(input_x[0], 1) * pow(input_x[1], 1) * pow(input_x[4], 2) * pow(input_x[5], 1);
        idvd_poly_feat[462] = pow(input_x[0], 1) * pow(input_x[1], 1) * pow(input_x[4], 2) * pow(input_x[6], 1);
        idvd_poly_feat[463] = pow(input_x[0], 1) * pow(input_x[1], 1) * pow(input_x[4], 1) * pow(input_x[5], 2);
        idvd_poly_feat[464] = pow(input_x[0], 1) * pow(input_x[1], 1) * pow(input_x[4], 1) * pow(input_x[5], 1) * pow(input_x[6], 1);
        idvd_poly_feat[465] = pow(input_x[0], 1) * pow(input_x[1], 1) * pow(input_x[4], 1) * pow(input_x[6], 2);
        idvd_poly_feat[466] = pow(input_x[0], 1) * pow(input_x[1], 1) * pow(input_x[5], 3);
        idvd_poly_feat[467] = pow(input_x[0], 1) * pow(input_x[1], 1) * pow(input_x[5], 2) * pow(input_x[6], 1);
        idvd_poly_feat[468] = pow(input_x[0], 1) * pow(input_x[1], 1) * pow(input_x[5], 1) * pow(input_x[6], 2);
        idvd_poly_feat[469] = pow(input_x[0], 1) * pow(input_x[1], 1) * pow(input_x[6], 3);
        idvd_poly_feat[470] = pow(input_x[0], 1) * pow(input_x[2], 4);
        idvd_poly_feat[471] = pow(input_x[0], 1) * pow(input_x[2], 3) * pow(input_x[3], 1);
        idvd_poly_feat[472] = pow(input_x[0], 1) * pow(input_x[2], 3) * pow(input_x[4], 1);
        idvd_poly_feat[473] = pow(input_x[0], 1) * pow(input_x[2], 3) * pow(input_x[5], 1);
        idvd_poly_feat[474] = pow(input_x[0], 1) * pow(input_x[2], 3) * pow(input_x[6], 1);
        idvd_poly_feat[475] = pow(input_x[0], 1) * pow(input_x[2], 2) * pow(input_x[3], 2);
        idvd_poly_feat[476] = pow(input_x[0], 1) * pow(input_x[2], 2) * pow(input_x[3], 1) * pow(input_x[4], 1);
        idvd_poly_feat[477] = pow(input_x[0], 1) * pow(input_x[2], 2) * pow(input_x[3], 1) * pow(input_x[5], 1);
        idvd_poly_feat[478] = pow(input_x[0], 1) * pow(input_x[2], 2) * pow(input_x[3], 1) * pow(input_x[6], 1);
        idvd_poly_feat[479] = pow(input_x[0], 1) * pow(input_x[2], 2) * pow(input_x[4], 2);
        idvd_poly_feat[480] = pow(input_x[0], 1) * pow(input_x[2], 2) * pow(input_x[4], 1) * pow(input_x[5], 1);
        idvd_poly_feat[481] = pow(input_x[0], 1) * pow(input_x[2], 2) * pow(input_x[4], 1) * pow(input_x[6], 1);
        idvd_poly_feat[482] = pow(input_x[0], 1) * pow(input_x[2], 2) * pow(input_x[5], 2);
        idvd_poly_feat[483] = pow(input_x[0], 1) * pow(input_x[2], 2) * pow(input_x[5], 1) * pow(input_x[6], 1);
        idvd_poly_feat[484] = pow(input_x[0], 1) * pow(input_x[2], 2) * pow(input_x[6], 2);
        idvd_poly_feat[485] = pow(input_x[0], 1) * pow(input_x[2], 1) * pow(input_x[3], 3);
        idvd_poly_feat[486] = pow(input_x[0], 1) * pow(input_x[2], 1) * pow(input_x[3], 2) * pow(input_x[4], 1);
        idvd_poly_feat[487] = pow(input_x[0], 1) * pow(input_x[2], 1) * pow(input_x[3], 2) * pow(input_x[5], 1);
        idvd_poly_feat[488] = pow(input_x[0], 1) * pow(input_x[2], 1) * pow(input_x[3], 2) * pow(input_x[6], 1);
        idvd_poly_feat[489] = pow(input_x[0], 1) * pow(input_x[2], 1) * pow(input_x[3], 1) * pow(input_x[4], 2);
        idvd_poly_feat[490] = pow(input_x[0], 1) * pow(input_x[2], 1) * pow(input_x[3], 1) * pow(input_x[4], 1) * pow(input_x[5], 1);
        idvd_poly_feat[491] = pow(input_x[0], 1) * pow(input_x[2], 1) * pow(input_x[3], 1) * pow(input_x[4], 1) * pow(input_x[6], 1);
        idvd_poly_feat[492] = pow(input_x[0], 1) * pow(input_x[2], 1) * pow(input_x[3], 1) * pow(input_x[5], 2);
        idvd_poly_feat[493] = pow(input_x[0], 1) * pow(input_x[2], 1) * pow(input_x[3], 1) * pow(input_x[5], 1) * pow(input_x[6], 1);
        idvd_poly_feat[494] = pow(input_x[0], 1) * pow(input_x[2], 1) * pow(input_x[3], 1) * pow(input_x[6], 2);
        idvd_poly_feat[495] = pow(input_x[0], 1) * pow(input_x[2], 1) * pow(input_x[4], 3);
        idvd_poly_feat[496] = pow(input_x[0], 1) * pow(input_x[2], 1) * pow(input_x[4], 2) * pow(input_x[5], 1);
        idvd_poly_feat[497] = pow(input_x[0], 1) * pow(input_x[2], 1) * pow(input_x[4], 2) * pow(input_x[6], 1);
        idvd_poly_feat[498] = pow(input_x[0], 1) * pow(input_x[2], 1) * pow(input_x[4], 1) * pow(input_x[5], 2);
        idvd_poly_feat[499] = pow(input_x[0], 1) * pow(input_x[2], 1) * pow(input_x[4], 1) * pow(input_x[5], 1) * pow(input_x[6], 1);
        idvd_poly_feat[500] = pow(input_x[0], 1) * pow(input_x[2], 1) * pow(input_x[4], 1) * pow(input_x[6], 2);
        idvd_poly_feat[501] = pow(input_x[0], 1) * pow(input_x[2], 1) * pow(input_x[5], 3);
        idvd_poly_feat[502] = pow(input_x[0], 1) * pow(input_x[2], 1) * pow(input_x[5], 2) * pow(input_x[6], 1);
        idvd_poly_feat[503] = pow(input_x[0], 1) * pow(input_x[2], 1) * pow(input_x[5], 1) * pow(input_x[6], 2);
        idvd_poly_feat[504] = pow(input_x[0], 1) * pow(input_x[2], 1) * pow(input_x[6], 3);
        idvd_poly_feat[505] = pow(input_x[0], 1) * pow(input_x[3], 4);
        idvd_poly_feat[506] = pow(input_x[0], 1) * pow(input_x[3], 3) * pow(input_x[4], 1);
        idvd_poly_feat[507] = pow(input_x[0], 1) * pow(input_x[3], 3) * pow(input_x[5], 1);
        idvd_poly_feat[508] = pow(input_x[0], 1) * pow(input_x[3], 3) * pow(input_x[6], 1);
        idvd_poly_feat[509] = pow(input_x[0], 1) * pow(input_x[3], 2) * pow(input_x[4], 2);
        idvd_poly_feat[510] = pow(input_x[0], 1) * pow(input_x[3], 2) * pow(input_x[4], 1) * pow(input_x[5], 1);
        idvd_poly_feat[511] = pow(input_x[0], 1) * pow(input_x[3], 2) * pow(input_x[4], 1) * pow(input_x[6], 1);
        idvd_poly_feat[512] = pow(input_x[0], 1) * pow(input_x[3], 2) * pow(input_x[5], 2);
        idvd_poly_feat[513] = pow(input_x[0], 1) * pow(input_x[3], 2) * pow(input_x[5], 1) * pow(input_x[6], 1);
        idvd_poly_feat[514] = pow(input_x[0], 1) * pow(input_x[3], 2) * pow(input_x[6], 2);
        idvd_poly_feat[515] = pow(input_x[0], 1) * pow(input_x[3], 1) * pow(input_x[4], 3);
        idvd_poly_feat[516] = pow(input_x[0], 1) * pow(input_x[3], 1) * pow(input_x[4], 2) * pow(input_x[5], 1);
        idvd_poly_feat[517] = pow(input_x[0], 1) * pow(input_x[3], 1) * pow(input_x[4], 2) * pow(input_x[6], 1);
        idvd_poly_feat[518] = pow(input_x[0], 1) * pow(input_x[3], 1) * pow(input_x[4], 1) * pow(input_x[5], 2);
        idvd_poly_feat[519] = pow(input_x[0], 1) * pow(input_x[3], 1) * pow(input_x[4], 1) * pow(input_x[5], 1) * pow(input_x[6], 1);
        idvd_poly_feat[520] = pow(input_x[0], 1) * pow(input_x[3], 1) * pow(input_x[4], 1) * pow(input_x[6], 2);
        idvd_poly_feat[521] = pow(input_x[0], 1) * pow(input_x[3], 1) * pow(input_x[5], 3);
        idvd_poly_feat[522] = pow(input_x[0], 1) * pow(input_x[3], 1) * pow(input_x[5], 2) * pow(input_x[6], 1);
        idvd_poly_feat[523] = pow(input_x[0], 1) * pow(input_x[3], 1) * pow(input_x[5], 1) * pow(input_x[6], 2);
        idvd_poly_feat[524] = pow(input_x[0], 1) * pow(input_x[3], 1) * pow(input_x[6], 3);
        idvd_poly_feat[525] = pow(input_x[0], 1) * pow(input_x[4], 4);
        idvd_poly_feat[526] = pow(input_x[0], 1) * pow(input_x[4], 3) * pow(input_x[5], 1);
        idvd_poly_feat[527] = pow(input_x[0], 1) * pow(input_x[4], 3) * pow(input_x[6], 1);
        idvd_poly_feat[528] = pow(input_x[0], 1) * pow(input_x[4], 2) * pow(input_x[5], 2);
        idvd_poly_feat[529] = pow(input_x[0], 1) * pow(input_x[4], 2) * pow(input_x[5], 1) * pow(input_x[6], 1);
        idvd_poly_feat[530] = pow(input_x[0], 1) * pow(input_x[4], 2) * pow(input_x[6], 2);
        idvd_poly_feat[531] = pow(input_x[0], 1) * pow(input_x[4], 1) * pow(input_x[5], 3);
        idvd_poly_feat[532] = pow(input_x[0], 1) * pow(input_x[4], 1) * pow(input_x[5], 2) * pow(input_x[6], 1);
        idvd_poly_feat[533] = pow(input_x[0], 1) * pow(input_x[4], 1) * pow(input_x[5], 1) * pow(input_x[6], 2);
        idvd_poly_feat[534] = pow(input_x[0], 1) * pow(input_x[4], 1) * pow(input_x[6], 3);
        idvd_poly_feat[535] = pow(input_x[0], 1) * pow(input_x[5], 4);
        idvd_poly_feat[536] = pow(input_x[0], 1) * pow(input_x[5], 3) * pow(input_x[6], 1);
        idvd_poly_feat[537] = pow(input_x[0], 1) * pow(input_x[5], 2) * pow(input_x[6], 2);
        idvd_poly_feat[538] = pow(input_x[0], 1) * pow(input_x[5], 1) * pow(input_x[6], 3);
        idvd_poly_feat[539] = pow(input_x[0], 1) * pow(input_x[6], 4);
        idvd_poly_feat[540] = pow(input_x[1], 5);
        idvd_poly_feat[541] = pow(input_x[1], 4) * pow(input_x[2], 1);
        idvd_poly_feat[542] = pow(input_x[1], 4) * pow(input_x[3], 1);
        idvd_poly_feat[543] = pow(input_x[1], 4) * pow(input_x[4], 1);
        idvd_poly_feat[544] = pow(input_x[1], 4) * pow(input_x[5], 1);
        idvd_poly_feat[545] = pow(input_x[1], 4) * pow(input_x[6], 1);
        idvd_poly_feat[546] = pow(input_x[1], 3) * pow(input_x[2], 2);
        idvd_poly_feat[547] = pow(input_x[1], 3) * pow(input_x[2], 1) * pow(input_x[3], 1);
        idvd_poly_feat[548] = pow(input_x[1], 3) * pow(input_x[2], 1) * pow(input_x[4], 1);
        idvd_poly_feat[549] = pow(input_x[1], 3) * pow(input_x[2], 1) * pow(input_x[5], 1);
        idvd_poly_feat[550] = pow(input_x[1], 3) * pow(input_x[2], 1) * pow(input_x[6], 1);
        idvd_poly_feat[551] = pow(input_x[1], 3) * pow(input_x[3], 2);
        idvd_poly_feat[552] = pow(input_x[1], 3) * pow(input_x[3], 1) * pow(input_x[4], 1);
        idvd_poly_feat[553] = pow(input_x[1], 3) * pow(input_x[3], 1) * pow(input_x[5], 1);
        idvd_poly_feat[554] = pow(input_x[1], 3) * pow(input_x[3], 1) * pow(input_x[6], 1);
        idvd_poly_feat[555] = pow(input_x[1], 3) * pow(input_x[4], 2);
        idvd_poly_feat[556] = pow(input_x[1], 3) * pow(input_x[4], 1) * pow(input_x[5], 1);
        idvd_poly_feat[557] = pow(input_x[1], 3) * pow(input_x[4], 1) * pow(input_x[6], 1);
        idvd_poly_feat[558] = pow(input_x[1], 3) * pow(input_x[5], 2);
        idvd_poly_feat[559] = pow(input_x[1], 3) * pow(input_x[5], 1) * pow(input_x[6], 1);
        idvd_poly_feat[560] = pow(input_x[1], 3) * pow(input_x[6], 2);
        idvd_poly_feat[561] = pow(input_x[1], 2) * pow(input_x[2], 3);
        idvd_poly_feat[562] = pow(input_x[1], 2) * pow(input_x[2], 2) * pow(input_x[3], 1);
        idvd_poly_feat[563] = pow(input_x[1], 2) * pow(input_x[2], 2) * pow(input_x[4], 1);
        idvd_poly_feat[564] = pow(input_x[1], 2) * pow(input_x[2], 2) * pow(input_x[5], 1);
        idvd_poly_feat[565] = pow(input_x[1], 2) * pow(input_x[2], 2) * pow(input_x[6], 1);
        idvd_poly_feat[566] = pow(input_x[1], 2) * pow(input_x[2], 1) * pow(input_x[3], 2);
        idvd_poly_feat[567] = pow(input_x[1], 2) * pow(input_x[2], 1) * pow(input_x[3], 1) * pow(input_x[4], 1);
        idvd_poly_feat[568] = pow(input_x[1], 2) * pow(input_x[2], 1) * pow(input_x[3], 1) * pow(input_x[5], 1);
        idvd_poly_feat[569] = pow(input_x[1], 2) * pow(input_x[2], 1) * pow(input_x[3], 1) * pow(input_x[6], 1);
        idvd_poly_feat[570] = pow(input_x[1], 2) * pow(input_x[2], 1) * pow(input_x[4], 2);
        idvd_poly_feat[571] = pow(input_x[1], 2) * pow(input_x[2], 1) * pow(input_x[4], 1) * pow(input_x[5], 1);
        idvd_poly_feat[572] = pow(input_x[1], 2) * pow(input_x[2], 1) * pow(input_x[4], 1) * pow(input_x[6], 1);
        idvd_poly_feat[573] = pow(input_x[1], 2) * pow(input_x[2], 1) * pow(input_x[5], 2);
        idvd_poly_feat[574] = pow(input_x[1], 2) * pow(input_x[2], 1) * pow(input_x[5], 1) * pow(input_x[6], 1);
        idvd_poly_feat[575] = pow(input_x[1], 2) * pow(input_x[2], 1) * pow(input_x[6], 2);
        idvd_poly_feat[576] = pow(input_x[1], 2) * pow(input_x[3], 3);
        idvd_poly_feat[577] = pow(input_x[1], 2) * pow(input_x[3], 2) * pow(input_x[4], 1);
        idvd_poly_feat[578] = pow(input_x[1], 2) * pow(input_x[3], 2) * pow(input_x[5], 1);
        idvd_poly_feat[579] = pow(input_x[1], 2) * pow(input_x[3], 2) * pow(input_x[6], 1);
        idvd_poly_feat[580] = pow(input_x[1], 2) * pow(input_x[3], 1) * pow(input_x[4], 2);
        idvd_poly_feat[581] = pow(input_x[1], 2) * pow(input_x[3], 1) * pow(input_x[4], 1) * pow(input_x[5], 1);
        idvd_poly_feat[582] = pow(input_x[1], 2) * pow(input_x[3], 1) * pow(input_x[4], 1) * pow(input_x[6], 1);
        idvd_poly_feat[583] = pow(input_x[1], 2) * pow(input_x[3], 1) * pow(input_x[5], 2);
        idvd_poly_feat[584] = pow(input_x[1], 2) * pow(input_x[3], 1) * pow(input_x[5], 1) * pow(input_x[6], 1);
        idvd_poly_feat[585] = pow(input_x[1], 2) * pow(input_x[3], 1) * pow(input_x[6], 2);
        idvd_poly_feat[586] = pow(input_x[1], 2) * pow(input_x[4], 3);
        idvd_poly_feat[587] = pow(input_x[1], 2) * pow(input_x[4], 2) * pow(input_x[5], 1);
        idvd_poly_feat[588] = pow(input_x[1], 2) * pow(input_x[4], 2) * pow(input_x[6], 1);
        idvd_poly_feat[589] = pow(input_x[1], 2) * pow(input_x[4], 1) * pow(input_x[5], 2);
        idvd_poly_feat[590] = pow(input_x[1], 2) * pow(input_x[4], 1) * pow(input_x[5], 1) * pow(input_x[6], 1);
        idvd_poly_feat[591] = pow(input_x[1], 2) * pow(input_x[4], 1) * pow(input_x[6], 2);
        idvd_poly_feat[592] = pow(input_x[1], 2) * pow(input_x[5], 3);
        idvd_poly_feat[593] = pow(input_x[1], 2) * pow(input_x[5], 2) * pow(input_x[6], 1);
        idvd_poly_feat[594] = pow(input_x[1], 2) * pow(input_x[5], 1) * pow(input_x[6], 2);
        idvd_poly_feat[595] = pow(input_x[1], 2) * pow(input_x[6], 3);
        idvd_poly_feat[596] = pow(input_x[1], 1) * pow(input_x[2], 4);
        idvd_poly_feat[597] = pow(input_x[1], 1) * pow(input_x[2], 3) * pow(input_x[3], 1);
        idvd_poly_feat[598] = pow(input_x[1], 1) * pow(input_x[2], 3) * pow(input_x[4], 1);
        idvd_poly_feat[599] = pow(input_x[1], 1) * pow(input_x[2], 3) * pow(input_x[5], 1);
        idvd_poly_feat[600] = pow(input_x[1], 1) * pow(input_x[2], 3) * pow(input_x[6], 1);
        idvd_poly_feat[601] = pow(input_x[1], 1) * pow(input_x[2], 2) * pow(input_x[3], 2);
        idvd_poly_feat[602] = pow(input_x[1], 1) * pow(input_x[2], 2) * pow(input_x[3], 1) * pow(input_x[4], 1);
        idvd_poly_feat[603] = pow(input_x[1], 1) * pow(input_x[2], 2) * pow(input_x[3], 1) * pow(input_x[5], 1);
        idvd_poly_feat[604] = pow(input_x[1], 1) * pow(input_x[2], 2) * pow(input_x[3], 1) * pow(input_x[6], 1);
        idvd_poly_feat[605] = pow(input_x[1], 1) * pow(input_x[2], 2) * pow(input_x[4], 2);
        idvd_poly_feat[606] = pow(input_x[1], 1) * pow(input_x[2], 2) * pow(input_x[4], 1) * pow(input_x[5], 1);
        idvd_poly_feat[607] = pow(input_x[1], 1) * pow(input_x[2], 2) * pow(input_x[4], 1) * pow(input_x[6], 1);
        idvd_poly_feat[608] = pow(input_x[1], 1) * pow(input_x[2], 2) * pow(input_x[5], 2);
        idvd_poly_feat[609] = pow(input_x[1], 1) * pow(input_x[2], 2) * pow(input_x[5], 1) * pow(input_x[6], 1);
        idvd_poly_feat[610] = pow(input_x[1], 1) * pow(input_x[2], 2) * pow(input_x[6], 2);
        idvd_poly_feat[611] = pow(input_x[1], 1) * pow(input_x[2], 1) * pow(input_x[3], 3);
        idvd_poly_feat[612] = pow(input_x[1], 1) * pow(input_x[2], 1) * pow(input_x[3], 2) * pow(input_x[4], 1);
        idvd_poly_feat[613] = pow(input_x[1], 1) * pow(input_x[2], 1) * pow(input_x[3], 2) * pow(input_x[5], 1);
        idvd_poly_feat[614] = pow(input_x[1], 1) * pow(input_x[2], 1) * pow(input_x[3], 2) * pow(input_x[6], 1);
        idvd_poly_feat[615] = pow(input_x[1], 1) * pow(input_x[2], 1) * pow(input_x[3], 1) * pow(input_x[4], 2);
        idvd_poly_feat[616] = pow(input_x[1], 1) * pow(input_x[2], 1) * pow(input_x[3], 1) * pow(input_x[4], 1) * pow(input_x[5], 1);
        idvd_poly_feat[617] = pow(input_x[1], 1) * pow(input_x[2], 1) * pow(input_x[3], 1) * pow(input_x[4], 1) * pow(input_x[6], 1);
        idvd_poly_feat[618] = pow(input_x[1], 1) * pow(input_x[2], 1) * pow(input_x[3], 1) * pow(input_x[5], 2);
        idvd_poly_feat[619] = pow(input_x[1], 1) * pow(input_x[2], 1) * pow(input_x[3], 1) * pow(input_x[5], 1) * pow(input_x[6], 1);
        idvd_poly_feat[620] = pow(input_x[1], 1) * pow(input_x[2], 1) * pow(input_x[3], 1) * pow(input_x[6], 2);
        idvd_poly_feat[621] = pow(input_x[1], 1) * pow(input_x[2], 1) * pow(input_x[4], 3);
        idvd_poly_feat[622] = pow(input_x[1], 1) * pow(input_x[2], 1) * pow(input_x[4], 2) * pow(input_x[5], 1);
        idvd_poly_feat[623] = pow(input_x[1], 1) * pow(input_x[2], 1) * pow(input_x[4], 2) * pow(input_x[6], 1);
        idvd_poly_feat[624] = pow(input_x[1], 1) * pow(input_x[2], 1) * pow(input_x[4], 1) * pow(input_x[5], 2);
        idvd_poly_feat[625] = pow(input_x[1], 1) * pow(input_x[2], 1) * pow(input_x[4], 1) * pow(input_x[5], 1) * pow(input_x[6], 1);
        idvd_poly_feat[626] = pow(input_x[1], 1) * pow(input_x[2], 1) * pow(input_x[4], 1) * pow(input_x[6], 2);
        idvd_poly_feat[627] = pow(input_x[1], 1) * pow(input_x[2], 1) * pow(input_x[5], 3);
        idvd_poly_feat[628] = pow(input_x[1], 1) * pow(input_x[2], 1) * pow(input_x[5], 2) * pow(input_x[6], 1);
        idvd_poly_feat[629] = pow(input_x[1], 1) * pow(input_x[2], 1) * pow(input_x[5], 1) * pow(input_x[6], 2);
        idvd_poly_feat[630] = pow(input_x[1], 1) * pow(input_x[2], 1) * pow(input_x[6], 3);
        idvd_poly_feat[631] = pow(input_x[1], 1) * pow(input_x[3], 4);
        idvd_poly_feat[632] = pow(input_x[1], 1) * pow(input_x[3], 3) * pow(input_x[4], 1);
        idvd_poly_feat[633] = pow(input_x[1], 1) * pow(input_x[3], 3) * pow(input_x[5], 1);
        idvd_poly_feat[634] = pow(input_x[1], 1) * pow(input_x[3], 3) * pow(input_x[6], 1);
        idvd_poly_feat[635] = pow(input_x[1], 1) * pow(input_x[3], 2) * pow(input_x[4], 2);
        idvd_poly_feat[636] = pow(input_x[1], 1) * pow(input_x[3], 2) * pow(input_x[4], 1) * pow(input_x[5], 1);
        idvd_poly_feat[637] = pow(input_x[1], 1) * pow(input_x[3], 2) * pow(input_x[4], 1) * pow(input_x[6], 1);
        idvd_poly_feat[638] = pow(input_x[1], 1) * pow(input_x[3], 2) * pow(input_x[5], 2);
        idvd_poly_feat[639] = pow(input_x[1], 1) * pow(input_x[3], 2) * pow(input_x[5], 1) * pow(input_x[6], 1);
        idvd_poly_feat[640] = pow(input_x[1], 1) * pow(input_x[3], 2) * pow(input_x[6], 2);
        idvd_poly_feat[641] = pow(input_x[1], 1) * pow(input_x[3], 1) * pow(input_x[4], 3);
        idvd_poly_feat[642] = pow(input_x[1], 1) * pow(input_x[3], 1) * pow(input_x[4], 2) * pow(input_x[5], 1);
        idvd_poly_feat[643] = pow(input_x[1], 1) * pow(input_x[3], 1) * pow(input_x[4], 2) * pow(input_x[6], 1);
        idvd_poly_feat[644] = pow(input_x[1], 1) * pow(input_x[3], 1) * pow(input_x[4], 1) * pow(input_x[5], 2);
        idvd_poly_feat[645] = pow(input_x[1], 1) * pow(input_x[3], 1) * pow(input_x[4], 1) * pow(input_x[5], 1) * pow(input_x[6], 1);
        idvd_poly_feat[646] = pow(input_x[1], 1) * pow(input_x[3], 1) * pow(input_x[4], 1) * pow(input_x[6], 2);
        idvd_poly_feat[647] = pow(input_x[1], 1) * pow(input_x[3], 1) * pow(input_x[5], 3);
        idvd_poly_feat[648] = pow(input_x[1], 1) * pow(input_x[3], 1) * pow(input_x[5], 2) * pow(input_x[6], 1);
        idvd_poly_feat[649] = pow(input_x[1], 1) * pow(input_x[3], 1) * pow(input_x[5], 1) * pow(input_x[6], 2);
        idvd_poly_feat[650] = pow(input_x[1], 1) * pow(input_x[3], 1) * pow(input_x[6], 3);
        idvd_poly_feat[651] = pow(input_x[1], 1) * pow(input_x[4], 4);
        idvd_poly_feat[652] = pow(input_x[1], 1) * pow(input_x[4], 3) * pow(input_x[5], 1);
        idvd_poly_feat[653] = pow(input_x[1], 1) * pow(input_x[4], 3) * pow(input_x[6], 1);
        idvd_poly_feat[654] = pow(input_x[1], 1) * pow(input_x[4], 2) * pow(input_x[5], 2);
        idvd_poly_feat[655] = pow(input_x[1], 1) * pow(input_x[4], 2) * pow(input_x[5], 1) * pow(input_x[6], 1);
        idvd_poly_feat[656] = pow(input_x[1], 1) * pow(input_x[4], 2) * pow(input_x[6], 2);
        idvd_poly_feat[657] = pow(input_x[1], 1) * pow(input_x[4], 1) * pow(input_x[5], 3);
        idvd_poly_feat[658] = pow(input_x[1], 1) * pow(input_x[4], 1) * pow(input_x[5], 2) * pow(input_x[6], 1);
        idvd_poly_feat[659] = pow(input_x[1], 1) * pow(input_x[4], 1) * pow(input_x[5], 1) * pow(input_x[6], 2);
        idvd_poly_feat[660] = pow(input_x[1], 1) * pow(input_x[4], 1) * pow(input_x[6], 3);
        idvd_poly_feat[661] = pow(input_x[1], 1) * pow(input_x[5], 4);
        idvd_poly_feat[662] = pow(input_x[1], 1) * pow(input_x[5], 3) * pow(input_x[6], 1);
        idvd_poly_feat[663] = pow(input_x[1], 1) * pow(input_x[5], 2) * pow(input_x[6], 2);
        idvd_poly_feat[664] = pow(input_x[1], 1) * pow(input_x[5], 1) * pow(input_x[6], 3);
        idvd_poly_feat[665] = pow(input_x[1], 1) * pow(input_x[6], 4);
        idvd_poly_feat[666] = pow(input_x[2], 5);
        idvd_poly_feat[667] = pow(input_x[2], 4) * pow(input_x[3], 1);
        idvd_poly_feat[668] = pow(input_x[2], 4) * pow(input_x[4], 1);
        idvd_poly_feat[669] = pow(input_x[2], 4) * pow(input_x[5], 1);
        idvd_poly_feat[670] = pow(input_x[2], 4) * pow(input_x[6], 1);
        idvd_poly_feat[671] = pow(input_x[2], 3) * pow(input_x[3], 2);
        idvd_poly_feat[672] = pow(input_x[2], 3) * pow(input_x[3], 1) * pow(input_x[4], 1);
        idvd_poly_feat[673] = pow(input_x[2], 3) * pow(input_x[3], 1) * pow(input_x[5], 1);
        idvd_poly_feat[674] = pow(input_x[2], 3) * pow(input_x[3], 1) * pow(input_x[6], 1);
        idvd_poly_feat[675] = pow(input_x[2], 3) * pow(input_x[4], 2);
        idvd_poly_feat[676] = pow(input_x[2], 3) * pow(input_x[4], 1) * pow(input_x[5], 1);
        idvd_poly_feat[677] = pow(input_x[2], 3) * pow(input_x[4], 1) * pow(input_x[6], 1);
        idvd_poly_feat[678] = pow(input_x[2], 3) * pow(input_x[5], 2);
        idvd_poly_feat[679] = pow(input_x[2], 3) * pow(input_x[5], 1) * pow(input_x[6], 1);
        idvd_poly_feat[680] = pow(input_x[2], 3) * pow(input_x[6], 2);
        idvd_poly_feat[681] = pow(input_x[2], 2) * pow(input_x[3], 3);
        idvd_poly_feat[682] = pow(input_x[2], 2) * pow(input_x[3], 2) * pow(input_x[4], 1);
        idvd_poly_feat[683] = pow(input_x[2], 2) * pow(input_x[3], 2) * pow(input_x[5], 1);
        idvd_poly_feat[684] = pow(input_x[2], 2) * pow(input_x[3], 2) * pow(input_x[6], 1);
        idvd_poly_feat[685] = pow(input_x[2], 2) * pow(input_x[3], 1) * pow(input_x[4], 2);
        idvd_poly_feat[686] = pow(input_x[2], 2) * pow(input_x[3], 1) * pow(input_x[4], 1) * pow(input_x[5], 1);
        idvd_poly_feat[687] = pow(input_x[2], 2) * pow(input_x[3], 1) * pow(input_x[4], 1) * pow(input_x[6], 1);
        idvd_poly_feat[688] = pow(input_x[2], 2) * pow(input_x[3], 1) * pow(input_x[5], 2);
        idvd_poly_feat[689] = pow(input_x[2], 2) * pow(input_x[3], 1) * pow(input_x[5], 1) * pow(input_x[6], 1);
        idvd_poly_feat[690] = pow(input_x[2], 2) * pow(input_x[3], 1) * pow(input_x[6], 2);
        idvd_poly_feat[691] = pow(input_x[2], 2) * pow(input_x[4], 3);
        idvd_poly_feat[692] = pow(input_x[2], 2) * pow(input_x[4], 2) * pow(input_x[5], 1);
        idvd_poly_feat[693] = pow(input_x[2], 2) * pow(input_x[4], 2) * pow(input_x[6], 1);
        idvd_poly_feat[694] = pow(input_x[2], 2) * pow(input_x[4], 1) * pow(input_x[5], 2);
        idvd_poly_feat[695] = pow(input_x[2], 2) * pow(input_x[4], 1) * pow(input_x[5], 1) * pow(input_x[6], 1);
        idvd_poly_feat[696] = pow(input_x[2], 2) * pow(input_x[4], 1) * pow(input_x[6], 2);
        idvd_poly_feat[697] = pow(input_x[2], 2) * pow(input_x[5], 3);
        idvd_poly_feat[698] = pow(input_x[2], 2) * pow(input_x[5], 2) * pow(input_x[6], 1);
        idvd_poly_feat[699] = pow(input_x[2], 2) * pow(input_x[5], 1) * pow(input_x[6], 2);
        idvd_poly_feat[700] = pow(input_x[2], 2) * pow(input_x[6], 3);
        idvd_poly_feat[701] = pow(input_x[2], 1) * pow(input_x[3], 4);
        idvd_poly_feat[702] = pow(input_x[2], 1) * pow(input_x[3], 3) * pow(input_x[4], 1);
        idvd_poly_feat[703] = pow(input_x[2], 1) * pow(input_x[3], 3) * pow(input_x[5], 1);
        idvd_poly_feat[704] = pow(input_x[2], 1) * pow(input_x[3], 3) * pow(input_x[6], 1);
        idvd_poly_feat[705] = pow(input_x[2], 1) * pow(input_x[3], 2) * pow(input_x[4], 2);
        idvd_poly_feat[706] = pow(input_x[2], 1) * pow(input_x[3], 2) * pow(input_x[4], 1) * pow(input_x[5], 1);
        idvd_poly_feat[707] = pow(input_x[2], 1) * pow(input_x[3], 2) * pow(input_x[4], 1) * pow(input_x[6], 1);
        idvd_poly_feat[708] = pow(input_x[2], 1) * pow(input_x[3], 2) * pow(input_x[5], 2);
        idvd_poly_feat[709] = pow(input_x[2], 1) * pow(input_x[3], 2) * pow(input_x[5], 1) * pow(input_x[6], 1);
        idvd_poly_feat[710] = pow(input_x[2], 1) * pow(input_x[3], 2) * pow(input_x[6], 2);
        idvd_poly_feat[711] = pow(input_x[2], 1) * pow(input_x[3], 1) * pow(input_x[4], 3);
        idvd_poly_feat[712] = pow(input_x[2], 1) * pow(input_x[3], 1) * pow(input_x[4], 2) * pow(input_x[5], 1);
        idvd_poly_feat[713] = pow(input_x[2], 1) * pow(input_x[3], 1) * pow(input_x[4], 2) * pow(input_x[6], 1);
        idvd_poly_feat[714] = pow(input_x[2], 1) * pow(input_x[3], 1) * pow(input_x[4], 1) * pow(input_x[5], 2);
        idvd_poly_feat[715] = pow(input_x[2], 1) * pow(input_x[3], 1) * pow(input_x[4], 1) * pow(input_x[5], 1) * pow(input_x[6], 1);
        idvd_poly_feat[716] = pow(input_x[2], 1) * pow(input_x[3], 1) * pow(input_x[4], 1) * pow(input_x[6], 2);
        idvd_poly_feat[717] = pow(input_x[2], 1) * pow(input_x[3], 1) * pow(input_x[5], 3);
        idvd_poly_feat[718] = pow(input_x[2], 1) * pow(input_x[3], 1) * pow(input_x[5], 2) * pow(input_x[6], 1);
        idvd_poly_feat[719] = pow(input_x[2], 1) * pow(input_x[3], 1) * pow(input_x[5], 1) * pow(input_x[6], 2);
        idvd_poly_feat[720] = pow(input_x[2], 1) * pow(input_x[3], 1) * pow(input_x[6], 3);
        idvd_poly_feat[721] = pow(input_x[2], 1) * pow(input_x[4], 4);
        idvd_poly_feat[722] = pow(input_x[2], 1) * pow(input_x[4], 3) * pow(input_x[5], 1);
        idvd_poly_feat[723] = pow(input_x[2], 1) * pow(input_x[4], 3) * pow(input_x[6], 1);
        idvd_poly_feat[724] = pow(input_x[2], 1) * pow(input_x[4], 2) * pow(input_x[5], 2);
        idvd_poly_feat[725] = pow(input_x[2], 1) * pow(input_x[4], 2) * pow(input_x[5], 1) * pow(input_x[6], 1);
        idvd_poly_feat[726] = pow(input_x[2], 1) * pow(input_x[4], 2) * pow(input_x[6], 2);
        idvd_poly_feat[727] = pow(input_x[2], 1) * pow(input_x[4], 1) * pow(input_x[5], 3);
        idvd_poly_feat[728] = pow(input_x[2], 1) * pow(input_x[4], 1) * pow(input_x[5], 2) * pow(input_x[6], 1);
        idvd_poly_feat[729] = pow(input_x[2], 1) * pow(input_x[4], 1) * pow(input_x[5], 1) * pow(input_x[6], 2);
        idvd_poly_feat[730] = pow(input_x[2], 1) * pow(input_x[4], 1) * pow(input_x[6], 3);
        idvd_poly_feat[731] = pow(input_x[2], 1) * pow(input_x[5], 4);
        idvd_poly_feat[732] = pow(input_x[2], 1) * pow(input_x[5], 3) * pow(input_x[6], 1);
        idvd_poly_feat[733] = pow(input_x[2], 1) * pow(input_x[5], 2) * pow(input_x[6], 2);
        idvd_poly_feat[734] = pow(input_x[2], 1) * pow(input_x[5], 1) * pow(input_x[6], 3);
        idvd_poly_feat[735] = pow(input_x[2], 1) * pow(input_x[6], 4);
        idvd_poly_feat[736] = pow(input_x[3], 5);
        idvd_poly_feat[737] = pow(input_x[3], 4) * pow(input_x[4], 1);
        idvd_poly_feat[738] = pow(input_x[3], 4) * pow(input_x[5], 1);
        idvd_poly_feat[739] = pow(input_x[3], 4) * pow(input_x[6], 1);
        idvd_poly_feat[740] = pow(input_x[3], 3) * pow(input_x[4], 2);
        idvd_poly_feat[741] = pow(input_x[3], 3) * pow(input_x[4], 1) * pow(input_x[5], 1);
        idvd_poly_feat[742] = pow(input_x[3], 3) * pow(input_x[4], 1) * pow(input_x[6], 1);
        idvd_poly_feat[743] = pow(input_x[3], 3) * pow(input_x[5], 2);
        idvd_poly_feat[744] = pow(input_x[3], 3) * pow(input_x[5], 1) * pow(input_x[6], 1);
        idvd_poly_feat[745] = pow(input_x[3], 3) * pow(input_x[6], 2);
        idvd_poly_feat[746] = pow(input_x[3], 2) * pow(input_x[4], 3);
        idvd_poly_feat[747] = pow(input_x[3], 2) * pow(input_x[4], 2) * pow(input_x[5], 1);
        idvd_poly_feat[748] = pow(input_x[3], 2) * pow(input_x[4], 2) * pow(input_x[6], 1);
        idvd_poly_feat[749] = pow(input_x[3], 2) * pow(input_x[4], 1) * pow(input_x[5], 2);
        idvd_poly_feat[750] = pow(input_x[3], 2) * pow(input_x[4], 1) * pow(input_x[5], 1) * pow(input_x[6], 1);
        idvd_poly_feat[751] = pow(input_x[3], 2) * pow(input_x[4], 1) * pow(input_x[6], 2);
        idvd_poly_feat[752] = pow(input_x[3], 2) * pow(input_x[5], 3);
        idvd_poly_feat[753] = pow(input_x[3], 2) * pow(input_x[5], 2) * pow(input_x[6], 1);
        idvd_poly_feat[754] = pow(input_x[3], 2) * pow(input_x[5], 1) * pow(input_x[6], 2);
        idvd_poly_feat[755] = pow(input_x[3], 2) * pow(input_x[6], 3);
        idvd_poly_feat[756] = pow(input_x[3], 1) * pow(input_x[4], 4);
        idvd_poly_feat[757] = pow(input_x[3], 1) * pow(input_x[4], 3) * pow(input_x[5], 1);
        idvd_poly_feat[758] = pow(input_x[3], 1) * pow(input_x[4], 3) * pow(input_x[6], 1);
        idvd_poly_feat[759] = pow(input_x[3], 1) * pow(input_x[4], 2) * pow(input_x[5], 2);
        idvd_poly_feat[760] = pow(input_x[3], 1) * pow(input_x[4], 2) * pow(input_x[5], 1) * pow(input_x[6], 1);
        idvd_poly_feat[761] = pow(input_x[3], 1) * pow(input_x[4], 2) * pow(input_x[6], 2);
        idvd_poly_feat[762] = pow(input_x[3], 1) * pow(input_x[4], 1) * pow(input_x[5], 3);
        idvd_poly_feat[763] = pow(input_x[3], 1) * pow(input_x[4], 1) * pow(input_x[5], 2) * pow(input_x[6], 1);
        idvd_poly_feat[764] = pow(input_x[3], 1) * pow(input_x[4], 1) * pow(input_x[5], 1) * pow(input_x[6], 2);
        idvd_poly_feat[765] = pow(input_x[3], 1) * pow(input_x[4], 1) * pow(input_x[6], 3);
        idvd_poly_feat[766] = pow(input_x[3], 1) * pow(input_x[5], 4);
        idvd_poly_feat[767] = pow(input_x[3], 1) * pow(input_x[5], 3) * pow(input_x[6], 1);
        idvd_poly_feat[768] = pow(input_x[3], 1) * pow(input_x[5], 2) * pow(input_x[6], 2);
        idvd_poly_feat[769] = pow(input_x[3], 1) * pow(input_x[5], 1) * pow(input_x[6], 3);
        idvd_poly_feat[770] = pow(input_x[3], 1) * pow(input_x[6], 4);
        idvd_poly_feat[771] = pow(input_x[4], 5);
        idvd_poly_feat[772] = pow(input_x[4], 4) * pow(input_x[5], 1);
        idvd_poly_feat[773] = pow(input_x[4], 4) * pow(input_x[6], 1);
        idvd_poly_feat[774] = pow(input_x[4], 3) * pow(input_x[5], 2);
        idvd_poly_feat[775] = pow(input_x[4], 3) * pow(input_x[5], 1) * pow(input_x[6], 1);
        idvd_poly_feat[776] = pow(input_x[4], 3) * pow(input_x[6], 2);
        idvd_poly_feat[777] = pow(input_x[4], 2) * pow(input_x[5], 3);
        idvd_poly_feat[778] = pow(input_x[4], 2) * pow(input_x[5], 2) * pow(input_x[6], 1);
        idvd_poly_feat[779] = pow(input_x[4], 2) * pow(input_x[5], 1) * pow(input_x[6], 2);
        idvd_poly_feat[780] = pow(input_x[4], 2) * pow(input_x[6], 3);
        idvd_poly_feat[781] = pow(input_x[4], 1) * pow(input_x[5], 4);
        idvd_poly_feat[782] = pow(input_x[4], 1) * pow(input_x[5], 3) * pow(input_x[6], 1);
        idvd_poly_feat[783] = pow(input_x[4], 1) * pow(input_x[5], 2) * pow(input_x[6], 2);
        idvd_poly_feat[784] = pow(input_x[4], 1) * pow(input_x[5], 1) * pow(input_x[6], 3);
        idvd_poly_feat[785] = pow(input_x[4], 1) * pow(input_x[6], 4);
        idvd_poly_feat[786] = pow(input_x[5], 5);
        idvd_poly_feat[787] = pow(input_x[5], 4) * pow(input_x[6], 1);
        idvd_poly_feat[788] = pow(input_x[5], 3) * pow(input_x[6], 2);
        idvd_poly_feat[789] = pow(input_x[5], 2) * pow(input_x[6], 3);
        idvd_poly_feat[790] = pow(input_x[5], 1) * pow(input_x[6], 4);
        idvd_poly_feat[791] = pow(input_x[6], 5);
        idvd_poly_feat[792] = pow(input_x[0], 6);
        idvd_poly_feat[793] = pow(input_x[0], 5) * pow(input_x[1], 1);
        idvd_poly_feat[794] = pow(input_x[0], 5) * pow(input_x[2], 1);
        idvd_poly_feat[795] = pow(input_x[0], 5) * pow(input_x[3], 1);
        idvd_poly_feat[796] = pow(input_x[0], 5) * pow(input_x[4], 1);
        idvd_poly_feat[797] = pow(input_x[0], 5) * pow(input_x[5], 1);
        idvd_poly_feat[798] = pow(input_x[0], 5) * pow(input_x[6], 1);
        idvd_poly_feat[799] = pow(input_x[0], 4) * pow(input_x[1], 2);
        idvd_poly_feat[800] = pow(input_x[0], 4) * pow(input_x[1], 1) * pow(input_x[2], 1);
        idvd_poly_feat[801] = pow(input_x[0], 4) * pow(input_x[1], 1) * pow(input_x[3], 1);
        idvd_poly_feat[802] = pow(input_x[0], 4) * pow(input_x[1], 1) * pow(input_x[4], 1);
        idvd_poly_feat[803] = pow(input_x[0], 4) * pow(input_x[1], 1) * pow(input_x[5], 1);
        idvd_poly_feat[804] = pow(input_x[0], 4) * pow(input_x[1], 1) * pow(input_x[6], 1);
        idvd_poly_feat[805] = pow(input_x[0], 4) * pow(input_x[2], 2);
        idvd_poly_feat[806] = pow(input_x[0], 4) * pow(input_x[2], 1) * pow(input_x[3], 1);
        idvd_poly_feat[807] = pow(input_x[0], 4) * pow(input_x[2], 1) * pow(input_x[4], 1);
        idvd_poly_feat[808] = pow(input_x[0], 4) * pow(input_x[2], 1) * pow(input_x[5], 1);
        idvd_poly_feat[809] = pow(input_x[0], 4) * pow(input_x[2], 1) * pow(input_x[6], 1);
        idvd_poly_feat[810] = pow(input_x[0], 4) * pow(input_x[3], 2);
        idvd_poly_feat[811] = pow(input_x[0], 4) * pow(input_x[3], 1) * pow(input_x[4], 1);
        idvd_poly_feat[812] = pow(input_x[0], 4) * pow(input_x[3], 1) * pow(input_x[5], 1);
        idvd_poly_feat[813] = pow(input_x[0], 4) * pow(input_x[3], 1) * pow(input_x[6], 1);
        idvd_poly_feat[814] = pow(input_x[0], 4) * pow(input_x[4], 2);
        idvd_poly_feat[815] = pow(input_x[0], 4) * pow(input_x[4], 1) * pow(input_x[5], 1);
        idvd_poly_feat[816] = pow(input_x[0], 4) * pow(input_x[4], 1) * pow(input_x[6], 1);
        idvd_poly_feat[817] = pow(input_x[0], 4) * pow(input_x[5], 2);
        idvd_poly_feat[818] = pow(input_x[0], 4) * pow(input_x[5], 1) * pow(input_x[6], 1);
        idvd_poly_feat[819] = pow(input_x[0], 4) * pow(input_x[6], 2);
        idvd_poly_feat[820] = pow(input_x[0], 3) * pow(input_x[1], 3);
        idvd_poly_feat[821] = pow(input_x[0], 3) * pow(input_x[1], 2) * pow(input_x[2], 1);
        idvd_poly_feat[822] = pow(input_x[0], 3) * pow(input_x[1], 2) * pow(input_x[3], 1);
        idvd_poly_feat[823] = pow(input_x[0], 3) * pow(input_x[1], 2) * pow(input_x[4], 1);
        idvd_poly_feat[824] = pow(input_x[0], 3) * pow(input_x[1], 2) * pow(input_x[5], 1);
        idvd_poly_feat[825] = pow(input_x[0], 3) * pow(input_x[1], 2) * pow(input_x[6], 1);
        idvd_poly_feat[826] = pow(input_x[0], 3) * pow(input_x[1], 1) * pow(input_x[2], 2);
        idvd_poly_feat[827] = pow(input_x[0], 3) * pow(input_x[1], 1) * pow(input_x[2], 1) * pow(input_x[3], 1);
        idvd_poly_feat[828] = pow(input_x[0], 3) * pow(input_x[1], 1) * pow(input_x[2], 1) * pow(input_x[4], 1);
        idvd_poly_feat[829] = pow(input_x[0], 3) * pow(input_x[1], 1) * pow(input_x[2], 1) * pow(input_x[5], 1);
        idvd_poly_feat[830] = pow(input_x[0], 3) * pow(input_x[1], 1) * pow(input_x[2], 1) * pow(input_x[6], 1);
        idvd_poly_feat[831] = pow(input_x[0], 3) * pow(input_x[1], 1) * pow(input_x[3], 2);
        idvd_poly_feat[832] = pow(input_x[0], 3) * pow(input_x[1], 1) * pow(input_x[3], 1) * pow(input_x[4], 1);
        idvd_poly_feat[833] = pow(input_x[0], 3) * pow(input_x[1], 1) * pow(input_x[3], 1) * pow(input_x[5], 1);
        idvd_poly_feat[834] = pow(input_x[0], 3) * pow(input_x[1], 1) * pow(input_x[3], 1) * pow(input_x[6], 1);
        idvd_poly_feat[835] = pow(input_x[0], 3) * pow(input_x[1], 1) * pow(input_x[4], 2);
        idvd_poly_feat[836] = pow(input_x[0], 3) * pow(input_x[1], 1) * pow(input_x[4], 1) * pow(input_x[5], 1);
        idvd_poly_feat[837] = pow(input_x[0], 3) * pow(input_x[1], 1) * pow(input_x[4], 1) * pow(input_x[6], 1);
        idvd_poly_feat[838] = pow(input_x[0], 3) * pow(input_x[1], 1) * pow(input_x[5], 2);
        idvd_poly_feat[839] = pow(input_x[0], 3) * pow(input_x[1], 1) * pow(input_x[5], 1) * pow(input_x[6], 1);
        idvd_poly_feat[840] = pow(input_x[0], 3) * pow(input_x[1], 1) * pow(input_x[6], 2);
        idvd_poly_feat[841] = pow(input_x[0], 3) * pow(input_x[2], 3);
        idvd_poly_feat[842] = pow(input_x[0], 3) * pow(input_x[2], 2) * pow(input_x[3], 1);
        idvd_poly_feat[843] = pow(input_x[0], 3) * pow(input_x[2], 2) * pow(input_x[4], 1);
        idvd_poly_feat[844] = pow(input_x[0], 3) * pow(input_x[2], 2) * pow(input_x[5], 1);
        idvd_poly_feat[845] = pow(input_x[0], 3) * pow(input_x[2], 2) * pow(input_x[6], 1);
        idvd_poly_feat[846] = pow(input_x[0], 3) * pow(input_x[2], 1) * pow(input_x[3], 2);
        idvd_poly_feat[847] = pow(input_x[0], 3) * pow(input_x[2], 1) * pow(input_x[3], 1) * pow(input_x[4], 1);
        idvd_poly_feat[848] = pow(input_x[0], 3) * pow(input_x[2], 1) * pow(input_x[3], 1) * pow(input_x[5], 1);
        idvd_poly_feat[849] = pow(input_x[0], 3) * pow(input_x[2], 1) * pow(input_x[3], 1) * pow(input_x[6], 1);
        idvd_poly_feat[850] = pow(input_x[0], 3) * pow(input_x[2], 1) * pow(input_x[4], 2);
        idvd_poly_feat[851] = pow(input_x[0], 3) * pow(input_x[2], 1) * pow(input_x[4], 1) * pow(input_x[5], 1);
        idvd_poly_feat[852] = pow(input_x[0], 3) * pow(input_x[2], 1) * pow(input_x[4], 1) * pow(input_x[6], 1);
        idvd_poly_feat[853] = pow(input_x[0], 3) * pow(input_x[2], 1) * pow(input_x[5], 2);
        idvd_poly_feat[854] = pow(input_x[0], 3) * pow(input_x[2], 1) * pow(input_x[5], 1) * pow(input_x[6], 1);
        idvd_poly_feat[855] = pow(input_x[0], 3) * pow(input_x[2], 1) * pow(input_x[6], 2);
        idvd_poly_feat[856] = pow(input_x[0], 3) * pow(input_x[3], 3);
        idvd_poly_feat[857] = pow(input_x[0], 3) * pow(input_x[3], 2) * pow(input_x[4], 1);
        idvd_poly_feat[858] = pow(input_x[0], 3) * pow(input_x[3], 2) * pow(input_x[5], 1);
        idvd_poly_feat[859] = pow(input_x[0], 3) * pow(input_x[3], 2) * pow(input_x[6], 1);
        idvd_poly_feat[860] = pow(input_x[0], 3) * pow(input_x[3], 1) * pow(input_x[4], 2);
        idvd_poly_feat[861] = pow(input_x[0], 3) * pow(input_x[3], 1) * pow(input_x[4], 1) * pow(input_x[5], 1);
        idvd_poly_feat[862] = pow(input_x[0], 3) * pow(input_x[3], 1) * pow(input_x[4], 1) * pow(input_x[6], 1);
        idvd_poly_feat[863] = pow(input_x[0], 3) * pow(input_x[3], 1) * pow(input_x[5], 2);
        idvd_poly_feat[864] = pow(input_x[0], 3) * pow(input_x[3], 1) * pow(input_x[5], 1) * pow(input_x[6], 1);
        idvd_poly_feat[865] = pow(input_x[0], 3) * pow(input_x[3], 1) * pow(input_x[6], 2);
        idvd_poly_feat[866] = pow(input_x[0], 3) * pow(input_x[4], 3);
        idvd_poly_feat[867] = pow(input_x[0], 3) * pow(input_x[4], 2) * pow(input_x[5], 1);
        idvd_poly_feat[868] = pow(input_x[0], 3) * pow(input_x[4], 2) * pow(input_x[6], 1);
        idvd_poly_feat[869] = pow(input_x[0], 3) * pow(input_x[4], 1) * pow(input_x[5], 2);
        idvd_poly_feat[870] = pow(input_x[0], 3) * pow(input_x[4], 1) * pow(input_x[5], 1) * pow(input_x[6], 1);
        idvd_poly_feat[871] = pow(input_x[0], 3) * pow(input_x[4], 1) * pow(input_x[6], 2);
        idvd_poly_feat[872] = pow(input_x[0], 3) * pow(input_x[5], 3);
        idvd_poly_feat[873] = pow(input_x[0], 3) * pow(input_x[5], 2) * pow(input_x[6], 1);
        idvd_poly_feat[874] = pow(input_x[0], 3) * pow(input_x[5], 1) * pow(input_x[6], 2);
        idvd_poly_feat[875] = pow(input_x[0], 3) * pow(input_x[6], 3);
        idvd_poly_feat[876] = pow(input_x[0], 2) * pow(input_x[1], 4);
        idvd_poly_feat[877] = pow(input_x[0], 2) * pow(input_x[1], 3) * pow(input_x[2], 1);
        idvd_poly_feat[878] = pow(input_x[0], 2) * pow(input_x[1], 3) * pow(input_x[3], 1);
        idvd_poly_feat[879] = pow(input_x[0], 2) * pow(input_x[1], 3) * pow(input_x[4], 1);
        idvd_poly_feat[880] = pow(input_x[0], 2) * pow(input_x[1], 3) * pow(input_x[5], 1);
        idvd_poly_feat[881] = pow(input_x[0], 2) * pow(input_x[1], 3) * pow(input_x[6], 1);
        idvd_poly_feat[882] = pow(input_x[0], 2) * pow(input_x[1], 2) * pow(input_x[2], 2);
        idvd_poly_feat[883] = pow(input_x[0], 2) * pow(input_x[1], 2) * pow(input_x[2], 1) * pow(input_x[3], 1);
        idvd_poly_feat[884] = pow(input_x[0], 2) * pow(input_x[1], 2) * pow(input_x[2], 1) * pow(input_x[4], 1);
        idvd_poly_feat[885] = pow(input_x[0], 2) * pow(input_x[1], 2) * pow(input_x[2], 1) * pow(input_x[5], 1);
        idvd_poly_feat[886] = pow(input_x[0], 2) * pow(input_x[1], 2) * pow(input_x[2], 1) * pow(input_x[6], 1);
        idvd_poly_feat[887] = pow(input_x[0], 2) * pow(input_x[1], 2) * pow(input_x[3], 2);
        idvd_poly_feat[888] = pow(input_x[0], 2) * pow(input_x[1], 2) * pow(input_x[3], 1) * pow(input_x[4], 1);
        idvd_poly_feat[889] = pow(input_x[0], 2) * pow(input_x[1], 2) * pow(input_x[3], 1) * pow(input_x[5], 1);
        idvd_poly_feat[890] = pow(input_x[0], 2) * pow(input_x[1], 2) * pow(input_x[3], 1) * pow(input_x[6], 1);
        idvd_poly_feat[891] = pow(input_x[0], 2) * pow(input_x[1], 2) * pow(input_x[4], 2);
        idvd_poly_feat[892] = pow(input_x[0], 2) * pow(input_x[1], 2) * pow(input_x[4], 1) * pow(input_x[5], 1);
        idvd_poly_feat[893] = pow(input_x[0], 2) * pow(input_x[1], 2) * pow(input_x[4], 1) * pow(input_x[6], 1);
        idvd_poly_feat[894] = pow(input_x[0], 2) * pow(input_x[1], 2) * pow(input_x[5], 2);
        idvd_poly_feat[895] = pow(input_x[0], 2) * pow(input_x[1], 2) * pow(input_x[5], 1) * pow(input_x[6], 1);
        idvd_poly_feat[896] = pow(input_x[0], 2) * pow(input_x[1], 2) * pow(input_x[6], 2);
        idvd_poly_feat[897] = pow(input_x[0], 2) * pow(input_x[1], 1) * pow(input_x[2], 3);
        idvd_poly_feat[898] = pow(input_x[0], 2) * pow(input_x[1], 1) * pow(input_x[2], 2) * pow(input_x[3], 1);
        idvd_poly_feat[899] = pow(input_x[0], 2) * pow(input_x[1], 1) * pow(input_x[2], 2) * pow(input_x[4], 1);
        idvd_poly_feat[900] = pow(input_x[0], 2) * pow(input_x[1], 1) * pow(input_x[2], 2) * pow(input_x[5], 1);
        idvd_poly_feat[901] = pow(input_x[0], 2) * pow(input_x[1], 1) * pow(input_x[2], 2) * pow(input_x[6], 1);
        idvd_poly_feat[902] = pow(input_x[0], 2) * pow(input_x[1], 1) * pow(input_x[2], 1) * pow(input_x[3], 2);
        idvd_poly_feat[903] = pow(input_x[0], 2) * pow(input_x[1], 1) * pow(input_x[2], 1) * pow(input_x[3], 1) * pow(input_x[4], 1);
        idvd_poly_feat[904] = pow(input_x[0], 2) * pow(input_x[1], 1) * pow(input_x[2], 1) * pow(input_x[3], 1) * pow(input_x[5], 1);
        idvd_poly_feat[905] = pow(input_x[0], 2) * pow(input_x[1], 1) * pow(input_x[2], 1) * pow(input_x[3], 1) * pow(input_x[6], 1);
        idvd_poly_feat[906] = pow(input_x[0], 2) * pow(input_x[1], 1) * pow(input_x[2], 1) * pow(input_x[4], 2);
        idvd_poly_feat[907] = pow(input_x[0], 2) * pow(input_x[1], 1) * pow(input_x[2], 1) * pow(input_x[4], 1) * pow(input_x[5], 1);
        idvd_poly_feat[908] = pow(input_x[0], 2) * pow(input_x[1], 1) * pow(input_x[2], 1) * pow(input_x[4], 1) * pow(input_x[6], 1);
        idvd_poly_feat[909] = pow(input_x[0], 2) * pow(input_x[1], 1) * pow(input_x[2], 1) * pow(input_x[5], 2);
        idvd_poly_feat[910] = pow(input_x[0], 2) * pow(input_x[1], 1) * pow(input_x[2], 1) * pow(input_x[5], 1) * pow(input_x[6], 1);
        idvd_poly_feat[911] = pow(input_x[0], 2) * pow(input_x[1], 1) * pow(input_x[2], 1) * pow(input_x[6], 2);
        idvd_poly_feat[912] = pow(input_x[0], 2) * pow(input_x[1], 1) * pow(input_x[3], 3);
        idvd_poly_feat[913] = pow(input_x[0], 2) * pow(input_x[1], 1) * pow(input_x[3], 2) * pow(input_x[4], 1);
        idvd_poly_feat[914] = pow(input_x[0], 2) * pow(input_x[1], 1) * pow(input_x[3], 2) * pow(input_x[5], 1);
        idvd_poly_feat[915] = pow(input_x[0], 2) * pow(input_x[1], 1) * pow(input_x[3], 2) * pow(input_x[6], 1);
        idvd_poly_feat[916] = pow(input_x[0], 2) * pow(input_x[1], 1) * pow(input_x[3], 1) * pow(input_x[4], 2);
        idvd_poly_feat[917] = pow(input_x[0], 2) * pow(input_x[1], 1) * pow(input_x[3], 1) * pow(input_x[4], 1) * pow(input_x[5], 1);
        idvd_poly_feat[918] = pow(input_x[0], 2) * pow(input_x[1], 1) * pow(input_x[3], 1) * pow(input_x[4], 1) * pow(input_x[6], 1);
        idvd_poly_feat[919] = pow(input_x[0], 2) * pow(input_x[1], 1) * pow(input_x[3], 1) * pow(input_x[5], 2);
        idvd_poly_feat[920] = pow(input_x[0], 2) * pow(input_x[1], 1) * pow(input_x[3], 1) * pow(input_x[5], 1) * pow(input_x[6], 1);
        idvd_poly_feat[921] = pow(input_x[0], 2) * pow(input_x[1], 1) * pow(input_x[3], 1) * pow(input_x[6], 2);
        idvd_poly_feat[922] = pow(input_x[0], 2) * pow(input_x[1], 1) * pow(input_x[4], 3);
        idvd_poly_feat[923] = pow(input_x[0], 2) * pow(input_x[1], 1) * pow(input_x[4], 2) * pow(input_x[5], 1);
        idvd_poly_feat[924] = pow(input_x[0], 2) * pow(input_x[1], 1) * pow(input_x[4], 2) * pow(input_x[6], 1);
        idvd_poly_feat[925] = pow(input_x[0], 2) * pow(input_x[1], 1) * pow(input_x[4], 1) * pow(input_x[5], 2);
        idvd_poly_feat[926] = pow(input_x[0], 2) * pow(input_x[1], 1) * pow(input_x[4], 1) * pow(input_x[5], 1) * pow(input_x[6], 1);
        idvd_poly_feat[927] = pow(input_x[0], 2) * pow(input_x[1], 1) * pow(input_x[4], 1) * pow(input_x[6], 2);
        idvd_poly_feat[928] = pow(input_x[0], 2) * pow(input_x[1], 1) * pow(input_x[5], 3);
        idvd_poly_feat[929] = pow(input_x[0], 2) * pow(input_x[1], 1) * pow(input_x[5], 2) * pow(input_x[6], 1);
        idvd_poly_feat[930] = pow(input_x[0], 2) * pow(input_x[1], 1) * pow(input_x[5], 1) * pow(input_x[6], 2);
        idvd_poly_feat[931] = pow(input_x[0], 2) * pow(input_x[1], 1) * pow(input_x[6], 3);
        idvd_poly_feat[932] = pow(input_x[0], 2) * pow(input_x[2], 4);
        idvd_poly_feat[933] = pow(input_x[0], 2) * pow(input_x[2], 3) * pow(input_x[3], 1);
        idvd_poly_feat[934] = pow(input_x[0], 2) * pow(input_x[2], 3) * pow(input_x[4], 1);
        idvd_poly_feat[935] = pow(input_x[0], 2) * pow(input_x[2], 3) * pow(input_x[5], 1);
        idvd_poly_feat[936] = pow(input_x[0], 2) * pow(input_x[2], 3) * pow(input_x[6], 1);
        idvd_poly_feat[937] = pow(input_x[0], 2) * pow(input_x[2], 2) * pow(input_x[3], 2);
        idvd_poly_feat[938] = pow(input_x[0], 2) * pow(input_x[2], 2) * pow(input_x[3], 1) * pow(input_x[4], 1);
        idvd_poly_feat[939] = pow(input_x[0], 2) * pow(input_x[2], 2) * pow(input_x[3], 1) * pow(input_x[5], 1);
        idvd_poly_feat[940] = pow(input_x[0], 2) * pow(input_x[2], 2) * pow(input_x[3], 1) * pow(input_x[6], 1);
        idvd_poly_feat[941] = pow(input_x[0], 2) * pow(input_x[2], 2) * pow(input_x[4], 2);
        idvd_poly_feat[942] = pow(input_x[0], 2) * pow(input_x[2], 2) * pow(input_x[4], 1) * pow(input_x[5], 1);
        idvd_poly_feat[943] = pow(input_x[0], 2) * pow(input_x[2], 2) * pow(input_x[4], 1) * pow(input_x[6], 1);
        idvd_poly_feat[944] = pow(input_x[0], 2) * pow(input_x[2], 2) * pow(input_x[5], 2);
        idvd_poly_feat[945] = pow(input_x[0], 2) * pow(input_x[2], 2) * pow(input_x[5], 1) * pow(input_x[6], 1);
        idvd_poly_feat[946] = pow(input_x[0], 2) * pow(input_x[2], 2) * pow(input_x[6], 2);
        idvd_poly_feat[947] = pow(input_x[0], 2) * pow(input_x[2], 1) * pow(input_x[3], 3);
        idvd_poly_feat[948] = pow(input_x[0], 2) * pow(input_x[2], 1) * pow(input_x[3], 2) * pow(input_x[4], 1);
        idvd_poly_feat[949] = pow(input_x[0], 2) * pow(input_x[2], 1) * pow(input_x[3], 2) * pow(input_x[5], 1);
        idvd_poly_feat[950] = pow(input_x[0], 2) * pow(input_x[2], 1) * pow(input_x[3], 2) * pow(input_x[6], 1);
        idvd_poly_feat[951] = pow(input_x[0], 2) * pow(input_x[2], 1) * pow(input_x[3], 1) * pow(input_x[4], 2);
        idvd_poly_feat[952] = pow(input_x[0], 2) * pow(input_x[2], 1) * pow(input_x[3], 1) * pow(input_x[4], 1) * pow(input_x[5], 1);
        idvd_poly_feat[953] = pow(input_x[0], 2) * pow(input_x[2], 1) * pow(input_x[3], 1) * pow(input_x[4], 1) * pow(input_x[6], 1);
        idvd_poly_feat[954] = pow(input_x[0], 2) * pow(input_x[2], 1) * pow(input_x[3], 1) * pow(input_x[5], 2);
        idvd_poly_feat[955] = pow(input_x[0], 2) * pow(input_x[2], 1) * pow(input_x[3], 1) * pow(input_x[5], 1) * pow(input_x[6], 1);
        idvd_poly_feat[956] = pow(input_x[0], 2) * pow(input_x[2], 1) * pow(input_x[3], 1) * pow(input_x[6], 2);
        idvd_poly_feat[957] = pow(input_x[0], 2) * pow(input_x[2], 1) * pow(input_x[4], 3);
        idvd_poly_feat[958] = pow(input_x[0], 2) * pow(input_x[2], 1) * pow(input_x[4], 2) * pow(input_x[5], 1);
        idvd_poly_feat[959] = pow(input_x[0], 2) * pow(input_x[2], 1) * pow(input_x[4], 2) * pow(input_x[6], 1);
        idvd_poly_feat[960] = pow(input_x[0], 2) * pow(input_x[2], 1) * pow(input_x[4], 1) * pow(input_x[5], 2);
        idvd_poly_feat[961] = pow(input_x[0], 2) * pow(input_x[2], 1) * pow(input_x[4], 1) * pow(input_x[5], 1) * pow(input_x[6], 1);
        idvd_poly_feat[962] = pow(input_x[0], 2) * pow(input_x[2], 1) * pow(input_x[4], 1) * pow(input_x[6], 2);
        idvd_poly_feat[963] = pow(input_x[0], 2) * pow(input_x[2], 1) * pow(input_x[5], 3);
        idvd_poly_feat[964] = pow(input_x[0], 2) * pow(input_x[2], 1) * pow(input_x[5], 2) * pow(input_x[6], 1);
        idvd_poly_feat[965] = pow(input_x[0], 2) * pow(input_x[2], 1) * pow(input_x[5], 1) * pow(input_x[6], 2);
        idvd_poly_feat[966] = pow(input_x[0], 2) * pow(input_x[2], 1) * pow(input_x[6], 3);
        idvd_poly_feat[967] = pow(input_x[0], 2) * pow(input_x[3], 4);
        idvd_poly_feat[968] = pow(input_x[0], 2) * pow(input_x[3], 3) * pow(input_x[4], 1);
        idvd_poly_feat[969] = pow(input_x[0], 2) * pow(input_x[3], 3) * pow(input_x[5], 1);
        idvd_poly_feat[970] = pow(input_x[0], 2) * pow(input_x[3], 3) * pow(input_x[6], 1);
        idvd_poly_feat[971] = pow(input_x[0], 2) * pow(input_x[3], 2) * pow(input_x[4], 2);
        idvd_poly_feat[972] = pow(input_x[0], 2) * pow(input_x[3], 2) * pow(input_x[4], 1) * pow(input_x[5], 1);
        idvd_poly_feat[973] = pow(input_x[0], 2) * pow(input_x[3], 2) * pow(input_x[4], 1) * pow(input_x[6], 1);
        idvd_poly_feat[974] = pow(input_x[0], 2) * pow(input_x[3], 2) * pow(input_x[5], 2);
        idvd_poly_feat[975] = pow(input_x[0], 2) * pow(input_x[3], 2) * pow(input_x[5], 1) * pow(input_x[6], 1);
        idvd_poly_feat[976] = pow(input_x[0], 2) * pow(input_x[3], 2) * pow(input_x[6], 2);
        idvd_poly_feat[977] = pow(input_x[0], 2) * pow(input_x[3], 1) * pow(input_x[4], 3);
        idvd_poly_feat[978] = pow(input_x[0], 2) * pow(input_x[3], 1) * pow(input_x[4], 2) * pow(input_x[5], 1);
        idvd_poly_feat[979] = pow(input_x[0], 2) * pow(input_x[3], 1) * pow(input_x[4], 2) * pow(input_x[6], 1);
        idvd_poly_feat[980] = pow(input_x[0], 2) * pow(input_x[3], 1) * pow(input_x[4], 1) * pow(input_x[5], 2);
        idvd_poly_feat[981] = pow(input_x[0], 2) * pow(input_x[3], 1) * pow(input_x[4], 1) * pow(input_x[5], 1) * pow(input_x[6], 1);
        idvd_poly_feat[982] = pow(input_x[0], 2) * pow(input_x[3], 1) * pow(input_x[4], 1) * pow(input_x[6], 2);
        idvd_poly_feat[983] = pow(input_x[0], 2) * pow(input_x[3], 1) * pow(input_x[5], 3);
        idvd_poly_feat[984] = pow(input_x[0], 2) * pow(input_x[3], 1) * pow(input_x[5], 2) * pow(input_x[6], 1);
        idvd_poly_feat[985] = pow(input_x[0], 2) * pow(input_x[3], 1) * pow(input_x[5], 1) * pow(input_x[6], 2);
        idvd_poly_feat[986] = pow(input_x[0], 2) * pow(input_x[3], 1) * pow(input_x[6], 3);
        idvd_poly_feat[987] = pow(input_x[0], 2) * pow(input_x[4], 4);
        idvd_poly_feat[988] = pow(input_x[0], 2) * pow(input_x[4], 3) * pow(input_x[5], 1);
        idvd_poly_feat[989] = pow(input_x[0], 2) * pow(input_x[4], 3) * pow(input_x[6], 1);
        idvd_poly_feat[990] = pow(input_x[0], 2) * pow(input_x[4], 2) * pow(input_x[5], 2);
        idvd_poly_feat[991] = pow(input_x[0], 2) * pow(input_x[4], 2) * pow(input_x[5], 1) * pow(input_x[6], 1);
        idvd_poly_feat[992] = pow(input_x[0], 2) * pow(input_x[4], 2) * pow(input_x[6], 2);
        idvd_poly_feat[993] = pow(input_x[0], 2) * pow(input_x[4], 1) * pow(input_x[5], 3);
        idvd_poly_feat[994] = pow(input_x[0], 2) * pow(input_x[4], 1) * pow(input_x[5], 2) * pow(input_x[6], 1);
        idvd_poly_feat[995] = pow(input_x[0], 2) * pow(input_x[4], 1) * pow(input_x[5], 1) * pow(input_x[6], 2);
        idvd_poly_feat[996] = pow(input_x[0], 2) * pow(input_x[4], 1) * pow(input_x[6], 3);
        idvd_poly_feat[997] = pow(input_x[0], 2) * pow(input_x[5], 4);
        idvd_poly_feat[998] = pow(input_x[0], 2) * pow(input_x[5], 3) * pow(input_x[6], 1);
        idvd_poly_feat[999] = pow(input_x[0], 2) * pow(input_x[5], 2) * pow(input_x[6], 2);
        idvd_poly_feat[1000] = pow(input_x[0], 2) * pow(input_x[5], 1) * pow(input_x[6], 3);
        idvd_poly_feat[1001] = pow(input_x[0], 2) * pow(input_x[6], 4);
        idvd_poly_feat[1002] = pow(input_x[0], 1) * pow(input_x[1], 5);
        idvd_poly_feat[1003] = pow(input_x[0], 1) * pow(input_x[1], 4) * pow(input_x[2], 1);
        idvd_poly_feat[1004] = pow(input_x[0], 1) * pow(input_x[1], 4) * pow(input_x[3], 1);
        idvd_poly_feat[1005] = pow(input_x[0], 1) * pow(input_x[1], 4) * pow(input_x[4], 1);
        idvd_poly_feat[1006] = pow(input_x[0], 1) * pow(input_x[1], 4) * pow(input_x[5], 1);
        idvd_poly_feat[1007] = pow(input_x[0], 1) * pow(input_x[1], 4) * pow(input_x[6], 1);
        idvd_poly_feat[1008] = pow(input_x[0], 1) * pow(input_x[1], 3) * pow(input_x[2], 2);
        idvd_poly_feat[1009] = pow(input_x[0], 1) * pow(input_x[1], 3) * pow(input_x[2], 1) * pow(input_x[3], 1);
        idvd_poly_feat[1010] = pow(input_x[0], 1) * pow(input_x[1], 3) * pow(input_x[2], 1) * pow(input_x[4], 1);
        idvd_poly_feat[1011] = pow(input_x[0], 1) * pow(input_x[1], 3) * pow(input_x[2], 1) * pow(input_x[5], 1);
        idvd_poly_feat[1012] = pow(input_x[0], 1) * pow(input_x[1], 3) * pow(input_x[2], 1) * pow(input_x[6], 1);
        idvd_poly_feat[1013] = pow(input_x[0], 1) * pow(input_x[1], 3) * pow(input_x[3], 2);
        idvd_poly_feat[1014] = pow(input_x[0], 1) * pow(input_x[1], 3) * pow(input_x[3], 1) * pow(input_x[4], 1);
        idvd_poly_feat[1015] = pow(input_x[0], 1) * pow(input_x[1], 3) * pow(input_x[3], 1) * pow(input_x[5], 1);
        idvd_poly_feat[1016] = pow(input_x[0], 1) * pow(input_x[1], 3) * pow(input_x[3], 1) * pow(input_x[6], 1);
        idvd_poly_feat[1017] = pow(input_x[0], 1) * pow(input_x[1], 3) * pow(input_x[4], 2);
        idvd_poly_feat[1018] = pow(input_x[0], 1) * pow(input_x[1], 3) * pow(input_x[4], 1) * pow(input_x[5], 1);
        idvd_poly_feat[1019] = pow(input_x[0], 1) * pow(input_x[1], 3) * pow(input_x[4], 1) * pow(input_x[6], 1);
        idvd_poly_feat[1020] = pow(input_x[0], 1) * pow(input_x[1], 3) * pow(input_x[5], 2);
        idvd_poly_feat[1021] = pow(input_x[0], 1) * pow(input_x[1], 3) * pow(input_x[5], 1) * pow(input_x[6], 1);
        idvd_poly_feat[1022] = pow(input_x[0], 1) * pow(input_x[1], 3) * pow(input_x[6], 2);
        idvd_poly_feat[1023] = pow(input_x[0], 1) * pow(input_x[1], 2) * pow(input_x[2], 3);
        idvd_poly_feat[1024] = pow(input_x[0], 1) * pow(input_x[1], 2) * pow(input_x[2], 2) * pow(input_x[3], 1);
        idvd_poly_feat[1025] = pow(input_x[0], 1) * pow(input_x[1], 2) * pow(input_x[2], 2) * pow(input_x[4], 1);
        idvd_poly_feat[1026] = pow(input_x[0], 1) * pow(input_x[1], 2) * pow(input_x[2], 2) * pow(input_x[5], 1);
        idvd_poly_feat[1027] = pow(input_x[0], 1) * pow(input_x[1], 2) * pow(input_x[2], 2) * pow(input_x[6], 1);
        idvd_poly_feat[1028] = pow(input_x[0], 1) * pow(input_x[1], 2) * pow(input_x[2], 1) * pow(input_x[3], 2);
        idvd_poly_feat[1029] = pow(input_x[0], 1) * pow(input_x[1], 2) * pow(input_x[2], 1) * pow(input_x[3], 1) * pow(input_x[4], 1);
        idvd_poly_feat[1030] = pow(input_x[0], 1) * pow(input_x[1], 2) * pow(input_x[2], 1) * pow(input_x[3], 1) * pow(input_x[5], 1);
        idvd_poly_feat[1031] = pow(input_x[0], 1) * pow(input_x[1], 2) * pow(input_x[2], 1) * pow(input_x[3], 1) * pow(input_x[6], 1);
        idvd_poly_feat[1032] = pow(input_x[0], 1) * pow(input_x[1], 2) * pow(input_x[2], 1) * pow(input_x[4], 2);
        idvd_poly_feat[1033] = pow(input_x[0], 1) * pow(input_x[1], 2) * pow(input_x[2], 1) * pow(input_x[4], 1) * pow(input_x[5], 1);
        idvd_poly_feat[1034] = pow(input_x[0], 1) * pow(input_x[1], 2) * pow(input_x[2], 1) * pow(input_x[4], 1) * pow(input_x[6], 1);
        idvd_poly_feat[1035] = pow(input_x[0], 1) * pow(input_x[1], 2) * pow(input_x[2], 1) * pow(input_x[5], 2);
        idvd_poly_feat[1036] = pow(input_x[0], 1) * pow(input_x[1], 2) * pow(input_x[2], 1) * pow(input_x[5], 1) * pow(input_x[6], 1);
        idvd_poly_feat[1037] = pow(input_x[0], 1) * pow(input_x[1], 2) * pow(input_x[2], 1) * pow(input_x[6], 2);
        idvd_poly_feat[1038] = pow(input_x[0], 1) * pow(input_x[1], 2) * pow(input_x[3], 3);
        idvd_poly_feat[1039] = pow(input_x[0], 1) * pow(input_x[1], 2) * pow(input_x[3], 2) * pow(input_x[4], 1);
        idvd_poly_feat[1040] = pow(input_x[0], 1) * pow(input_x[1], 2) * pow(input_x[3], 2) * pow(input_x[5], 1);
        idvd_poly_feat[1041] = pow(input_x[0], 1) * pow(input_x[1], 2) * pow(input_x[3], 2) * pow(input_x[6], 1);
        idvd_poly_feat[1042] = pow(input_x[0], 1) * pow(input_x[1], 2) * pow(input_x[3], 1) * pow(input_x[4], 2);
        idvd_poly_feat[1043] = pow(input_x[0], 1) * pow(input_x[1], 2) * pow(input_x[3], 1) * pow(input_x[4], 1) * pow(input_x[5], 1);
        idvd_poly_feat[1044] = pow(input_x[0], 1) * pow(input_x[1], 2) * pow(input_x[3], 1) * pow(input_x[4], 1) * pow(input_x[6], 1);
        idvd_poly_feat[1045] = pow(input_x[0], 1) * pow(input_x[1], 2) * pow(input_x[3], 1) * pow(input_x[5], 2);
        idvd_poly_feat[1046] = pow(input_x[0], 1) * pow(input_x[1], 2) * pow(input_x[3], 1) * pow(input_x[5], 1) * pow(input_x[6], 1);
        idvd_poly_feat[1047] = pow(input_x[0], 1) * pow(input_x[1], 2) * pow(input_x[3], 1) * pow(input_x[6], 2);
        idvd_poly_feat[1048] = pow(input_x[0], 1) * pow(input_x[1], 2) * pow(input_x[4], 3);
        idvd_poly_feat[1049] = pow(input_x[0], 1) * pow(input_x[1], 2) * pow(input_x[4], 2) * pow(input_x[5], 1);
        idvd_poly_feat[1050] = pow(input_x[0], 1) * pow(input_x[1], 2) * pow(input_x[4], 2) * pow(input_x[6], 1);
        idvd_poly_feat[1051] = pow(input_x[0], 1) * pow(input_x[1], 2) * pow(input_x[4], 1) * pow(input_x[5], 2);
        idvd_poly_feat[1052] = pow(input_x[0], 1) * pow(input_x[1], 2) * pow(input_x[4], 1) * pow(input_x[5], 1) * pow(input_x[6], 1);
        idvd_poly_feat[1053] = pow(input_x[0], 1) * pow(input_x[1], 2) * pow(input_x[4], 1) * pow(input_x[6], 2);
        idvd_poly_feat[1054] = pow(input_x[0], 1) * pow(input_x[1], 2) * pow(input_x[5], 3);
        idvd_poly_feat[1055] = pow(input_x[0], 1) * pow(input_x[1], 2) * pow(input_x[5], 2) * pow(input_x[6], 1);
        idvd_poly_feat[1056] = pow(input_x[0], 1) * pow(input_x[1], 2) * pow(input_x[5], 1) * pow(input_x[6], 2);
        idvd_poly_feat[1057] = pow(input_x[0], 1) * pow(input_x[1], 2) * pow(input_x[6], 3);
        idvd_poly_feat[1058] = pow(input_x[0], 1) * pow(input_x[1], 1) * pow(input_x[2], 4);
        idvd_poly_feat[1059] = pow(input_x[0], 1) * pow(input_x[1], 1) * pow(input_x[2], 3) * pow(input_x[3], 1);
        idvd_poly_feat[1060] = pow(input_x[0], 1) * pow(input_x[1], 1) * pow(input_x[2], 3) * pow(input_x[4], 1);
        idvd_poly_feat[1061] = pow(input_x[0], 1) * pow(input_x[1], 1) * pow(input_x[2], 3) * pow(input_x[5], 1);
        idvd_poly_feat[1062] = pow(input_x[0], 1) * pow(input_x[1], 1) * pow(input_x[2], 3) * pow(input_x[6], 1);
        idvd_poly_feat[1063] = pow(input_x[0], 1) * pow(input_x[1], 1) * pow(input_x[2], 2) * pow(input_x[3], 2);
        idvd_poly_feat[1064] = pow(input_x[0], 1) * pow(input_x[1], 1) * pow(input_x[2], 2) * pow(input_x[3], 1) * pow(input_x[4], 1);
        idvd_poly_feat[1065] = pow(input_x[0], 1) * pow(input_x[1], 1) * pow(input_x[2], 2) * pow(input_x[3], 1) * pow(input_x[5], 1);
        idvd_poly_feat[1066] = pow(input_x[0], 1) * pow(input_x[1], 1) * pow(input_x[2], 2) * pow(input_x[3], 1) * pow(input_x[6], 1);
        idvd_poly_feat[1067] = pow(input_x[0], 1) * pow(input_x[1], 1) * pow(input_x[2], 2) * pow(input_x[4], 2);
        idvd_poly_feat[1068] = pow(input_x[0], 1) * pow(input_x[1], 1) * pow(input_x[2], 2) * pow(input_x[4], 1) * pow(input_x[5], 1);
        idvd_poly_feat[1069] = pow(input_x[0], 1) * pow(input_x[1], 1) * pow(input_x[2], 2) * pow(input_x[4], 1) * pow(input_x[6], 1);
        idvd_poly_feat[1070] = pow(input_x[0], 1) * pow(input_x[1], 1) * pow(input_x[2], 2) * pow(input_x[5], 2);
        idvd_poly_feat[1071] = pow(input_x[0], 1) * pow(input_x[1], 1) * pow(input_x[2], 2) * pow(input_x[5], 1) * pow(input_x[6], 1);
        idvd_poly_feat[1072] = pow(input_x[0], 1) * pow(input_x[1], 1) * pow(input_x[2], 2) * pow(input_x[6], 2);
        idvd_poly_feat[1073] = pow(input_x[0], 1) * pow(input_x[1], 1) * pow(input_x[2], 1) * pow(input_x[3], 3);
        idvd_poly_feat[1074] = pow(input_x[0], 1) * pow(input_x[1], 1) * pow(input_x[2], 1) * pow(input_x[3], 2) * pow(input_x[4], 1);
        idvd_poly_feat[1075] = pow(input_x[0], 1) * pow(input_x[1], 1) * pow(input_x[2], 1) * pow(input_x[3], 2) * pow(input_x[5], 1);
        idvd_poly_feat[1076] = pow(input_x[0], 1) * pow(input_x[1], 1) * pow(input_x[2], 1) * pow(input_x[3], 2) * pow(input_x[6], 1);
        idvd_poly_feat[1077] = pow(input_x[0], 1) * pow(input_x[1], 1) * pow(input_x[2], 1) * pow(input_x[3], 1) * pow(input_x[4], 2);
        idvd_poly_feat[1078] = pow(input_x[0], 1) * pow(input_x[1], 1) * pow(input_x[2], 1) * pow(input_x[3], 1) * pow(input_x[4], 1) * pow(input_x[5], 1);
        idvd_poly_feat[1079] = pow(input_x[0], 1) * pow(input_x[1], 1) * pow(input_x[2], 1) * pow(input_x[3], 1) * pow(input_x[4], 1) * pow(input_x[6], 1);
        idvd_poly_feat[1080] = pow(input_x[0], 1) * pow(input_x[1], 1) * pow(input_x[2], 1) * pow(input_x[3], 1) * pow(input_x[5], 2);
        idvd_poly_feat[1081] = pow(input_x[0], 1) * pow(input_x[1], 1) * pow(input_x[2], 1) * pow(input_x[3], 1) * pow(input_x[5], 1) * pow(input_x[6], 1);
        idvd_poly_feat[1082] = pow(input_x[0], 1) * pow(input_x[1], 1) * pow(input_x[2], 1) * pow(input_x[3], 1) * pow(input_x[6], 2);
        idvd_poly_feat[1083] = pow(input_x[0], 1) * pow(input_x[1], 1) * pow(input_x[2], 1) * pow(input_x[4], 3);
        idvd_poly_feat[1084] = pow(input_x[0], 1) * pow(input_x[1], 1) * pow(input_x[2], 1) * pow(input_x[4], 2) * pow(input_x[5], 1);
        idvd_poly_feat[1085] = pow(input_x[0], 1) * pow(input_x[1], 1) * pow(input_x[2], 1) * pow(input_x[4], 2) * pow(input_x[6], 1);
        idvd_poly_feat[1086] = pow(input_x[0], 1) * pow(input_x[1], 1) * pow(input_x[2], 1) * pow(input_x[4], 1) * pow(input_x[5], 2);
        idvd_poly_feat[1087] = pow(input_x[0], 1) * pow(input_x[1], 1) * pow(input_x[2], 1) * pow(input_x[4], 1) * pow(input_x[5], 1) * pow(input_x[6], 1);
        idvd_poly_feat[1088] = pow(input_x[0], 1) * pow(input_x[1], 1) * pow(input_x[2], 1) * pow(input_x[4], 1) * pow(input_x[6], 2);
        idvd_poly_feat[1089] = pow(input_x[0], 1) * pow(input_x[1], 1) * pow(input_x[2], 1) * pow(input_x[5], 3);
        idvd_poly_feat[1090] = pow(input_x[0], 1) * pow(input_x[1], 1) * pow(input_x[2], 1) * pow(input_x[5], 2) * pow(input_x[6], 1);
        idvd_poly_feat[1091] = pow(input_x[0], 1) * pow(input_x[1], 1) * pow(input_x[2], 1) * pow(input_x[5], 1) * pow(input_x[6], 2);
        idvd_poly_feat[1092] = pow(input_x[0], 1) * pow(input_x[1], 1) * pow(input_x[2], 1) * pow(input_x[6], 3);
        idvd_poly_feat[1093] = pow(input_x[0], 1) * pow(input_x[1], 1) * pow(input_x[3], 4);
        idvd_poly_feat[1094] = pow(input_x[0], 1) * pow(input_x[1], 1) * pow(input_x[3], 3) * pow(input_x[4], 1);
        idvd_poly_feat[1095] = pow(input_x[0], 1) * pow(input_x[1], 1) * pow(input_x[3], 3) * pow(input_x[5], 1);
        idvd_poly_feat[1096] = pow(input_x[0], 1) * pow(input_x[1], 1) * pow(input_x[3], 3) * pow(input_x[6], 1);
        idvd_poly_feat[1097] = pow(input_x[0], 1) * pow(input_x[1], 1) * pow(input_x[3], 2) * pow(input_x[4], 2);
        idvd_poly_feat[1098] = pow(input_x[0], 1) * pow(input_x[1], 1) * pow(input_x[3], 2) * pow(input_x[4], 1) * pow(input_x[5], 1);
        idvd_poly_feat[1099] = pow(input_x[0], 1) * pow(input_x[1], 1) * pow(input_x[3], 2) * pow(input_x[4], 1) * pow(input_x[6], 1);
        idvd_poly_feat[1100] = pow(input_x[0], 1) * pow(input_x[1], 1) * pow(input_x[3], 2) * pow(input_x[5], 2);
        idvd_poly_feat[1101] = pow(input_x[0], 1) * pow(input_x[1], 1) * pow(input_x[3], 2) * pow(input_x[5], 1) * pow(input_x[6], 1);
        idvd_poly_feat[1102] = pow(input_x[0], 1) * pow(input_x[1], 1) * pow(input_x[3], 2) * pow(input_x[6], 2);
        idvd_poly_feat[1103] = pow(input_x[0], 1) * pow(input_x[1], 1) * pow(input_x[3], 1) * pow(input_x[4], 3);
        idvd_poly_feat[1104] = pow(input_x[0], 1) * pow(input_x[1], 1) * pow(input_x[3], 1) * pow(input_x[4], 2) * pow(input_x[5], 1);
        idvd_poly_feat[1105] = pow(input_x[0], 1) * pow(input_x[1], 1) * pow(input_x[3], 1) * pow(input_x[4], 2) * pow(input_x[6], 1);
        idvd_poly_feat[1106] = pow(input_x[0], 1) * pow(input_x[1], 1) * pow(input_x[3], 1) * pow(input_x[4], 1) * pow(input_x[5], 2);
        idvd_poly_feat[1107] = pow(input_x[0], 1) * pow(input_x[1], 1) * pow(input_x[3], 1) * pow(input_x[4], 1) * pow(input_x[5], 1) * pow(input_x[6], 1);
        idvd_poly_feat[1108] = pow(input_x[0], 1) * pow(input_x[1], 1) * pow(input_x[3], 1) * pow(input_x[4], 1) * pow(input_x[6], 2);
        idvd_poly_feat[1109] = pow(input_x[0], 1) * pow(input_x[1], 1) * pow(input_x[3], 1) * pow(input_x[5], 3);
        idvd_poly_feat[1110] = pow(input_x[0], 1) * pow(input_x[1], 1) * pow(input_x[3], 1) * pow(input_x[5], 2) * pow(input_x[6], 1);
        idvd_poly_feat[1111] = pow(input_x[0], 1) * pow(input_x[1], 1) * pow(input_x[3], 1) * pow(input_x[5], 1) * pow(input_x[6], 2);
        idvd_poly_feat[1112] = pow(input_x[0], 1) * pow(input_x[1], 1) * pow(input_x[3], 1) * pow(input_x[6], 3);
        idvd_poly_feat[1113] = pow(input_x[0], 1) * pow(input_x[1], 1) * pow(input_x[4], 4);
        idvd_poly_feat[1114] = pow(input_x[0], 1) * pow(input_x[1], 1) * pow(input_x[4], 3) * pow(input_x[5], 1);
        idvd_poly_feat[1115] = pow(input_x[0], 1) * pow(input_x[1], 1) * pow(input_x[4], 3) * pow(input_x[6], 1);
        idvd_poly_feat[1116] = pow(input_x[0], 1) * pow(input_x[1], 1) * pow(input_x[4], 2) * pow(input_x[5], 2);
        idvd_poly_feat[1117] = pow(input_x[0], 1) * pow(input_x[1], 1) * pow(input_x[4], 2) * pow(input_x[5], 1) * pow(input_x[6], 1);
        idvd_poly_feat[1118] = pow(input_x[0], 1) * pow(input_x[1], 1) * pow(input_x[4], 2) * pow(input_x[6], 2);
        idvd_poly_feat[1119] = pow(input_x[0], 1) * pow(input_x[1], 1) * pow(input_x[4], 1) * pow(input_x[5], 3);
        idvd_poly_feat[1120] = pow(input_x[0], 1) * pow(input_x[1], 1) * pow(input_x[4], 1) * pow(input_x[5], 2) * pow(input_x[6], 1);
        idvd_poly_feat[1121] = pow(input_x[0], 1) * pow(input_x[1], 1) * pow(input_x[4], 1) * pow(input_x[5], 1) * pow(input_x[6], 2);
        idvd_poly_feat[1122] = pow(input_x[0], 1) * pow(input_x[1], 1) * pow(input_x[4], 1) * pow(input_x[6], 3);
        idvd_poly_feat[1123] = pow(input_x[0], 1) * pow(input_x[1], 1) * pow(input_x[5], 4);
        idvd_poly_feat[1124] = pow(input_x[0], 1) * pow(input_x[1], 1) * pow(input_x[5], 3) * pow(input_x[6], 1);
        idvd_poly_feat[1125] = pow(input_x[0], 1) * pow(input_x[1], 1) * pow(input_x[5], 2) * pow(input_x[6], 2);
        idvd_poly_feat[1126] = pow(input_x[0], 1) * pow(input_x[1], 1) * pow(input_x[5], 1) * pow(input_x[6], 3);
        idvd_poly_feat[1127] = pow(input_x[0], 1) * pow(input_x[1], 1) * pow(input_x[6], 4);
        idvd_poly_feat[1128] = pow(input_x[0], 1) * pow(input_x[2], 5);
        idvd_poly_feat[1129] = pow(input_x[0], 1) * pow(input_x[2], 4) * pow(input_x[3], 1);
        idvd_poly_feat[1130] = pow(input_x[0], 1) * pow(input_x[2], 4) * pow(input_x[4], 1);
        idvd_poly_feat[1131] = pow(input_x[0], 1) * pow(input_x[2], 4) * pow(input_x[5], 1);
        idvd_poly_feat[1132] = pow(input_x[0], 1) * pow(input_x[2], 4) * pow(input_x[6], 1);
        idvd_poly_feat[1133] = pow(input_x[0], 1) * pow(input_x[2], 3) * pow(input_x[3], 2);
        idvd_poly_feat[1134] = pow(input_x[0], 1) * pow(input_x[2], 3) * pow(input_x[3], 1) * pow(input_x[4], 1);
        idvd_poly_feat[1135] = pow(input_x[0], 1) * pow(input_x[2], 3) * pow(input_x[3], 1) * pow(input_x[5], 1);
        idvd_poly_feat[1136] = pow(input_x[0], 1) * pow(input_x[2], 3) * pow(input_x[3], 1) * pow(input_x[6], 1);
        idvd_poly_feat[1137] = pow(input_x[0], 1) * pow(input_x[2], 3) * pow(input_x[4], 2);
        idvd_poly_feat[1138] = pow(input_x[0], 1) * pow(input_x[2], 3) * pow(input_x[4], 1) * pow(input_x[5], 1);
        idvd_poly_feat[1139] = pow(input_x[0], 1) * pow(input_x[2], 3) * pow(input_x[4], 1) * pow(input_x[6], 1);
        idvd_poly_feat[1140] = pow(input_x[0], 1) * pow(input_x[2], 3) * pow(input_x[5], 2);
        idvd_poly_feat[1141] = pow(input_x[0], 1) * pow(input_x[2], 3) * pow(input_x[5], 1) * pow(input_x[6], 1);
        idvd_poly_feat[1142] = pow(input_x[0], 1) * pow(input_x[2], 3) * pow(input_x[6], 2);
        idvd_poly_feat[1143] = pow(input_x[0], 1) * pow(input_x[2], 2) * pow(input_x[3], 3);
        idvd_poly_feat[1144] = pow(input_x[0], 1) * pow(input_x[2], 2) * pow(input_x[3], 2) * pow(input_x[4], 1);
        idvd_poly_feat[1145] = pow(input_x[0], 1) * pow(input_x[2], 2) * pow(input_x[3], 2) * pow(input_x[5], 1);
        idvd_poly_feat[1146] = pow(input_x[0], 1) * pow(input_x[2], 2) * pow(input_x[3], 2) * pow(input_x[6], 1);
        idvd_poly_feat[1147] = pow(input_x[0], 1) * pow(input_x[2], 2) * pow(input_x[3], 1) * pow(input_x[4], 2);
        idvd_poly_feat[1148] = pow(input_x[0], 1) * pow(input_x[2], 2) * pow(input_x[3], 1) * pow(input_x[4], 1) * pow(input_x[5], 1);
        idvd_poly_feat[1149] = pow(input_x[0], 1) * pow(input_x[2], 2) * pow(input_x[3], 1) * pow(input_x[4], 1) * pow(input_x[6], 1);
        idvd_poly_feat[1150] = pow(input_x[0], 1) * pow(input_x[2], 2) * pow(input_x[3], 1) * pow(input_x[5], 2);
        idvd_poly_feat[1151] = pow(input_x[0], 1) * pow(input_x[2], 2) * pow(input_x[3], 1) * pow(input_x[5], 1) * pow(input_x[6], 1);
        idvd_poly_feat[1152] = pow(input_x[0], 1) * pow(input_x[2], 2) * pow(input_x[3], 1) * pow(input_x[6], 2);
        idvd_poly_feat[1153] = pow(input_x[0], 1) * pow(input_x[2], 2) * pow(input_x[4], 3);
        idvd_poly_feat[1154] = pow(input_x[0], 1) * pow(input_x[2], 2) * pow(input_x[4], 2) * pow(input_x[5], 1);
        idvd_poly_feat[1155] = pow(input_x[0], 1) * pow(input_x[2], 2) * pow(input_x[4], 2) * pow(input_x[6], 1);
        idvd_poly_feat[1156] = pow(input_x[0], 1) * pow(input_x[2], 2) * pow(input_x[4], 1) * pow(input_x[5], 2);
        idvd_poly_feat[1157] = pow(input_x[0], 1) * pow(input_x[2], 2) * pow(input_x[4], 1) * pow(input_x[5], 1) * pow(input_x[6], 1);
        idvd_poly_feat[1158] = pow(input_x[0], 1) * pow(input_x[2], 2) * pow(input_x[4], 1) * pow(input_x[6], 2);
        idvd_poly_feat[1159] = pow(input_x[0], 1) * pow(input_x[2], 2) * pow(input_x[5], 3);
        idvd_poly_feat[1160] = pow(input_x[0], 1) * pow(input_x[2], 2) * pow(input_x[5], 2) * pow(input_x[6], 1);
        idvd_poly_feat[1161] = pow(input_x[0], 1) * pow(input_x[2], 2) * pow(input_x[5], 1) * pow(input_x[6], 2);
        idvd_poly_feat[1162] = pow(input_x[0], 1) * pow(input_x[2], 2) * pow(input_x[6], 3);
        idvd_poly_feat[1163] = pow(input_x[0], 1) * pow(input_x[2], 1) * pow(input_x[3], 4);
        idvd_poly_feat[1164] = pow(input_x[0], 1) * pow(input_x[2], 1) * pow(input_x[3], 3) * pow(input_x[4], 1);
        idvd_poly_feat[1165] = pow(input_x[0], 1) * pow(input_x[2], 1) * pow(input_x[3], 3) * pow(input_x[5], 1);
        idvd_poly_feat[1166] = pow(input_x[0], 1) * pow(input_x[2], 1) * pow(input_x[3], 3) * pow(input_x[6], 1);
        idvd_poly_feat[1167] = pow(input_x[0], 1) * pow(input_x[2], 1) * pow(input_x[3], 2) * pow(input_x[4], 2);
        idvd_poly_feat[1168] = pow(input_x[0], 1) * pow(input_x[2], 1) * pow(input_x[3], 2) * pow(input_x[4], 1) * pow(input_x[5], 1);
        idvd_poly_feat[1169] = pow(input_x[0], 1) * pow(input_x[2], 1) * pow(input_x[3], 2) * pow(input_x[4], 1) * pow(input_x[6], 1);
        idvd_poly_feat[1170] = pow(input_x[0], 1) * pow(input_x[2], 1) * pow(input_x[3], 2) * pow(input_x[5], 2);
        idvd_poly_feat[1171] = pow(input_x[0], 1) * pow(input_x[2], 1) * pow(input_x[3], 2) * pow(input_x[5], 1) * pow(input_x[6], 1);
        idvd_poly_feat[1172] = pow(input_x[0], 1) * pow(input_x[2], 1) * pow(input_x[3], 2) * pow(input_x[6], 2);
        idvd_poly_feat[1173] = pow(input_x[0], 1) * pow(input_x[2], 1) * pow(input_x[3], 1) * pow(input_x[4], 3);
        idvd_poly_feat[1174] = pow(input_x[0], 1) * pow(input_x[2], 1) * pow(input_x[3], 1) * pow(input_x[4], 2) * pow(input_x[5], 1);
        idvd_poly_feat[1175] = pow(input_x[0], 1) * pow(input_x[2], 1) * pow(input_x[3], 1) * pow(input_x[4], 2) * pow(input_x[6], 1);
        idvd_poly_feat[1176] = pow(input_x[0], 1) * pow(input_x[2], 1) * pow(input_x[3], 1) * pow(input_x[4], 1) * pow(input_x[5], 2);
        idvd_poly_feat[1177] = pow(input_x[0], 1) * pow(input_x[2], 1) * pow(input_x[3], 1) * pow(input_x[4], 1) * pow(input_x[5], 1) * pow(input_x[6], 1);
        idvd_poly_feat[1178] = pow(input_x[0], 1) * pow(input_x[2], 1) * pow(input_x[3], 1) * pow(input_x[4], 1) * pow(input_x[6], 2);
        idvd_poly_feat[1179] = pow(input_x[0], 1) * pow(input_x[2], 1) * pow(input_x[3], 1) * pow(input_x[5], 3);
        idvd_poly_feat[1180] = pow(input_x[0], 1) * pow(input_x[2], 1) * pow(input_x[3], 1) * pow(input_x[5], 2) * pow(input_x[6], 1);
        idvd_poly_feat[1181] = pow(input_x[0], 1) * pow(input_x[2], 1) * pow(input_x[3], 1) * pow(input_x[5], 1) * pow(input_x[6], 2);
        idvd_poly_feat[1182] = pow(input_x[0], 1) * pow(input_x[2], 1) * pow(input_x[3], 1) * pow(input_x[6], 3);
        idvd_poly_feat[1183] = pow(input_x[0], 1) * pow(input_x[2], 1) * pow(input_x[4], 4);
        idvd_poly_feat[1184] = pow(input_x[0], 1) * pow(input_x[2], 1) * pow(input_x[4], 3) * pow(input_x[5], 1);
        idvd_poly_feat[1185] = pow(input_x[0], 1) * pow(input_x[2], 1) * pow(input_x[4], 3) * pow(input_x[6], 1);
        idvd_poly_feat[1186] = pow(input_x[0], 1) * pow(input_x[2], 1) * pow(input_x[4], 2) * pow(input_x[5], 2);
        idvd_poly_feat[1187] = pow(input_x[0], 1) * pow(input_x[2], 1) * pow(input_x[4], 2) * pow(input_x[5], 1) * pow(input_x[6], 1);
        idvd_poly_feat[1188] = pow(input_x[0], 1) * pow(input_x[2], 1) * pow(input_x[4], 2) * pow(input_x[6], 2);
        idvd_poly_feat[1189] = pow(input_x[0], 1) * pow(input_x[2], 1) * pow(input_x[4], 1) * pow(input_x[5], 3);
        idvd_poly_feat[1190] = pow(input_x[0], 1) * pow(input_x[2], 1) * pow(input_x[4], 1) * pow(input_x[5], 2) * pow(input_x[6], 1);
        idvd_poly_feat[1191] = pow(input_x[0], 1) * pow(input_x[2], 1) * pow(input_x[4], 1) * pow(input_x[5], 1) * pow(input_x[6], 2);
        idvd_poly_feat[1192] = pow(input_x[0], 1) * pow(input_x[2], 1) * pow(input_x[4], 1) * pow(input_x[6], 3);
        idvd_poly_feat[1193] = pow(input_x[0], 1) * pow(input_x[2], 1) * pow(input_x[5], 4);
        idvd_poly_feat[1194] = pow(input_x[0], 1) * pow(input_x[2], 1) * pow(input_x[5], 3) * pow(input_x[6], 1);
        idvd_poly_feat[1195] = pow(input_x[0], 1) * pow(input_x[2], 1) * pow(input_x[5], 2) * pow(input_x[6], 2);
        idvd_poly_feat[1196] = pow(input_x[0], 1) * pow(input_x[2], 1) * pow(input_x[5], 1) * pow(input_x[6], 3);
        idvd_poly_feat[1197] = pow(input_x[0], 1) * pow(input_x[2], 1) * pow(input_x[6], 4);
        idvd_poly_feat[1198] = pow(input_x[0], 1) * pow(input_x[3], 5);
        idvd_poly_feat[1199] = pow(input_x[0], 1) * pow(input_x[3], 4) * pow(input_x[4], 1);
        idvd_poly_feat[1200] = pow(input_x[0], 1) * pow(input_x[3], 4) * pow(input_x[5], 1);
        idvd_poly_feat[1201] = pow(input_x[0], 1) * pow(input_x[3], 4) * pow(input_x[6], 1);
        idvd_poly_feat[1202] = pow(input_x[0], 1) * pow(input_x[3], 3) * pow(input_x[4], 2);
        idvd_poly_feat[1203] = pow(input_x[0], 1) * pow(input_x[3], 3) * pow(input_x[4], 1) * pow(input_x[5], 1);
        idvd_poly_feat[1204] = pow(input_x[0], 1) * pow(input_x[3], 3) * pow(input_x[4], 1) * pow(input_x[6], 1);
        idvd_poly_feat[1205] = pow(input_x[0], 1) * pow(input_x[3], 3) * pow(input_x[5], 2);
        idvd_poly_feat[1206] = pow(input_x[0], 1) * pow(input_x[3], 3) * pow(input_x[5], 1) * pow(input_x[6], 1);
        idvd_poly_feat[1207] = pow(input_x[0], 1) * pow(input_x[3], 3) * pow(input_x[6], 2);
        idvd_poly_feat[1208] = pow(input_x[0], 1) * pow(input_x[3], 2) * pow(input_x[4], 3);
        idvd_poly_feat[1209] = pow(input_x[0], 1) * pow(input_x[3], 2) * pow(input_x[4], 2) * pow(input_x[5], 1);
        idvd_poly_feat[1210] = pow(input_x[0], 1) * pow(input_x[3], 2) * pow(input_x[4], 2) * pow(input_x[6], 1);
        idvd_poly_feat[1211] = pow(input_x[0], 1) * pow(input_x[3], 2) * pow(input_x[4], 1) * pow(input_x[5], 2);
        idvd_poly_feat[1212] = pow(input_x[0], 1) * pow(input_x[3], 2) * pow(input_x[4], 1) * pow(input_x[5], 1) * pow(input_x[6], 1);
        idvd_poly_feat[1213] = pow(input_x[0], 1) * pow(input_x[3], 2) * pow(input_x[4], 1) * pow(input_x[6], 2);
        idvd_poly_feat[1214] = pow(input_x[0], 1) * pow(input_x[3], 2) * pow(input_x[5], 3);
        idvd_poly_feat[1215] = pow(input_x[0], 1) * pow(input_x[3], 2) * pow(input_x[5], 2) * pow(input_x[6], 1);
        idvd_poly_feat[1216] = pow(input_x[0], 1) * pow(input_x[3], 2) * pow(input_x[5], 1) * pow(input_x[6], 2);
        idvd_poly_feat[1217] = pow(input_x[0], 1) * pow(input_x[3], 2) * pow(input_x[6], 3);
        idvd_poly_feat[1218] = pow(input_x[0], 1) * pow(input_x[3], 1) * pow(input_x[4], 4);
        idvd_poly_feat[1219] = pow(input_x[0], 1) * pow(input_x[3], 1) * pow(input_x[4], 3) * pow(input_x[5], 1);
        idvd_poly_feat[1220] = pow(input_x[0], 1) * pow(input_x[3], 1) * pow(input_x[4], 3) * pow(input_x[6], 1);
        idvd_poly_feat[1221] = pow(input_x[0], 1) * pow(input_x[3], 1) * pow(input_x[4], 2) * pow(input_x[5], 2);
        idvd_poly_feat[1222] = pow(input_x[0], 1) * pow(input_x[3], 1) * pow(input_x[4], 2) * pow(input_x[5], 1) * pow(input_x[6], 1);
        idvd_poly_feat[1223] = pow(input_x[0], 1) * pow(input_x[3], 1) * pow(input_x[4], 2) * pow(input_x[6], 2);
        idvd_poly_feat[1224] = pow(input_x[0], 1) * pow(input_x[3], 1) * pow(input_x[4], 1) * pow(input_x[5], 3);
        idvd_poly_feat[1225] = pow(input_x[0], 1) * pow(input_x[3], 1) * pow(input_x[4], 1) * pow(input_x[5], 2) * pow(input_x[6], 1);
        idvd_poly_feat[1226] = pow(input_x[0], 1) * pow(input_x[3], 1) * pow(input_x[4], 1) * pow(input_x[5], 1) * pow(input_x[6], 2);
        idvd_poly_feat[1227] = pow(input_x[0], 1) * pow(input_x[3], 1) * pow(input_x[4], 1) * pow(input_x[6], 3);
        idvd_poly_feat[1228] = pow(input_x[0], 1) * pow(input_x[3], 1) * pow(input_x[5], 4);
        idvd_poly_feat[1229] = pow(input_x[0], 1) * pow(input_x[3], 1) * pow(input_x[5], 3) * pow(input_x[6], 1);
        idvd_poly_feat[1230] = pow(input_x[0], 1) * pow(input_x[3], 1) * pow(input_x[5], 2) * pow(input_x[6], 2);
        idvd_poly_feat[1231] = pow(input_x[0], 1) * pow(input_x[3], 1) * pow(input_x[5], 1) * pow(input_x[6], 3);
        idvd_poly_feat[1232] = pow(input_x[0], 1) * pow(input_x[3], 1) * pow(input_x[6], 4);
        idvd_poly_feat[1233] = pow(input_x[0], 1) * pow(input_x[4], 5);
        idvd_poly_feat[1234] = pow(input_x[0], 1) * pow(input_x[4], 4) * pow(input_x[5], 1);
        idvd_poly_feat[1235] = pow(input_x[0], 1) * pow(input_x[4], 4) * pow(input_x[6], 1);
        idvd_poly_feat[1236] = pow(input_x[0], 1) * pow(input_x[4], 3) * pow(input_x[5], 2);
        idvd_poly_feat[1237] = pow(input_x[0], 1) * pow(input_x[4], 3) * pow(input_x[5], 1) * pow(input_x[6], 1);
        idvd_poly_feat[1238] = pow(input_x[0], 1) * pow(input_x[4], 3) * pow(input_x[6], 2);
        idvd_poly_feat[1239] = pow(input_x[0], 1) * pow(input_x[4], 2) * pow(input_x[5], 3);
        idvd_poly_feat[1240] = pow(input_x[0], 1) * pow(input_x[4], 2) * pow(input_x[5], 2) * pow(input_x[6], 1);
        idvd_poly_feat[1241] = pow(input_x[0], 1) * pow(input_x[4], 2) * pow(input_x[5], 1) * pow(input_x[6], 2);
        idvd_poly_feat[1242] = pow(input_x[0], 1) * pow(input_x[4], 2) * pow(input_x[6], 3);
        idvd_poly_feat[1243] = pow(input_x[0], 1) * pow(input_x[4], 1) * pow(input_x[5], 4);
        idvd_poly_feat[1244] = pow(input_x[0], 1) * pow(input_x[4], 1) * pow(input_x[5], 3) * pow(input_x[6], 1);
        idvd_poly_feat[1245] = pow(input_x[0], 1) * pow(input_x[4], 1) * pow(input_x[5], 2) * pow(input_x[6], 2);
        idvd_poly_feat[1246] = pow(input_x[0], 1) * pow(input_x[4], 1) * pow(input_x[5], 1) * pow(input_x[6], 3);
        idvd_poly_feat[1247] = pow(input_x[0], 1) * pow(input_x[4], 1) * pow(input_x[6], 4);
        idvd_poly_feat[1248] = pow(input_x[0], 1) * pow(input_x[5], 5);
        idvd_poly_feat[1249] = pow(input_x[0], 1) * pow(input_x[5], 4) * pow(input_x[6], 1);
        idvd_poly_feat[1250] = pow(input_x[0], 1) * pow(input_x[5], 3) * pow(input_x[6], 2);
        idvd_poly_feat[1251] = pow(input_x[0], 1) * pow(input_x[5], 2) * pow(input_x[6], 3);
        idvd_poly_feat[1252] = pow(input_x[0], 1) * pow(input_x[5], 1) * pow(input_x[6], 4);
        idvd_poly_feat[1253] = pow(input_x[0], 1) * pow(input_x[6], 5);
        idvd_poly_feat[1254] = pow(input_x[1], 6);
        idvd_poly_feat[1255] = pow(input_x[1], 5) * pow(input_x[2], 1);
        idvd_poly_feat[1256] = pow(input_x[1], 5) * pow(input_x[3], 1);
        idvd_poly_feat[1257] = pow(input_x[1], 5) * pow(input_x[4], 1);
        idvd_poly_feat[1258] = pow(input_x[1], 5) * pow(input_x[5], 1);
        idvd_poly_feat[1259] = pow(input_x[1], 5) * pow(input_x[6], 1);
        idvd_poly_feat[1260] = pow(input_x[1], 4) * pow(input_x[2], 2);
        idvd_poly_feat[1261] = pow(input_x[1], 4) * pow(input_x[2], 1) * pow(input_x[3], 1);
        idvd_poly_feat[1262] = pow(input_x[1], 4) * pow(input_x[2], 1) * pow(input_x[4], 1);
        idvd_poly_feat[1263] = pow(input_x[1], 4) * pow(input_x[2], 1) * pow(input_x[5], 1);
        idvd_poly_feat[1264] = pow(input_x[1], 4) * pow(input_x[2], 1) * pow(input_x[6], 1);
        idvd_poly_feat[1265] = pow(input_x[1], 4) * pow(input_x[3], 2);
        idvd_poly_feat[1266] = pow(input_x[1], 4) * pow(input_x[3], 1) * pow(input_x[4], 1);
        idvd_poly_feat[1267] = pow(input_x[1], 4) * pow(input_x[3], 1) * pow(input_x[5], 1);
        idvd_poly_feat[1268] = pow(input_x[1], 4) * pow(input_x[3], 1) * pow(input_x[6], 1);
        idvd_poly_feat[1269] = pow(input_x[1], 4) * pow(input_x[4], 2);
        idvd_poly_feat[1270] = pow(input_x[1], 4) * pow(input_x[4], 1) * pow(input_x[5], 1);
        idvd_poly_feat[1271] = pow(input_x[1], 4) * pow(input_x[4], 1) * pow(input_x[6], 1);
        idvd_poly_feat[1272] = pow(input_x[1], 4) * pow(input_x[5], 2);
        idvd_poly_feat[1273] = pow(input_x[1], 4) * pow(input_x[5], 1) * pow(input_x[6], 1);
        idvd_poly_feat[1274] = pow(input_x[1], 4) * pow(input_x[6], 2);
        idvd_poly_feat[1275] = pow(input_x[1], 3) * pow(input_x[2], 3);
        idvd_poly_feat[1276] = pow(input_x[1], 3) * pow(input_x[2], 2) * pow(input_x[3], 1);
        idvd_poly_feat[1277] = pow(input_x[1], 3) * pow(input_x[2], 2) * pow(input_x[4], 1);
        idvd_poly_feat[1278] = pow(input_x[1], 3) * pow(input_x[2], 2) * pow(input_x[5], 1);
        idvd_poly_feat[1279] = pow(input_x[1], 3) * pow(input_x[2], 2) * pow(input_x[6], 1);
        idvd_poly_feat[1280] = pow(input_x[1], 3) * pow(input_x[2], 1) * pow(input_x[3], 2);
        idvd_poly_feat[1281] = pow(input_x[1], 3) * pow(input_x[2], 1) * pow(input_x[3], 1) * pow(input_x[4], 1);
        idvd_poly_feat[1282] = pow(input_x[1], 3) * pow(input_x[2], 1) * pow(input_x[3], 1) * pow(input_x[5], 1);
        idvd_poly_feat[1283] = pow(input_x[1], 3) * pow(input_x[2], 1) * pow(input_x[3], 1) * pow(input_x[6], 1);
        idvd_poly_feat[1284] = pow(input_x[1], 3) * pow(input_x[2], 1) * pow(input_x[4], 2);
        idvd_poly_feat[1285] = pow(input_x[1], 3) * pow(input_x[2], 1) * pow(input_x[4], 1) * pow(input_x[5], 1);
        idvd_poly_feat[1286] = pow(input_x[1], 3) * pow(input_x[2], 1) * pow(input_x[4], 1) * pow(input_x[6], 1);
        idvd_poly_feat[1287] = pow(input_x[1], 3) * pow(input_x[2], 1) * pow(input_x[5], 2);
        idvd_poly_feat[1288] = pow(input_x[1], 3) * pow(input_x[2], 1) * pow(input_x[5], 1) * pow(input_x[6], 1);
        idvd_poly_feat[1289] = pow(input_x[1], 3) * pow(input_x[2], 1) * pow(input_x[6], 2);
        idvd_poly_feat[1290] = pow(input_x[1], 3) * pow(input_x[3], 3);
        idvd_poly_feat[1291] = pow(input_x[1], 3) * pow(input_x[3], 2) * pow(input_x[4], 1);
        idvd_poly_feat[1292] = pow(input_x[1], 3) * pow(input_x[3], 2) * pow(input_x[5], 1);
        idvd_poly_feat[1293] = pow(input_x[1], 3) * pow(input_x[3], 2) * pow(input_x[6], 1);
        idvd_poly_feat[1294] = pow(input_x[1], 3) * pow(input_x[3], 1) * pow(input_x[4], 2);
        idvd_poly_feat[1295] = pow(input_x[1], 3) * pow(input_x[3], 1) * pow(input_x[4], 1) * pow(input_x[5], 1);
        idvd_poly_feat[1296] = pow(input_x[1], 3) * pow(input_x[3], 1) * pow(input_x[4], 1) * pow(input_x[6], 1);
        idvd_poly_feat[1297] = pow(input_x[1], 3) * pow(input_x[3], 1) * pow(input_x[5], 2);
        idvd_poly_feat[1298] = pow(input_x[1], 3) * pow(input_x[3], 1) * pow(input_x[5], 1) * pow(input_x[6], 1);
        idvd_poly_feat[1299] = pow(input_x[1], 3) * pow(input_x[3], 1) * pow(input_x[6], 2);
        idvd_poly_feat[1300] = pow(input_x[1], 3) * pow(input_x[4], 3);
        idvd_poly_feat[1301] = pow(input_x[1], 3) * pow(input_x[4], 2) * pow(input_x[5], 1);
        idvd_poly_feat[1302] = pow(input_x[1], 3) * pow(input_x[4], 2) * pow(input_x[6], 1);
        idvd_poly_feat[1303] = pow(input_x[1], 3) * pow(input_x[4], 1) * pow(input_x[5], 2);
        idvd_poly_feat[1304] = pow(input_x[1], 3) * pow(input_x[4], 1) * pow(input_x[5], 1) * pow(input_x[6], 1);
        idvd_poly_feat[1305] = pow(input_x[1], 3) * pow(input_x[4], 1) * pow(input_x[6], 2);
        idvd_poly_feat[1306] = pow(input_x[1], 3) * pow(input_x[5], 3);
        idvd_poly_feat[1307] = pow(input_x[1], 3) * pow(input_x[5], 2) * pow(input_x[6], 1);
        idvd_poly_feat[1308] = pow(input_x[1], 3) * pow(input_x[5], 1) * pow(input_x[6], 2);
        idvd_poly_feat[1309] = pow(input_x[1], 3) * pow(input_x[6], 3);
        idvd_poly_feat[1310] = pow(input_x[1], 2) * pow(input_x[2], 4);
        idvd_poly_feat[1311] = pow(input_x[1], 2) * pow(input_x[2], 3) * pow(input_x[3], 1);
        idvd_poly_feat[1312] = pow(input_x[1], 2) * pow(input_x[2], 3) * pow(input_x[4], 1);
        idvd_poly_feat[1313] = pow(input_x[1], 2) * pow(input_x[2], 3) * pow(input_x[5], 1);
        idvd_poly_feat[1314] = pow(input_x[1], 2) * pow(input_x[2], 3) * pow(input_x[6], 1);
        idvd_poly_feat[1315] = pow(input_x[1], 2) * pow(input_x[2], 2) * pow(input_x[3], 2);
        idvd_poly_feat[1316] = pow(input_x[1], 2) * pow(input_x[2], 2) * pow(input_x[3], 1) * pow(input_x[4], 1);
        idvd_poly_feat[1317] = pow(input_x[1], 2) * pow(input_x[2], 2) * pow(input_x[3], 1) * pow(input_x[5], 1);
        idvd_poly_feat[1318] = pow(input_x[1], 2) * pow(input_x[2], 2) * pow(input_x[3], 1) * pow(input_x[6], 1);
        idvd_poly_feat[1319] = pow(input_x[1], 2) * pow(input_x[2], 2) * pow(input_x[4], 2);
        idvd_poly_feat[1320] = pow(input_x[1], 2) * pow(input_x[2], 2) * pow(input_x[4], 1) * pow(input_x[5], 1);
        idvd_poly_feat[1321] = pow(input_x[1], 2) * pow(input_x[2], 2) * pow(input_x[4], 1) * pow(input_x[6], 1);
        idvd_poly_feat[1322] = pow(input_x[1], 2) * pow(input_x[2], 2) * pow(input_x[5], 2);
        idvd_poly_feat[1323] = pow(input_x[1], 2) * pow(input_x[2], 2) * pow(input_x[5], 1) * pow(input_x[6], 1);
        idvd_poly_feat[1324] = pow(input_x[1], 2) * pow(input_x[2], 2) * pow(input_x[6], 2);
        idvd_poly_feat[1325] = pow(input_x[1], 2) * pow(input_x[2], 1) * pow(input_x[3], 3);
        idvd_poly_feat[1326] = pow(input_x[1], 2) * pow(input_x[2], 1) * pow(input_x[3], 2) * pow(input_x[4], 1);
        idvd_poly_feat[1327] = pow(input_x[1], 2) * pow(input_x[2], 1) * pow(input_x[3], 2) * pow(input_x[5], 1);
        idvd_poly_feat[1328] = pow(input_x[1], 2) * pow(input_x[2], 1) * pow(input_x[3], 2) * pow(input_x[6], 1);
        idvd_poly_feat[1329] = pow(input_x[1], 2) * pow(input_x[2], 1) * pow(input_x[3], 1) * pow(input_x[4], 2);
        idvd_poly_feat[1330] = pow(input_x[1], 2) * pow(input_x[2], 1) * pow(input_x[3], 1) * pow(input_x[4], 1) * pow(input_x[5], 1);
        idvd_poly_feat[1331] = pow(input_x[1], 2) * pow(input_x[2], 1) * pow(input_x[3], 1) * pow(input_x[4], 1) * pow(input_x[6], 1);
        idvd_poly_feat[1332] = pow(input_x[1], 2) * pow(input_x[2], 1) * pow(input_x[3], 1) * pow(input_x[5], 2);
        idvd_poly_feat[1333] = pow(input_x[1], 2) * pow(input_x[2], 1) * pow(input_x[3], 1) * pow(input_x[5], 1) * pow(input_x[6], 1);
        idvd_poly_feat[1334] = pow(input_x[1], 2) * pow(input_x[2], 1) * pow(input_x[3], 1) * pow(input_x[6], 2);
        idvd_poly_feat[1335] = pow(input_x[1], 2) * pow(input_x[2], 1) * pow(input_x[4], 3);
        idvd_poly_feat[1336] = pow(input_x[1], 2) * pow(input_x[2], 1) * pow(input_x[4], 2) * pow(input_x[5], 1);
        idvd_poly_feat[1337] = pow(input_x[1], 2) * pow(input_x[2], 1) * pow(input_x[4], 2) * pow(input_x[6], 1);
        idvd_poly_feat[1338] = pow(input_x[1], 2) * pow(input_x[2], 1) * pow(input_x[4], 1) * pow(input_x[5], 2);
        idvd_poly_feat[1339] = pow(input_x[1], 2) * pow(input_x[2], 1) * pow(input_x[4], 1) * pow(input_x[5], 1) * pow(input_x[6], 1);
        idvd_poly_feat[1340] = pow(input_x[1], 2) * pow(input_x[2], 1) * pow(input_x[4], 1) * pow(input_x[6], 2);
        idvd_poly_feat[1341] = pow(input_x[1], 2) * pow(input_x[2], 1) * pow(input_x[5], 3);
        idvd_poly_feat[1342] = pow(input_x[1], 2) * pow(input_x[2], 1) * pow(input_x[5], 2) * pow(input_x[6], 1);
        idvd_poly_feat[1343] = pow(input_x[1], 2) * pow(input_x[2], 1) * pow(input_x[5], 1) * pow(input_x[6], 2);
        idvd_poly_feat[1344] = pow(input_x[1], 2) * pow(input_x[2], 1) * pow(input_x[6], 3);
        idvd_poly_feat[1345] = pow(input_x[1], 2) * pow(input_x[3], 4);
        idvd_poly_feat[1346] = pow(input_x[1], 2) * pow(input_x[3], 3) * pow(input_x[4], 1);
        idvd_poly_feat[1347] = pow(input_x[1], 2) * pow(input_x[3], 3) * pow(input_x[5], 1);
        idvd_poly_feat[1348] = pow(input_x[1], 2) * pow(input_x[3], 3) * pow(input_x[6], 1);
        idvd_poly_feat[1349] = pow(input_x[1], 2) * pow(input_x[3], 2) * pow(input_x[4], 2);
        idvd_poly_feat[1350] = pow(input_x[1], 2) * pow(input_x[3], 2) * pow(input_x[4], 1) * pow(input_x[5], 1);
        idvd_poly_feat[1351] = pow(input_x[1], 2) * pow(input_x[3], 2) * pow(input_x[4], 1) * pow(input_x[6], 1);
        idvd_poly_feat[1352] = pow(input_x[1], 2) * pow(input_x[3], 2) * pow(input_x[5], 2);
        idvd_poly_feat[1353] = pow(input_x[1], 2) * pow(input_x[3], 2) * pow(input_x[5], 1) * pow(input_x[6], 1);
        idvd_poly_feat[1354] = pow(input_x[1], 2) * pow(input_x[3], 2) * pow(input_x[6], 2);
        idvd_poly_feat[1355] = pow(input_x[1], 2) * pow(input_x[3], 1) * pow(input_x[4], 3);
        idvd_poly_feat[1356] = pow(input_x[1], 2) * pow(input_x[3], 1) * pow(input_x[4], 2) * pow(input_x[5], 1);
        idvd_poly_feat[1357] = pow(input_x[1], 2) * pow(input_x[3], 1) * pow(input_x[4], 2) * pow(input_x[6], 1);
        idvd_poly_feat[1358] = pow(input_x[1], 2) * pow(input_x[3], 1) * pow(input_x[4], 1) * pow(input_x[5], 2);
        idvd_poly_feat[1359] = pow(input_x[1], 2) * pow(input_x[3], 1) * pow(input_x[4], 1) * pow(input_x[5], 1) * pow(input_x[6], 1);
        idvd_poly_feat[1360] = pow(input_x[1], 2) * pow(input_x[3], 1) * pow(input_x[4], 1) * pow(input_x[6], 2);
        idvd_poly_feat[1361] = pow(input_x[1], 2) * pow(input_x[3], 1) * pow(input_x[5], 3);
        idvd_poly_feat[1362] = pow(input_x[1], 2) * pow(input_x[3], 1) * pow(input_x[5], 2) * pow(input_x[6], 1);
        idvd_poly_feat[1363] = pow(input_x[1], 2) * pow(input_x[3], 1) * pow(input_x[5], 1) * pow(input_x[6], 2);
        idvd_poly_feat[1364] = pow(input_x[1], 2) * pow(input_x[3], 1) * pow(input_x[6], 3);
        idvd_poly_feat[1365] = pow(input_x[1], 2) * pow(input_x[4], 4);
        idvd_poly_feat[1366] = pow(input_x[1], 2) * pow(input_x[4], 3) * pow(input_x[5], 1);
        idvd_poly_feat[1367] = pow(input_x[1], 2) * pow(input_x[4], 3) * pow(input_x[6], 1);
        idvd_poly_feat[1368] = pow(input_x[1], 2) * pow(input_x[4], 2) * pow(input_x[5], 2);
        idvd_poly_feat[1369] = pow(input_x[1], 2) * pow(input_x[4], 2) * pow(input_x[5], 1) * pow(input_x[6], 1);
        idvd_poly_feat[1370] = pow(input_x[1], 2) * pow(input_x[4], 2) * pow(input_x[6], 2);
        idvd_poly_feat[1371] = pow(input_x[1], 2) * pow(input_x[4], 1) * pow(input_x[5], 3);
        idvd_poly_feat[1372] = pow(input_x[1], 2) * pow(input_x[4], 1) * pow(input_x[5], 2) * pow(input_x[6], 1);
        idvd_poly_feat[1373] = pow(input_x[1], 2) * pow(input_x[4], 1) * pow(input_x[5], 1) * pow(input_x[6], 2);
        idvd_poly_feat[1374] = pow(input_x[1], 2) * pow(input_x[4], 1) * pow(input_x[6], 3);
        idvd_poly_feat[1375] = pow(input_x[1], 2) * pow(input_x[5], 4);
        idvd_poly_feat[1376] = pow(input_x[1], 2) * pow(input_x[5], 3) * pow(input_x[6], 1);
        idvd_poly_feat[1377] = pow(input_x[1], 2) * pow(input_x[5], 2) * pow(input_x[6], 2);
        idvd_poly_feat[1378] = pow(input_x[1], 2) * pow(input_x[5], 1) * pow(input_x[6], 3);
        idvd_poly_feat[1379] = pow(input_x[1], 2) * pow(input_x[6], 4);
        idvd_poly_feat[1380] = pow(input_x[1], 1) * pow(input_x[2], 5);
        idvd_poly_feat[1381] = pow(input_x[1], 1) * pow(input_x[2], 4) * pow(input_x[3], 1);
        idvd_poly_feat[1382] = pow(input_x[1], 1) * pow(input_x[2], 4) * pow(input_x[4], 1);
        idvd_poly_feat[1383] = pow(input_x[1], 1) * pow(input_x[2], 4) * pow(input_x[5], 1);
        idvd_poly_feat[1384] = pow(input_x[1], 1) * pow(input_x[2], 4) * pow(input_x[6], 1);
        idvd_poly_feat[1385] = pow(input_x[1], 1) * pow(input_x[2], 3) * pow(input_x[3], 2);
        idvd_poly_feat[1386] = pow(input_x[1], 1) * pow(input_x[2], 3) * pow(input_x[3], 1) * pow(input_x[4], 1);
        idvd_poly_feat[1387] = pow(input_x[1], 1) * pow(input_x[2], 3) * pow(input_x[3], 1) * pow(input_x[5], 1);
        idvd_poly_feat[1388] = pow(input_x[1], 1) * pow(input_x[2], 3) * pow(input_x[3], 1) * pow(input_x[6], 1);
        idvd_poly_feat[1389] = pow(input_x[1], 1) * pow(input_x[2], 3) * pow(input_x[4], 2);
        idvd_poly_feat[1390] = pow(input_x[1], 1) * pow(input_x[2], 3) * pow(input_x[4], 1) * pow(input_x[5], 1);
        idvd_poly_feat[1391] = pow(input_x[1], 1) * pow(input_x[2], 3) * pow(input_x[4], 1) * pow(input_x[6], 1);
        idvd_poly_feat[1392] = pow(input_x[1], 1) * pow(input_x[2], 3) * pow(input_x[5], 2);
        idvd_poly_feat[1393] = pow(input_x[1], 1) * pow(input_x[2], 3) * pow(input_x[5], 1) * pow(input_x[6], 1);
        idvd_poly_feat[1394] = pow(input_x[1], 1) * pow(input_x[2], 3) * pow(input_x[6], 2);
        idvd_poly_feat[1395] = pow(input_x[1], 1) * pow(input_x[2], 2) * pow(input_x[3], 3);
        idvd_poly_feat[1396] = pow(input_x[1], 1) * pow(input_x[2], 2) * pow(input_x[3], 2) * pow(input_x[4], 1);
        idvd_poly_feat[1397] = pow(input_x[1], 1) * pow(input_x[2], 2) * pow(input_x[3], 2) * pow(input_x[5], 1);
        idvd_poly_feat[1398] = pow(input_x[1], 1) * pow(input_x[2], 2) * pow(input_x[3], 2) * pow(input_x[6], 1);
        idvd_poly_feat[1399] = pow(input_x[1], 1) * pow(input_x[2], 2) * pow(input_x[3], 1) * pow(input_x[4], 2);
        idvd_poly_feat[1400] = pow(input_x[1], 1) * pow(input_x[2], 2) * pow(input_x[3], 1) * pow(input_x[4], 1) * pow(input_x[5], 1);
        idvd_poly_feat[1401] = pow(input_x[1], 1) * pow(input_x[2], 2) * pow(input_x[3], 1) * pow(input_x[4], 1) * pow(input_x[6], 1);
        idvd_poly_feat[1402] = pow(input_x[1], 1) * pow(input_x[2], 2) * pow(input_x[3], 1) * pow(input_x[5], 2);
        idvd_poly_feat[1403] = pow(input_x[1], 1) * pow(input_x[2], 2) * pow(input_x[3], 1) * pow(input_x[5], 1) * pow(input_x[6], 1);
        idvd_poly_feat[1404] = pow(input_x[1], 1) * pow(input_x[2], 2) * pow(input_x[3], 1) * pow(input_x[6], 2);
        idvd_poly_feat[1405] = pow(input_x[1], 1) * pow(input_x[2], 2) * pow(input_x[4], 3);
        idvd_poly_feat[1406] = pow(input_x[1], 1) * pow(input_x[2], 2) * pow(input_x[4], 2) * pow(input_x[5], 1);
        idvd_poly_feat[1407] = pow(input_x[1], 1) * pow(input_x[2], 2) * pow(input_x[4], 2) * pow(input_x[6], 1);
        idvd_poly_feat[1408] = pow(input_x[1], 1) * pow(input_x[2], 2) * pow(input_x[4], 1) * pow(input_x[5], 2);
        idvd_poly_feat[1409] = pow(input_x[1], 1) * pow(input_x[2], 2) * pow(input_x[4], 1) * pow(input_x[5], 1) * pow(input_x[6], 1);
        idvd_poly_feat[1410] = pow(input_x[1], 1) * pow(input_x[2], 2) * pow(input_x[4], 1) * pow(input_x[6], 2);
        idvd_poly_feat[1411] = pow(input_x[1], 1) * pow(input_x[2], 2) * pow(input_x[5], 3);
        idvd_poly_feat[1412] = pow(input_x[1], 1) * pow(input_x[2], 2) * pow(input_x[5], 2) * pow(input_x[6], 1);
        idvd_poly_feat[1413] = pow(input_x[1], 1) * pow(input_x[2], 2) * pow(input_x[5], 1) * pow(input_x[6], 2);
        idvd_poly_feat[1414] = pow(input_x[1], 1) * pow(input_x[2], 2) * pow(input_x[6], 3);
        idvd_poly_feat[1415] = pow(input_x[1], 1) * pow(input_x[2], 1) * pow(input_x[3], 4);
        idvd_poly_feat[1416] = pow(input_x[1], 1) * pow(input_x[2], 1) * pow(input_x[3], 3) * pow(input_x[4], 1);
        idvd_poly_feat[1417] = pow(input_x[1], 1) * pow(input_x[2], 1) * pow(input_x[3], 3) * pow(input_x[5], 1);
        idvd_poly_feat[1418] = pow(input_x[1], 1) * pow(input_x[2], 1) * pow(input_x[3], 3) * pow(input_x[6], 1);
        idvd_poly_feat[1419] = pow(input_x[1], 1) * pow(input_x[2], 1) * pow(input_x[3], 2) * pow(input_x[4], 2);
        idvd_poly_feat[1420] = pow(input_x[1], 1) * pow(input_x[2], 1) * pow(input_x[3], 2) * pow(input_x[4], 1) * pow(input_x[5], 1);
        idvd_poly_feat[1421] = pow(input_x[1], 1) * pow(input_x[2], 1) * pow(input_x[3], 2) * pow(input_x[4], 1) * pow(input_x[6], 1);
        idvd_poly_feat[1422] = pow(input_x[1], 1) * pow(input_x[2], 1) * pow(input_x[3], 2) * pow(input_x[5], 2);
        idvd_poly_feat[1423] = pow(input_x[1], 1) * pow(input_x[2], 1) * pow(input_x[3], 2) * pow(input_x[5], 1) * pow(input_x[6], 1);
        idvd_poly_feat[1424] = pow(input_x[1], 1) * pow(input_x[2], 1) * pow(input_x[3], 2) * pow(input_x[6], 2);
        idvd_poly_feat[1425] = pow(input_x[1], 1) * pow(input_x[2], 1) * pow(input_x[3], 1) * pow(input_x[4], 3);
        idvd_poly_feat[1426] = pow(input_x[1], 1) * pow(input_x[2], 1) * pow(input_x[3], 1) * pow(input_x[4], 2) * pow(input_x[5], 1);
        idvd_poly_feat[1427] = pow(input_x[1], 1) * pow(input_x[2], 1) * pow(input_x[3], 1) * pow(input_x[4], 2) * pow(input_x[6], 1);
        idvd_poly_feat[1428] = pow(input_x[1], 1) * pow(input_x[2], 1) * pow(input_x[3], 1) * pow(input_x[4], 1) * pow(input_x[5], 2);
        idvd_poly_feat[1429] = pow(input_x[1], 1) * pow(input_x[2], 1) * pow(input_x[3], 1) * pow(input_x[4], 1) * pow(input_x[5], 1) * pow(input_x[6], 1);
        idvd_poly_feat[1430] = pow(input_x[1], 1) * pow(input_x[2], 1) * pow(input_x[3], 1) * pow(input_x[4], 1) * pow(input_x[6], 2);
        idvd_poly_feat[1431] = pow(input_x[1], 1) * pow(input_x[2], 1) * pow(input_x[3], 1) * pow(input_x[5], 3);
        idvd_poly_feat[1432] = pow(input_x[1], 1) * pow(input_x[2], 1) * pow(input_x[3], 1) * pow(input_x[5], 2) * pow(input_x[6], 1);
        idvd_poly_feat[1433] = pow(input_x[1], 1) * pow(input_x[2], 1) * pow(input_x[3], 1) * pow(input_x[5], 1) * pow(input_x[6], 2);
        idvd_poly_feat[1434] = pow(input_x[1], 1) * pow(input_x[2], 1) * pow(input_x[3], 1) * pow(input_x[6], 3);
        idvd_poly_feat[1435] = pow(input_x[1], 1) * pow(input_x[2], 1) * pow(input_x[4], 4);
        idvd_poly_feat[1436] = pow(input_x[1], 1) * pow(input_x[2], 1) * pow(input_x[4], 3) * pow(input_x[5], 1);
        idvd_poly_feat[1437] = pow(input_x[1], 1) * pow(input_x[2], 1) * pow(input_x[4], 3) * pow(input_x[6], 1);
        idvd_poly_feat[1438] = pow(input_x[1], 1) * pow(input_x[2], 1) * pow(input_x[4], 2) * pow(input_x[5], 2);
        idvd_poly_feat[1439] = pow(input_x[1], 1) * pow(input_x[2], 1) * pow(input_x[4], 2) * pow(input_x[5], 1) * pow(input_x[6], 1);
        idvd_poly_feat[1440] = pow(input_x[1], 1) * pow(input_x[2], 1) * pow(input_x[4], 2) * pow(input_x[6], 2);
        idvd_poly_feat[1441] = pow(input_x[1], 1) * pow(input_x[2], 1) * pow(input_x[4], 1) * pow(input_x[5], 3);
        idvd_poly_feat[1442] = pow(input_x[1], 1) * pow(input_x[2], 1) * pow(input_x[4], 1) * pow(input_x[5], 2) * pow(input_x[6], 1);
        idvd_poly_feat[1443] = pow(input_x[1], 1) * pow(input_x[2], 1) * pow(input_x[4], 1) * pow(input_x[5], 1) * pow(input_x[6], 2);
        idvd_poly_feat[1444] = pow(input_x[1], 1) * pow(input_x[2], 1) * pow(input_x[4], 1) * pow(input_x[6], 3);
        idvd_poly_feat[1445] = pow(input_x[1], 1) * pow(input_x[2], 1) * pow(input_x[5], 4);
        idvd_poly_feat[1446] = pow(input_x[1], 1) * pow(input_x[2], 1) * pow(input_x[5], 3) * pow(input_x[6], 1);
        idvd_poly_feat[1447] = pow(input_x[1], 1) * pow(input_x[2], 1) * pow(input_x[5], 2) * pow(input_x[6], 2);
        idvd_poly_feat[1448] = pow(input_x[1], 1) * pow(input_x[2], 1) * pow(input_x[5], 1) * pow(input_x[6], 3);
        idvd_poly_feat[1449] = pow(input_x[1], 1) * pow(input_x[2], 1) * pow(input_x[6], 4);
        idvd_poly_feat[1450] = pow(input_x[1], 1) * pow(input_x[3], 5);
        idvd_poly_feat[1451] = pow(input_x[1], 1) * pow(input_x[3], 4) * pow(input_x[4], 1);
        idvd_poly_feat[1452] = pow(input_x[1], 1) * pow(input_x[3], 4) * pow(input_x[5], 1);
        idvd_poly_feat[1453] = pow(input_x[1], 1) * pow(input_x[3], 4) * pow(input_x[6], 1);
        idvd_poly_feat[1454] = pow(input_x[1], 1) * pow(input_x[3], 3) * pow(input_x[4], 2);
        idvd_poly_feat[1455] = pow(input_x[1], 1) * pow(input_x[3], 3) * pow(input_x[4], 1) * pow(input_x[5], 1);
        idvd_poly_feat[1456] = pow(input_x[1], 1) * pow(input_x[3], 3) * pow(input_x[4], 1) * pow(input_x[6], 1);
        idvd_poly_feat[1457] = pow(input_x[1], 1) * pow(input_x[3], 3) * pow(input_x[5], 2);
        idvd_poly_feat[1458] = pow(input_x[1], 1) * pow(input_x[3], 3) * pow(input_x[5], 1) * pow(input_x[6], 1);
        idvd_poly_feat[1459] = pow(input_x[1], 1) * pow(input_x[3], 3) * pow(input_x[6], 2);
        idvd_poly_feat[1460] = pow(input_x[1], 1) * pow(input_x[3], 2) * pow(input_x[4], 3);
        idvd_poly_feat[1461] = pow(input_x[1], 1) * pow(input_x[3], 2) * pow(input_x[4], 2) * pow(input_x[5], 1);
        idvd_poly_feat[1462] = pow(input_x[1], 1) * pow(input_x[3], 2) * pow(input_x[4], 2) * pow(input_x[6], 1);
        idvd_poly_feat[1463] = pow(input_x[1], 1) * pow(input_x[3], 2) * pow(input_x[4], 1) * pow(input_x[5], 2);
        idvd_poly_feat[1464] = pow(input_x[1], 1) * pow(input_x[3], 2) * pow(input_x[4], 1) * pow(input_x[5], 1) * pow(input_x[6], 1);
        idvd_poly_feat[1465] = pow(input_x[1], 1) * pow(input_x[3], 2) * pow(input_x[4], 1) * pow(input_x[6], 2);
        idvd_poly_feat[1466] = pow(input_x[1], 1) * pow(input_x[3], 2) * pow(input_x[5], 3);
        idvd_poly_feat[1467] = pow(input_x[1], 1) * pow(input_x[3], 2) * pow(input_x[5], 2) * pow(input_x[6], 1);
        idvd_poly_feat[1468] = pow(input_x[1], 1) * pow(input_x[3], 2) * pow(input_x[5], 1) * pow(input_x[6], 2);
        idvd_poly_feat[1469] = pow(input_x[1], 1) * pow(input_x[3], 2) * pow(input_x[6], 3);
        idvd_poly_feat[1470] = pow(input_x[1], 1) * pow(input_x[3], 1) * pow(input_x[4], 4);
        idvd_poly_feat[1471] = pow(input_x[1], 1) * pow(input_x[3], 1) * pow(input_x[4], 3) * pow(input_x[5], 1);
        idvd_poly_feat[1472] = pow(input_x[1], 1) * pow(input_x[3], 1) * pow(input_x[4], 3) * pow(input_x[6], 1);
        idvd_poly_feat[1473] = pow(input_x[1], 1) * pow(input_x[3], 1) * pow(input_x[4], 2) * pow(input_x[5], 2);
        idvd_poly_feat[1474] = pow(input_x[1], 1) * pow(input_x[3], 1) * pow(input_x[4], 2) * pow(input_x[5], 1) * pow(input_x[6], 1);
        idvd_poly_feat[1475] = pow(input_x[1], 1) * pow(input_x[3], 1) * pow(input_x[4], 2) * pow(input_x[6], 2);
        idvd_poly_feat[1476] = pow(input_x[1], 1) * pow(input_x[3], 1) * pow(input_x[4], 1) * pow(input_x[5], 3);
        idvd_poly_feat[1477] = pow(input_x[1], 1) * pow(input_x[3], 1) * pow(input_x[4], 1) * pow(input_x[5], 2) * pow(input_x[6], 1);
        idvd_poly_feat[1478] = pow(input_x[1], 1) * pow(input_x[3], 1) * pow(input_x[4], 1) * pow(input_x[5], 1) * pow(input_x[6], 2);
        idvd_poly_feat[1479] = pow(input_x[1], 1) * pow(input_x[3], 1) * pow(input_x[4], 1) * pow(input_x[6], 3);
        idvd_poly_feat[1480] = pow(input_x[1], 1) * pow(input_x[3], 1) * pow(input_x[5], 4);
        idvd_poly_feat[1481] = pow(input_x[1], 1) * pow(input_x[3], 1) * pow(input_x[5], 3) * pow(input_x[6], 1);
        idvd_poly_feat[1482] = pow(input_x[1], 1) * pow(input_x[3], 1) * pow(input_x[5], 2) * pow(input_x[6], 2);
        idvd_poly_feat[1483] = pow(input_x[1], 1) * pow(input_x[3], 1) * pow(input_x[5], 1) * pow(input_x[6], 3);
        idvd_poly_feat[1484] = pow(input_x[1], 1) * pow(input_x[3], 1) * pow(input_x[6], 4);
        idvd_poly_feat[1485] = pow(input_x[1], 1) * pow(input_x[4], 5);
        idvd_poly_feat[1486] = pow(input_x[1], 1) * pow(input_x[4], 4) * pow(input_x[5], 1);
        idvd_poly_feat[1487] = pow(input_x[1], 1) * pow(input_x[4], 4) * pow(input_x[6], 1);
        idvd_poly_feat[1488] = pow(input_x[1], 1) * pow(input_x[4], 3) * pow(input_x[5], 2);
        idvd_poly_feat[1489] = pow(input_x[1], 1) * pow(input_x[4], 3) * pow(input_x[5], 1) * pow(input_x[6], 1);
        idvd_poly_feat[1490] = pow(input_x[1], 1) * pow(input_x[4], 3) * pow(input_x[6], 2);
        idvd_poly_feat[1491] = pow(input_x[1], 1) * pow(input_x[4], 2) * pow(input_x[5], 3);
        idvd_poly_feat[1492] = pow(input_x[1], 1) * pow(input_x[4], 2) * pow(input_x[5], 2) * pow(input_x[6], 1);
        idvd_poly_feat[1493] = pow(input_x[1], 1) * pow(input_x[4], 2) * pow(input_x[5], 1) * pow(input_x[6], 2);
        idvd_poly_feat[1494] = pow(input_x[1], 1) * pow(input_x[4], 2) * pow(input_x[6], 3);
        idvd_poly_feat[1495] = pow(input_x[1], 1) * pow(input_x[4], 1) * pow(input_x[5], 4);
        idvd_poly_feat[1496] = pow(input_x[1], 1) * pow(input_x[4], 1) * pow(input_x[5], 3) * pow(input_x[6], 1);
        idvd_poly_feat[1497] = pow(input_x[1], 1) * pow(input_x[4], 1) * pow(input_x[5], 2) * pow(input_x[6], 2);
        idvd_poly_feat[1498] = pow(input_x[1], 1) * pow(input_x[4], 1) * pow(input_x[5], 1) * pow(input_x[6], 3);
        idvd_poly_feat[1499] = pow(input_x[1], 1) * pow(input_x[4], 1) * pow(input_x[6], 4);
        idvd_poly_feat[1500] = pow(input_x[1], 1) * pow(input_x[5], 5);
        idvd_poly_feat[1501] = pow(input_x[1], 1) * pow(input_x[5], 4) * pow(input_x[6], 1);
        idvd_poly_feat[1502] = pow(input_x[1], 1) * pow(input_x[5], 3) * pow(input_x[6], 2);
        idvd_poly_feat[1503] = pow(input_x[1], 1) * pow(input_x[5], 2) * pow(input_x[6], 3);
        idvd_poly_feat[1504] = pow(input_x[1], 1) * pow(input_x[5], 1) * pow(input_x[6], 4);
        idvd_poly_feat[1505] = pow(input_x[1], 1) * pow(input_x[6], 5);
        idvd_poly_feat[1506] = pow(input_x[2], 6);
        idvd_poly_feat[1507] = pow(input_x[2], 5) * pow(input_x[3], 1);
        idvd_poly_feat[1508] = pow(input_x[2], 5) * pow(input_x[4], 1);
        idvd_poly_feat[1509] = pow(input_x[2], 5) * pow(input_x[5], 1);
        idvd_poly_feat[1510] = pow(input_x[2], 5) * pow(input_x[6], 1);
        idvd_poly_feat[1511] = pow(input_x[2], 4) * pow(input_x[3], 2);
        idvd_poly_feat[1512] = pow(input_x[2], 4) * pow(input_x[3], 1) * pow(input_x[4], 1);
        idvd_poly_feat[1513] = pow(input_x[2], 4) * pow(input_x[3], 1) * pow(input_x[5], 1);
        idvd_poly_feat[1514] = pow(input_x[2], 4) * pow(input_x[3], 1) * pow(input_x[6], 1);
        idvd_poly_feat[1515] = pow(input_x[2], 4) * pow(input_x[4], 2);
        idvd_poly_feat[1516] = pow(input_x[2], 4) * pow(input_x[4], 1) * pow(input_x[5], 1);
        idvd_poly_feat[1517] = pow(input_x[2], 4) * pow(input_x[4], 1) * pow(input_x[6], 1);
        idvd_poly_feat[1518] = pow(input_x[2], 4) * pow(input_x[5], 2);
        idvd_poly_feat[1519] = pow(input_x[2], 4) * pow(input_x[5], 1) * pow(input_x[6], 1);
        idvd_poly_feat[1520] = pow(input_x[2], 4) * pow(input_x[6], 2);
        idvd_poly_feat[1521] = pow(input_x[2], 3) * pow(input_x[3], 3);
        idvd_poly_feat[1522] = pow(input_x[2], 3) * pow(input_x[3], 2) * pow(input_x[4], 1);
        idvd_poly_feat[1523] = pow(input_x[2], 3) * pow(input_x[3], 2) * pow(input_x[5], 1);
        idvd_poly_feat[1524] = pow(input_x[2], 3) * pow(input_x[3], 2) * pow(input_x[6], 1);
        idvd_poly_feat[1525] = pow(input_x[2], 3) * pow(input_x[3], 1) * pow(input_x[4], 2);
        idvd_poly_feat[1526] = pow(input_x[2], 3) * pow(input_x[3], 1) * pow(input_x[4], 1) * pow(input_x[5], 1);
        idvd_poly_feat[1527] = pow(input_x[2], 3) * pow(input_x[3], 1) * pow(input_x[4], 1) * pow(input_x[6], 1);
        idvd_poly_feat[1528] = pow(input_x[2], 3) * pow(input_x[3], 1) * pow(input_x[5], 2);
        idvd_poly_feat[1529] = pow(input_x[2], 3) * pow(input_x[3], 1) * pow(input_x[5], 1) * pow(input_x[6], 1);
        idvd_poly_feat[1530] = pow(input_x[2], 3) * pow(input_x[3], 1) * pow(input_x[6], 2);
        idvd_poly_feat[1531] = pow(input_x[2], 3) * pow(input_x[4], 3);
        idvd_poly_feat[1532] = pow(input_x[2], 3) * pow(input_x[4], 2) * pow(input_x[5], 1);
        idvd_poly_feat[1533] = pow(input_x[2], 3) * pow(input_x[4], 2) * pow(input_x[6], 1);
        idvd_poly_feat[1534] = pow(input_x[2], 3) * pow(input_x[4], 1) * pow(input_x[5], 2);
        idvd_poly_feat[1535] = pow(input_x[2], 3) * pow(input_x[4], 1) * pow(input_x[5], 1) * pow(input_x[6], 1);
        idvd_poly_feat[1536] = pow(input_x[2], 3) * pow(input_x[4], 1) * pow(input_x[6], 2);
        idvd_poly_feat[1537] = pow(input_x[2], 3) * pow(input_x[5], 3);
        idvd_poly_feat[1538] = pow(input_x[2], 3) * pow(input_x[5], 2) * pow(input_x[6], 1);
        idvd_poly_feat[1539] = pow(input_x[2], 3) * pow(input_x[5], 1) * pow(input_x[6], 2);
        idvd_poly_feat[1540] = pow(input_x[2], 3) * pow(input_x[6], 3);
        idvd_poly_feat[1541] = pow(input_x[2], 2) * pow(input_x[3], 4);
        idvd_poly_feat[1542] = pow(input_x[2], 2) * pow(input_x[3], 3) * pow(input_x[4], 1);
        idvd_poly_feat[1543] = pow(input_x[2], 2) * pow(input_x[3], 3) * pow(input_x[5], 1);
        idvd_poly_feat[1544] = pow(input_x[2], 2) * pow(input_x[3], 3) * pow(input_x[6], 1);
        idvd_poly_feat[1545] = pow(input_x[2], 2) * pow(input_x[3], 2) * pow(input_x[4], 2);
        idvd_poly_feat[1546] = pow(input_x[2], 2) * pow(input_x[3], 2) * pow(input_x[4], 1) * pow(input_x[5], 1);
        idvd_poly_feat[1547] = pow(input_x[2], 2) * pow(input_x[3], 2) * pow(input_x[4], 1) * pow(input_x[6], 1);
        idvd_poly_feat[1548] = pow(input_x[2], 2) * pow(input_x[3], 2) * pow(input_x[5], 2);
        idvd_poly_feat[1549] = pow(input_x[2], 2) * pow(input_x[3], 2) * pow(input_x[5], 1) * pow(input_x[6], 1);
        idvd_poly_feat[1550] = pow(input_x[2], 2) * pow(input_x[3], 2) * pow(input_x[6], 2);
        idvd_poly_feat[1551] = pow(input_x[2], 2) * pow(input_x[3], 1) * pow(input_x[4], 3);
        idvd_poly_feat[1552] = pow(input_x[2], 2) * pow(input_x[3], 1) * pow(input_x[4], 2) * pow(input_x[5], 1);
        idvd_poly_feat[1553] = pow(input_x[2], 2) * pow(input_x[3], 1) * pow(input_x[4], 2) * pow(input_x[6], 1);
        idvd_poly_feat[1554] = pow(input_x[2], 2) * pow(input_x[3], 1) * pow(input_x[4], 1) * pow(input_x[5], 2);
        idvd_poly_feat[1555] = pow(input_x[2], 2) * pow(input_x[3], 1) * pow(input_x[4], 1) * pow(input_x[5], 1) * pow(input_x[6], 1);
        idvd_poly_feat[1556] = pow(input_x[2], 2) * pow(input_x[3], 1) * pow(input_x[4], 1) * pow(input_x[6], 2);
        idvd_poly_feat[1557] = pow(input_x[2], 2) * pow(input_x[3], 1) * pow(input_x[5], 3);
        idvd_poly_feat[1558] = pow(input_x[2], 2) * pow(input_x[3], 1) * pow(input_x[5], 2) * pow(input_x[6], 1);
        idvd_poly_feat[1559] = pow(input_x[2], 2) * pow(input_x[3], 1) * pow(input_x[5], 1) * pow(input_x[6], 2);
        idvd_poly_feat[1560] = pow(input_x[2], 2) * pow(input_x[3], 1) * pow(input_x[6], 3);
        idvd_poly_feat[1561] = pow(input_x[2], 2) * pow(input_x[4], 4);
        idvd_poly_feat[1562] = pow(input_x[2], 2) * pow(input_x[4], 3) * pow(input_x[5], 1);
        idvd_poly_feat[1563] = pow(input_x[2], 2) * pow(input_x[4], 3) * pow(input_x[6], 1);
        idvd_poly_feat[1564] = pow(input_x[2], 2) * pow(input_x[4], 2) * pow(input_x[5], 2);
        idvd_poly_feat[1565] = pow(input_x[2], 2) * pow(input_x[4], 2) * pow(input_x[5], 1) * pow(input_x[6], 1);
        idvd_poly_feat[1566] = pow(input_x[2], 2) * pow(input_x[4], 2) * pow(input_x[6], 2);
        idvd_poly_feat[1567] = pow(input_x[2], 2) * pow(input_x[4], 1) * pow(input_x[5], 3);
        idvd_poly_feat[1568] = pow(input_x[2], 2) * pow(input_x[4], 1) * pow(input_x[5], 2) * pow(input_x[6], 1);
        idvd_poly_feat[1569] = pow(input_x[2], 2) * pow(input_x[4], 1) * pow(input_x[5], 1) * pow(input_x[6], 2);
        idvd_poly_feat[1570] = pow(input_x[2], 2) * pow(input_x[4], 1) * pow(input_x[6], 3);
        idvd_poly_feat[1571] = pow(input_x[2], 2) * pow(input_x[5], 4);
        idvd_poly_feat[1572] = pow(input_x[2], 2) * pow(input_x[5], 3) * pow(input_x[6], 1);
        idvd_poly_feat[1573] = pow(input_x[2], 2) * pow(input_x[5], 2) * pow(input_x[6], 2);
        idvd_poly_feat[1574] = pow(input_x[2], 2) * pow(input_x[5], 1) * pow(input_x[6], 3);
        idvd_poly_feat[1575] = pow(input_x[2], 2) * pow(input_x[6], 4);
        idvd_poly_feat[1576] = pow(input_x[2], 1) * pow(input_x[3], 5);
        idvd_poly_feat[1577] = pow(input_x[2], 1) * pow(input_x[3], 4) * pow(input_x[4], 1);
        idvd_poly_feat[1578] = pow(input_x[2], 1) * pow(input_x[3], 4) * pow(input_x[5], 1);
        idvd_poly_feat[1579] = pow(input_x[2], 1) * pow(input_x[3], 4) * pow(input_x[6], 1);
        idvd_poly_feat[1580] = pow(input_x[2], 1) * pow(input_x[3], 3) * pow(input_x[4], 2);
        idvd_poly_feat[1581] = pow(input_x[2], 1) * pow(input_x[3], 3) * pow(input_x[4], 1) * pow(input_x[5], 1);
        idvd_poly_feat[1582] = pow(input_x[2], 1) * pow(input_x[3], 3) * pow(input_x[4], 1) * pow(input_x[6], 1);
        idvd_poly_feat[1583] = pow(input_x[2], 1) * pow(input_x[3], 3) * pow(input_x[5], 2);
        idvd_poly_feat[1584] = pow(input_x[2], 1) * pow(input_x[3], 3) * pow(input_x[5], 1) * pow(input_x[6], 1);
        idvd_poly_feat[1585] = pow(input_x[2], 1) * pow(input_x[3], 3) * pow(input_x[6], 2);
        idvd_poly_feat[1586] = pow(input_x[2], 1) * pow(input_x[3], 2) * pow(input_x[4], 3);
        idvd_poly_feat[1587] = pow(input_x[2], 1) * pow(input_x[3], 2) * pow(input_x[4], 2) * pow(input_x[5], 1);
        idvd_poly_feat[1588] = pow(input_x[2], 1) * pow(input_x[3], 2) * pow(input_x[4], 2) * pow(input_x[6], 1);
        idvd_poly_feat[1589] = pow(input_x[2], 1) * pow(input_x[3], 2) * pow(input_x[4], 1) * pow(input_x[5], 2);
        idvd_poly_feat[1590] = pow(input_x[2], 1) * pow(input_x[3], 2) * pow(input_x[4], 1) * pow(input_x[5], 1) * pow(input_x[6], 1);
        idvd_poly_feat[1591] = pow(input_x[2], 1) * pow(input_x[3], 2) * pow(input_x[4], 1) * pow(input_x[6], 2);
        idvd_poly_feat[1592] = pow(input_x[2], 1) * pow(input_x[3], 2) * pow(input_x[5], 3);
        idvd_poly_feat[1593] = pow(input_x[2], 1) * pow(input_x[3], 2) * pow(input_x[5], 2) * pow(input_x[6], 1);
        idvd_poly_feat[1594] = pow(input_x[2], 1) * pow(input_x[3], 2) * pow(input_x[5], 1) * pow(input_x[6], 2);
        idvd_poly_feat[1595] = pow(input_x[2], 1) * pow(input_x[3], 2) * pow(input_x[6], 3);
        idvd_poly_feat[1596] = pow(input_x[2], 1) * pow(input_x[3], 1) * pow(input_x[4], 4);
        idvd_poly_feat[1597] = pow(input_x[2], 1) * pow(input_x[3], 1) * pow(input_x[4], 3) * pow(input_x[5], 1);
        idvd_poly_feat[1598] = pow(input_x[2], 1) * pow(input_x[3], 1) * pow(input_x[4], 3) * pow(input_x[6], 1);
        idvd_poly_feat[1599] = pow(input_x[2], 1) * pow(input_x[3], 1) * pow(input_x[4], 2) * pow(input_x[5], 2);
        idvd_poly_feat[1600] = pow(input_x[2], 1) * pow(input_x[3], 1) * pow(input_x[4], 2) * pow(input_x[5], 1) * pow(input_x[6], 1);
        idvd_poly_feat[1601] = pow(input_x[2], 1) * pow(input_x[3], 1) * pow(input_x[4], 2) * pow(input_x[6], 2);
        idvd_poly_feat[1602] = pow(input_x[2], 1) * pow(input_x[3], 1) * pow(input_x[4], 1) * pow(input_x[5], 3);
        idvd_poly_feat[1603] = pow(input_x[2], 1) * pow(input_x[3], 1) * pow(input_x[4], 1) * pow(input_x[5], 2) * pow(input_x[6], 1);
        idvd_poly_feat[1604] = pow(input_x[2], 1) * pow(input_x[3], 1) * pow(input_x[4], 1) * pow(input_x[5], 1) * pow(input_x[6], 2);
        idvd_poly_feat[1605] = pow(input_x[2], 1) * pow(input_x[3], 1) * pow(input_x[4], 1) * pow(input_x[6], 3);
        idvd_poly_feat[1606] = pow(input_x[2], 1) * pow(input_x[3], 1) * pow(input_x[5], 4);
        idvd_poly_feat[1607] = pow(input_x[2], 1) * pow(input_x[3], 1) * pow(input_x[5], 3) * pow(input_x[6], 1);
        idvd_poly_feat[1608] = pow(input_x[2], 1) * pow(input_x[3], 1) * pow(input_x[5], 2) * pow(input_x[6], 2);
        idvd_poly_feat[1609] = pow(input_x[2], 1) * pow(input_x[3], 1) * pow(input_x[5], 1) * pow(input_x[6], 3);
        idvd_poly_feat[1610] = pow(input_x[2], 1) * pow(input_x[3], 1) * pow(input_x[6], 4);
        idvd_poly_feat[1611] = pow(input_x[2], 1) * pow(input_x[4], 5);
        idvd_poly_feat[1612] = pow(input_x[2], 1) * pow(input_x[4], 4) * pow(input_x[5], 1);
        idvd_poly_feat[1613] = pow(input_x[2], 1) * pow(input_x[4], 4) * pow(input_x[6], 1);
        idvd_poly_feat[1614] = pow(input_x[2], 1) * pow(input_x[4], 3) * pow(input_x[5], 2);
        idvd_poly_feat[1615] = pow(input_x[2], 1) * pow(input_x[4], 3) * pow(input_x[5], 1) * pow(input_x[6], 1);
        idvd_poly_feat[1616] = pow(input_x[2], 1) * pow(input_x[4], 3) * pow(input_x[6], 2);
        idvd_poly_feat[1617] = pow(input_x[2], 1) * pow(input_x[4], 2) * pow(input_x[5], 3);
        idvd_poly_feat[1618] = pow(input_x[2], 1) * pow(input_x[4], 2) * pow(input_x[5], 2) * pow(input_x[6], 1);
        idvd_poly_feat[1619] = pow(input_x[2], 1) * pow(input_x[4], 2) * pow(input_x[5], 1) * pow(input_x[6], 2);
        idvd_poly_feat[1620] = pow(input_x[2], 1) * pow(input_x[4], 2) * pow(input_x[6], 3);
        idvd_poly_feat[1621] = pow(input_x[2], 1) * pow(input_x[4], 1) * pow(input_x[5], 4);
        idvd_poly_feat[1622] = pow(input_x[2], 1) * pow(input_x[4], 1) * pow(input_x[5], 3) * pow(input_x[6], 1);
        idvd_poly_feat[1623] = pow(input_x[2], 1) * pow(input_x[4], 1) * pow(input_x[5], 2) * pow(input_x[6], 2);
        idvd_poly_feat[1624] = pow(input_x[2], 1) * pow(input_x[4], 1) * pow(input_x[5], 1) * pow(input_x[6], 3);
        idvd_poly_feat[1625] = pow(input_x[2], 1) * pow(input_x[4], 1) * pow(input_x[6], 4);
        idvd_poly_feat[1626] = pow(input_x[2], 1) * pow(input_x[5], 5);
        idvd_poly_feat[1627] = pow(input_x[2], 1) * pow(input_x[5], 4) * pow(input_x[6], 1);
        idvd_poly_feat[1628] = pow(input_x[2], 1) * pow(input_x[5], 3) * pow(input_x[6], 2);
        idvd_poly_feat[1629] = pow(input_x[2], 1) * pow(input_x[5], 2) * pow(input_x[6], 3);
        idvd_poly_feat[1630] = pow(input_x[2], 1) * pow(input_x[5], 1) * pow(input_x[6], 4);
        idvd_poly_feat[1631] = pow(input_x[2], 1) * pow(input_x[6], 5);
        idvd_poly_feat[1632] = pow(input_x[3], 6);
        idvd_poly_feat[1633] = pow(input_x[3], 5) * pow(input_x[4], 1);
        idvd_poly_feat[1634] = pow(input_x[3], 5) * pow(input_x[5], 1);
        idvd_poly_feat[1635] = pow(input_x[3], 5) * pow(input_x[6], 1);
        idvd_poly_feat[1636] = pow(input_x[3], 4) * pow(input_x[4], 2);
        idvd_poly_feat[1637] = pow(input_x[3], 4) * pow(input_x[4], 1) * pow(input_x[5], 1);
        idvd_poly_feat[1638] = pow(input_x[3], 4) * pow(input_x[4], 1) * pow(input_x[6], 1);
        idvd_poly_feat[1639] = pow(input_x[3], 4) * pow(input_x[5], 2);
        idvd_poly_feat[1640] = pow(input_x[3], 4) * pow(input_x[5], 1) * pow(input_x[6], 1);
        idvd_poly_feat[1641] = pow(input_x[3], 4) * pow(input_x[6], 2);
        idvd_poly_feat[1642] = pow(input_x[3], 3) * pow(input_x[4], 3);
        idvd_poly_feat[1643] = pow(input_x[3], 3) * pow(input_x[4], 2) * pow(input_x[5], 1);
        idvd_poly_feat[1644] = pow(input_x[3], 3) * pow(input_x[4], 2) * pow(input_x[6], 1);
        idvd_poly_feat[1645] = pow(input_x[3], 3) * pow(input_x[4], 1) * pow(input_x[5], 2);
        idvd_poly_feat[1646] = pow(input_x[3], 3) * pow(input_x[4], 1) * pow(input_x[5], 1) * pow(input_x[6], 1);
        idvd_poly_feat[1647] = pow(input_x[3], 3) * pow(input_x[4], 1) * pow(input_x[6], 2);
        idvd_poly_feat[1648] = pow(input_x[3], 3) * pow(input_x[5], 3);
        idvd_poly_feat[1649] = pow(input_x[3], 3) * pow(input_x[5], 2) * pow(input_x[6], 1);
        idvd_poly_feat[1650] = pow(input_x[3], 3) * pow(input_x[5], 1) * pow(input_x[6], 2);
        idvd_poly_feat[1651] = pow(input_x[3], 3) * pow(input_x[6], 3);
        idvd_poly_feat[1652] = pow(input_x[3], 2) * pow(input_x[4], 4);
        idvd_poly_feat[1653] = pow(input_x[3], 2) * pow(input_x[4], 3) * pow(input_x[5], 1);
        idvd_poly_feat[1654] = pow(input_x[3], 2) * pow(input_x[4], 3) * pow(input_x[6], 1);
        idvd_poly_feat[1655] = pow(input_x[3], 2) * pow(input_x[4], 2) * pow(input_x[5], 2);
        idvd_poly_feat[1656] = pow(input_x[3], 2) * pow(input_x[4], 2) * pow(input_x[5], 1) * pow(input_x[6], 1);
        idvd_poly_feat[1657] = pow(input_x[3], 2) * pow(input_x[4], 2) * pow(input_x[6], 2);
        idvd_poly_feat[1658] = pow(input_x[3], 2) * pow(input_x[4], 1) * pow(input_x[5], 3);
        idvd_poly_feat[1659] = pow(input_x[3], 2) * pow(input_x[4], 1) * pow(input_x[5], 2) * pow(input_x[6], 1);
        idvd_poly_feat[1660] = pow(input_x[3], 2) * pow(input_x[4], 1) * pow(input_x[5], 1) * pow(input_x[6], 2);
        idvd_poly_feat[1661] = pow(input_x[3], 2) * pow(input_x[4], 1) * pow(input_x[6], 3);
        idvd_poly_feat[1662] = pow(input_x[3], 2) * pow(input_x[5], 4);
        idvd_poly_feat[1663] = pow(input_x[3], 2) * pow(input_x[5], 3) * pow(input_x[6], 1);
        idvd_poly_feat[1664] = pow(input_x[3], 2) * pow(input_x[5], 2) * pow(input_x[6], 2);
        idvd_poly_feat[1665] = pow(input_x[3], 2) * pow(input_x[5], 1) * pow(input_x[6], 3);
        idvd_poly_feat[1666] = pow(input_x[3], 2) * pow(input_x[6], 4);
        idvd_poly_feat[1667] = pow(input_x[3], 1) * pow(input_x[4], 5);
        idvd_poly_feat[1668] = pow(input_x[3], 1) * pow(input_x[4], 4) * pow(input_x[5], 1);
        idvd_poly_feat[1669] = pow(input_x[3], 1) * pow(input_x[4], 4) * pow(input_x[6], 1);
        idvd_poly_feat[1670] = pow(input_x[3], 1) * pow(input_x[4], 3) * pow(input_x[5], 2);
        idvd_poly_feat[1671] = pow(input_x[3], 1) * pow(input_x[4], 3) * pow(input_x[5], 1) * pow(input_x[6], 1);
        idvd_poly_feat[1672] = pow(input_x[3], 1) * pow(input_x[4], 3) * pow(input_x[6], 2);
        idvd_poly_feat[1673] = pow(input_x[3], 1) * pow(input_x[4], 2) * pow(input_x[5], 3);
        idvd_poly_feat[1674] = pow(input_x[3], 1) * pow(input_x[4], 2) * pow(input_x[5], 2) * pow(input_x[6], 1);
        idvd_poly_feat[1675] = pow(input_x[3], 1) * pow(input_x[4], 2) * pow(input_x[5], 1) * pow(input_x[6], 2);
        idvd_poly_feat[1676] = pow(input_x[3], 1) * pow(input_x[4], 2) * pow(input_x[6], 3);
        idvd_poly_feat[1677] = pow(input_x[3], 1) * pow(input_x[4], 1) * pow(input_x[5], 4);
        idvd_poly_feat[1678] = pow(input_x[3], 1) * pow(input_x[4], 1) * pow(input_x[5], 3) * pow(input_x[6], 1);
        idvd_poly_feat[1679] = pow(input_x[3], 1) * pow(input_x[4], 1) * pow(input_x[5], 2) * pow(input_x[6], 2);
        idvd_poly_feat[1680] = pow(input_x[3], 1) * pow(input_x[4], 1) * pow(input_x[5], 1) * pow(input_x[6], 3);
        idvd_poly_feat[1681] = pow(input_x[3], 1) * pow(input_x[4], 1) * pow(input_x[6], 4);
        idvd_poly_feat[1682] = pow(input_x[3], 1) * pow(input_x[5], 5);
        idvd_poly_feat[1683] = pow(input_x[3], 1) * pow(input_x[5], 4) * pow(input_x[6], 1);
        idvd_poly_feat[1684] = pow(input_x[3], 1) * pow(input_x[5], 3) * pow(input_x[6], 2);
        idvd_poly_feat[1685] = pow(input_x[3], 1) * pow(input_x[5], 2) * pow(input_x[6], 3);
        idvd_poly_feat[1686] = pow(input_x[3], 1) * pow(input_x[5], 1) * pow(input_x[6], 4);
        idvd_poly_feat[1687] = pow(input_x[3], 1) * pow(input_x[6], 5);
        idvd_poly_feat[1688] = pow(input_x[4], 6);
        idvd_poly_feat[1689] = pow(input_x[4], 5) * pow(input_x[5], 1);
        idvd_poly_feat[1690] = pow(input_x[4], 5) * pow(input_x[6], 1);
        idvd_poly_feat[1691] = pow(input_x[4], 4) * pow(input_x[5], 2);
        idvd_poly_feat[1692] = pow(input_x[4], 4) * pow(input_x[5], 1) * pow(input_x[6], 1);
        idvd_poly_feat[1693] = pow(input_x[4], 4) * pow(input_x[6], 2);
        idvd_poly_feat[1694] = pow(input_x[4], 3) * pow(input_x[5], 3);
        idvd_poly_feat[1695] = pow(input_x[4], 3) * pow(input_x[5], 2) * pow(input_x[6], 1);
        idvd_poly_feat[1696] = pow(input_x[4], 3) * pow(input_x[5], 1) * pow(input_x[6], 2);
        idvd_poly_feat[1697] = pow(input_x[4], 3) * pow(input_x[6], 3);
        idvd_poly_feat[1698] = pow(input_x[4], 2) * pow(input_x[5], 4);
        idvd_poly_feat[1699] = pow(input_x[4], 2) * pow(input_x[5], 3) * pow(input_x[6], 1);
        idvd_poly_feat[1700] = pow(input_x[4], 2) * pow(input_x[5], 2) * pow(input_x[6], 2);
        idvd_poly_feat[1701] = pow(input_x[4], 2) * pow(input_x[5], 1) * pow(input_x[6], 3);
        idvd_poly_feat[1702] = pow(input_x[4], 2) * pow(input_x[6], 4);
        idvd_poly_feat[1703] = pow(input_x[4], 1) * pow(input_x[5], 5);
        idvd_poly_feat[1704] = pow(input_x[4], 1) * pow(input_x[5], 4) * pow(input_x[6], 1);
        idvd_poly_feat[1705] = pow(input_x[4], 1) * pow(input_x[5], 3) * pow(input_x[6], 2);
        idvd_poly_feat[1706] = pow(input_x[4], 1) * pow(input_x[5], 2) * pow(input_x[6], 3);
        idvd_poly_feat[1707] = pow(input_x[4], 1) * pow(input_x[5], 1) * pow(input_x[6], 4);
        idvd_poly_feat[1708] = pow(input_x[4], 1) * pow(input_x[6], 5);
        idvd_poly_feat[1709] = pow(input_x[5], 6);
        idvd_poly_feat[1710] = pow(input_x[5], 5) * pow(input_x[6], 1);
        idvd_poly_feat[1711] = pow(input_x[5], 4) * pow(input_x[6], 2);
        idvd_poly_feat[1712] = pow(input_x[5], 3) * pow(input_x[6], 3);
        idvd_poly_feat[1713] = pow(input_x[5], 2) * pow(input_x[6], 4);
        idvd_poly_feat[1714] = pow(input_x[5], 1) * pow(input_x[6], 5);
        idvd_poly_feat[1715] = pow(input_x[6], 6);
        idvd_poly_feat[1716] = pow(input_x[0], 7);
        idvd_poly_feat[1717] = pow(input_x[0], 6) * pow(input_x[1], 1);
        idvd_poly_feat[1718] = pow(input_x[0], 6) * pow(input_x[2], 1);
        idvd_poly_feat[1719] = pow(input_x[0], 6) * pow(input_x[3], 1);
        idvd_poly_feat[1720] = pow(input_x[0], 6) * pow(input_x[4], 1);
        idvd_poly_feat[1721] = pow(input_x[0], 6) * pow(input_x[5], 1);
        idvd_poly_feat[1722] = pow(input_x[0], 6) * pow(input_x[6], 1);
        idvd_poly_feat[1723] = pow(input_x[0], 5) * pow(input_x[1], 2);
        idvd_poly_feat[1724] = pow(input_x[0], 5) * pow(input_x[1], 1) * pow(input_x[2], 1);
        idvd_poly_feat[1725] = pow(input_x[0], 5) * pow(input_x[1], 1) * pow(input_x[3], 1);
        idvd_poly_feat[1726] = pow(input_x[0], 5) * pow(input_x[1], 1) * pow(input_x[4], 1);
        idvd_poly_feat[1727] = pow(input_x[0], 5) * pow(input_x[1], 1) * pow(input_x[5], 1);
        idvd_poly_feat[1728] = pow(input_x[0], 5) * pow(input_x[1], 1) * pow(input_x[6], 1);
        idvd_poly_feat[1729] = pow(input_x[0], 5) * pow(input_x[2], 2);
        idvd_poly_feat[1730] = pow(input_x[0], 5) * pow(input_x[2], 1) * pow(input_x[3], 1);
        idvd_poly_feat[1731] = pow(input_x[0], 5) * pow(input_x[2], 1) * pow(input_x[4], 1);
        idvd_poly_feat[1732] = pow(input_x[0], 5) * pow(input_x[2], 1) * pow(input_x[5], 1);
        idvd_poly_feat[1733] = pow(input_x[0], 5) * pow(input_x[2], 1) * pow(input_x[6], 1);
        idvd_poly_feat[1734] = pow(input_x[0], 5) * pow(input_x[3], 2);
        idvd_poly_feat[1735] = pow(input_x[0], 5) * pow(input_x[3], 1) * pow(input_x[4], 1);
        idvd_poly_feat[1736] = pow(input_x[0], 5) * pow(input_x[3], 1) * pow(input_x[5], 1);
        idvd_poly_feat[1737] = pow(input_x[0], 5) * pow(input_x[3], 1) * pow(input_x[6], 1);
        idvd_poly_feat[1738] = pow(input_x[0], 5) * pow(input_x[4], 2);
        idvd_poly_feat[1739] = pow(input_x[0], 5) * pow(input_x[4], 1) * pow(input_x[5], 1);
        idvd_poly_feat[1740] = pow(input_x[0], 5) * pow(input_x[4], 1) * pow(input_x[6], 1);
        idvd_poly_feat[1741] = pow(input_x[0], 5) * pow(input_x[5], 2);
        idvd_poly_feat[1742] = pow(input_x[0], 5) * pow(input_x[5], 1) * pow(input_x[6], 1);
        idvd_poly_feat[1743] = pow(input_x[0], 5) * pow(input_x[6], 2);
        idvd_poly_feat[1744] = pow(input_x[0], 4) * pow(input_x[1], 3);
        idvd_poly_feat[1745] = pow(input_x[0], 4) * pow(input_x[1], 2) * pow(input_x[2], 1);
        idvd_poly_feat[1746] = pow(input_x[0], 4) * pow(input_x[1], 2) * pow(input_x[3], 1);
        idvd_poly_feat[1747] = pow(input_x[0], 4) * pow(input_x[1], 2) * pow(input_x[4], 1);
        idvd_poly_feat[1748] = pow(input_x[0], 4) * pow(input_x[1], 2) * pow(input_x[5], 1);
        idvd_poly_feat[1749] = pow(input_x[0], 4) * pow(input_x[1], 2) * pow(input_x[6], 1);
        idvd_poly_feat[1750] = pow(input_x[0], 4) * pow(input_x[1], 1) * pow(input_x[2], 2);
        idvd_poly_feat[1751] = pow(input_x[0], 4) * pow(input_x[1], 1) * pow(input_x[2], 1) * pow(input_x[3], 1);
        idvd_poly_feat[1752] = pow(input_x[0], 4) * pow(input_x[1], 1) * pow(input_x[2], 1) * pow(input_x[4], 1);
        idvd_poly_feat[1753] = pow(input_x[0], 4) * pow(input_x[1], 1) * pow(input_x[2], 1) * pow(input_x[5], 1);
        idvd_poly_feat[1754] = pow(input_x[0], 4) * pow(input_x[1], 1) * pow(input_x[2], 1) * pow(input_x[6], 1);
        idvd_poly_feat[1755] = pow(input_x[0], 4) * pow(input_x[1], 1) * pow(input_x[3], 2);
        idvd_poly_feat[1756] = pow(input_x[0], 4) * pow(input_x[1], 1) * pow(input_x[3], 1) * pow(input_x[4], 1);
        idvd_poly_feat[1757] = pow(input_x[0], 4) * pow(input_x[1], 1) * pow(input_x[3], 1) * pow(input_x[5], 1);
        idvd_poly_feat[1758] = pow(input_x[0], 4) * pow(input_x[1], 1) * pow(input_x[3], 1) * pow(input_x[6], 1);
        idvd_poly_feat[1759] = pow(input_x[0], 4) * pow(input_x[1], 1) * pow(input_x[4], 2);
        idvd_poly_feat[1760] = pow(input_x[0], 4) * pow(input_x[1], 1) * pow(input_x[4], 1) * pow(input_x[5], 1);
        idvd_poly_feat[1761] = pow(input_x[0], 4) * pow(input_x[1], 1) * pow(input_x[4], 1) * pow(input_x[6], 1);
        idvd_poly_feat[1762] = pow(input_x[0], 4) * pow(input_x[1], 1) * pow(input_x[5], 2);
        idvd_poly_feat[1763] = pow(input_x[0], 4) * pow(input_x[1], 1) * pow(input_x[5], 1) * pow(input_x[6], 1);
        idvd_poly_feat[1764] = pow(input_x[0], 4) * pow(input_x[1], 1) * pow(input_x[6], 2);
        idvd_poly_feat[1765] = pow(input_x[0], 4) * pow(input_x[2], 3);
        idvd_poly_feat[1766] = pow(input_x[0], 4) * pow(input_x[2], 2) * pow(input_x[3], 1);
        idvd_poly_feat[1767] = pow(input_x[0], 4) * pow(input_x[2], 2) * pow(input_x[4], 1);
        idvd_poly_feat[1768] = pow(input_x[0], 4) * pow(input_x[2], 2) * pow(input_x[5], 1);
        idvd_poly_feat[1769] = pow(input_x[0], 4) * pow(input_x[2], 2) * pow(input_x[6], 1);
        idvd_poly_feat[1770] = pow(input_x[0], 4) * pow(input_x[2], 1) * pow(input_x[3], 2);
        idvd_poly_feat[1771] = pow(input_x[0], 4) * pow(input_x[2], 1) * pow(input_x[3], 1) * pow(input_x[4], 1);
        idvd_poly_feat[1772] = pow(input_x[0], 4) * pow(input_x[2], 1) * pow(input_x[3], 1) * pow(input_x[5], 1);
        idvd_poly_feat[1773] = pow(input_x[0], 4) * pow(input_x[2], 1) * pow(input_x[3], 1) * pow(input_x[6], 1);
        idvd_poly_feat[1774] = pow(input_x[0], 4) * pow(input_x[2], 1) * pow(input_x[4], 2);
        idvd_poly_feat[1775] = pow(input_x[0], 4) * pow(input_x[2], 1) * pow(input_x[4], 1) * pow(input_x[5], 1);
        idvd_poly_feat[1776] = pow(input_x[0], 4) * pow(input_x[2], 1) * pow(input_x[4], 1) * pow(input_x[6], 1);
        idvd_poly_feat[1777] = pow(input_x[0], 4) * pow(input_x[2], 1) * pow(input_x[5], 2);
        idvd_poly_feat[1778] = pow(input_x[0], 4) * pow(input_x[2], 1) * pow(input_x[5], 1) * pow(input_x[6], 1);
        idvd_poly_feat[1779] = pow(input_x[0], 4) * pow(input_x[2], 1) * pow(input_x[6], 2);
        idvd_poly_feat[1780] = pow(input_x[0], 4) * pow(input_x[3], 3);
        idvd_poly_feat[1781] = pow(input_x[0], 4) * pow(input_x[3], 2) * pow(input_x[4], 1);
        idvd_poly_feat[1782] = pow(input_x[0], 4) * pow(input_x[3], 2) * pow(input_x[5], 1);
        idvd_poly_feat[1783] = pow(input_x[0], 4) * pow(input_x[3], 2) * pow(input_x[6], 1);
        idvd_poly_feat[1784] = pow(input_x[0], 4) * pow(input_x[3], 1) * pow(input_x[4], 2);
        idvd_poly_feat[1785] = pow(input_x[0], 4) * pow(input_x[3], 1) * pow(input_x[4], 1) * pow(input_x[5], 1);
        idvd_poly_feat[1786] = pow(input_x[0], 4) * pow(input_x[3], 1) * pow(input_x[4], 1) * pow(input_x[6], 1);
        idvd_poly_feat[1787] = pow(input_x[0], 4) * pow(input_x[3], 1) * pow(input_x[5], 2);
        idvd_poly_feat[1788] = pow(input_x[0], 4) * pow(input_x[3], 1) * pow(input_x[5], 1) * pow(input_x[6], 1);
        idvd_poly_feat[1789] = pow(input_x[0], 4) * pow(input_x[3], 1) * pow(input_x[6], 2);
        idvd_poly_feat[1790] = pow(input_x[0], 4) * pow(input_x[4], 3);
        idvd_poly_feat[1791] = pow(input_x[0], 4) * pow(input_x[4], 2) * pow(input_x[5], 1);
        idvd_poly_feat[1792] = pow(input_x[0], 4) * pow(input_x[4], 2) * pow(input_x[6], 1);
        idvd_poly_feat[1793] = pow(input_x[0], 4) * pow(input_x[4], 1) * pow(input_x[5], 2);
        idvd_poly_feat[1794] = pow(input_x[0], 4) * pow(input_x[4], 1) * pow(input_x[5], 1) * pow(input_x[6], 1);
        idvd_poly_feat[1795] = pow(input_x[0], 4) * pow(input_x[4], 1) * pow(input_x[6], 2);
        idvd_poly_feat[1796] = pow(input_x[0], 4) * pow(input_x[5], 3);
        idvd_poly_feat[1797] = pow(input_x[0], 4) * pow(input_x[5], 2) * pow(input_x[6], 1);
        idvd_poly_feat[1798] = pow(input_x[0], 4) * pow(input_x[5], 1) * pow(input_x[6], 2);
        idvd_poly_feat[1799] = pow(input_x[0], 4) * pow(input_x[6], 3);
        idvd_poly_feat[1800] = pow(input_x[0], 3) * pow(input_x[1], 4);
        idvd_poly_feat[1801] = pow(input_x[0], 3) * pow(input_x[1], 3) * pow(input_x[2], 1);
        idvd_poly_feat[1802] = pow(input_x[0], 3) * pow(input_x[1], 3) * pow(input_x[3], 1);
        idvd_poly_feat[1803] = pow(input_x[0], 3) * pow(input_x[1], 3) * pow(input_x[4], 1);
        idvd_poly_feat[1804] = pow(input_x[0], 3) * pow(input_x[1], 3) * pow(input_x[5], 1);
        idvd_poly_feat[1805] = pow(input_x[0], 3) * pow(input_x[1], 3) * pow(input_x[6], 1);
        idvd_poly_feat[1806] = pow(input_x[0], 3) * pow(input_x[1], 2) * pow(input_x[2], 2);
        idvd_poly_feat[1807] = pow(input_x[0], 3) * pow(input_x[1], 2) * pow(input_x[2], 1) * pow(input_x[3], 1);
        idvd_poly_feat[1808] = pow(input_x[0], 3) * pow(input_x[1], 2) * pow(input_x[2], 1) * pow(input_x[4], 1);
        idvd_poly_feat[1809] = pow(input_x[0], 3) * pow(input_x[1], 2) * pow(input_x[2], 1) * pow(input_x[5], 1);
        idvd_poly_feat[1810] = pow(input_x[0], 3) * pow(input_x[1], 2) * pow(input_x[2], 1) * pow(input_x[6], 1);
        idvd_poly_feat[1811] = pow(input_x[0], 3) * pow(input_x[1], 2) * pow(input_x[3], 2);
        idvd_poly_feat[1812] = pow(input_x[0], 3) * pow(input_x[1], 2) * pow(input_x[3], 1) * pow(input_x[4], 1);
        idvd_poly_feat[1813] = pow(input_x[0], 3) * pow(input_x[1], 2) * pow(input_x[3], 1) * pow(input_x[5], 1);
        idvd_poly_feat[1814] = pow(input_x[0], 3) * pow(input_x[1], 2) * pow(input_x[3], 1) * pow(input_x[6], 1);
        idvd_poly_feat[1815] = pow(input_x[0], 3) * pow(input_x[1], 2) * pow(input_x[4], 2);
        idvd_poly_feat[1816] = pow(input_x[0], 3) * pow(input_x[1], 2) * pow(input_x[4], 1) * pow(input_x[5], 1);
        idvd_poly_feat[1817] = pow(input_x[0], 3) * pow(input_x[1], 2) * pow(input_x[4], 1) * pow(input_x[6], 1);
        idvd_poly_feat[1818] = pow(input_x[0], 3) * pow(input_x[1], 2) * pow(input_x[5], 2);
        idvd_poly_feat[1819] = pow(input_x[0], 3) * pow(input_x[1], 2) * pow(input_x[5], 1) * pow(input_x[6], 1);
        idvd_poly_feat[1820] = pow(input_x[0], 3) * pow(input_x[1], 2) * pow(input_x[6], 2);
        idvd_poly_feat[1821] = pow(input_x[0], 3) * pow(input_x[1], 1) * pow(input_x[2], 3);
        idvd_poly_feat[1822] = pow(input_x[0], 3) * pow(input_x[1], 1) * pow(input_x[2], 2) * pow(input_x[3], 1);
        idvd_poly_feat[1823] = pow(input_x[0], 3) * pow(input_x[1], 1) * pow(input_x[2], 2) * pow(input_x[4], 1);
        idvd_poly_feat[1824] = pow(input_x[0], 3) * pow(input_x[1], 1) * pow(input_x[2], 2) * pow(input_x[5], 1);
        idvd_poly_feat[1825] = pow(input_x[0], 3) * pow(input_x[1], 1) * pow(input_x[2], 2) * pow(input_x[6], 1);
        idvd_poly_feat[1826] = pow(input_x[0], 3) * pow(input_x[1], 1) * pow(input_x[2], 1) * pow(input_x[3], 2);
        idvd_poly_feat[1827] = pow(input_x[0], 3) * pow(input_x[1], 1) * pow(input_x[2], 1) * pow(input_x[3], 1) * pow(input_x[4], 1);
        idvd_poly_feat[1828] = pow(input_x[0], 3) * pow(input_x[1], 1) * pow(input_x[2], 1) * pow(input_x[3], 1) * pow(input_x[5], 1);
        idvd_poly_feat[1829] = pow(input_x[0], 3) * pow(input_x[1], 1) * pow(input_x[2], 1) * pow(input_x[3], 1) * pow(input_x[6], 1);
        idvd_poly_feat[1830] = pow(input_x[0], 3) * pow(input_x[1], 1) * pow(input_x[2], 1) * pow(input_x[4], 2);
        idvd_poly_feat[1831] = pow(input_x[0], 3) * pow(input_x[1], 1) * pow(input_x[2], 1) * pow(input_x[4], 1) * pow(input_x[5], 1);
        idvd_poly_feat[1832] = pow(input_x[0], 3) * pow(input_x[1], 1) * pow(input_x[2], 1) * pow(input_x[4], 1) * pow(input_x[6], 1);
        idvd_poly_feat[1833] = pow(input_x[0], 3) * pow(input_x[1], 1) * pow(input_x[2], 1) * pow(input_x[5], 2);
        idvd_poly_feat[1834] = pow(input_x[0], 3) * pow(input_x[1], 1) * pow(input_x[2], 1) * pow(input_x[5], 1) * pow(input_x[6], 1);
        idvd_poly_feat[1835] = pow(input_x[0], 3) * pow(input_x[1], 1) * pow(input_x[2], 1) * pow(input_x[6], 2);
        idvd_poly_feat[1836] = pow(input_x[0], 3) * pow(input_x[1], 1) * pow(input_x[3], 3);
        idvd_poly_feat[1837] = pow(input_x[0], 3) * pow(input_x[1], 1) * pow(input_x[3], 2) * pow(input_x[4], 1);
        idvd_poly_feat[1838] = pow(input_x[0], 3) * pow(input_x[1], 1) * pow(input_x[3], 2) * pow(input_x[5], 1);
        idvd_poly_feat[1839] = pow(input_x[0], 3) * pow(input_x[1], 1) * pow(input_x[3], 2) * pow(input_x[6], 1);
        idvd_poly_feat[1840] = pow(input_x[0], 3) * pow(input_x[1], 1) * pow(input_x[3], 1) * pow(input_x[4], 2);
        idvd_poly_feat[1841] = pow(input_x[0], 3) * pow(input_x[1], 1) * pow(input_x[3], 1) * pow(input_x[4], 1) * pow(input_x[5], 1);
        idvd_poly_feat[1842] = pow(input_x[0], 3) * pow(input_x[1], 1) * pow(input_x[3], 1) * pow(input_x[4], 1) * pow(input_x[6], 1);
        idvd_poly_feat[1843] = pow(input_x[0], 3) * pow(input_x[1], 1) * pow(input_x[3], 1) * pow(input_x[5], 2);
        idvd_poly_feat[1844] = pow(input_x[0], 3) * pow(input_x[1], 1) * pow(input_x[3], 1) * pow(input_x[5], 1) * pow(input_x[6], 1);
        idvd_poly_feat[1845] = pow(input_x[0], 3) * pow(input_x[1], 1) * pow(input_x[3], 1) * pow(input_x[6], 2);
        idvd_poly_feat[1846] = pow(input_x[0], 3) * pow(input_x[1], 1) * pow(input_x[4], 3);
        idvd_poly_feat[1847] = pow(input_x[0], 3) * pow(input_x[1], 1) * pow(input_x[4], 2) * pow(input_x[5], 1);
        idvd_poly_feat[1848] = pow(input_x[0], 3) * pow(input_x[1], 1) * pow(input_x[4], 2) * pow(input_x[6], 1);
        idvd_poly_feat[1849] = pow(input_x[0], 3) * pow(input_x[1], 1) * pow(input_x[4], 1) * pow(input_x[5], 2);
        idvd_poly_feat[1850] = pow(input_x[0], 3) * pow(input_x[1], 1) * pow(input_x[4], 1) * pow(input_x[5], 1) * pow(input_x[6], 1);
        idvd_poly_feat[1851] = pow(input_x[0], 3) * pow(input_x[1], 1) * pow(input_x[4], 1) * pow(input_x[6], 2);
        idvd_poly_feat[1852] = pow(input_x[0], 3) * pow(input_x[1], 1) * pow(input_x[5], 3);
        idvd_poly_feat[1853] = pow(input_x[0], 3) * pow(input_x[1], 1) * pow(input_x[5], 2) * pow(input_x[6], 1);
        idvd_poly_feat[1854] = pow(input_x[0], 3) * pow(input_x[1], 1) * pow(input_x[5], 1) * pow(input_x[6], 2);
        idvd_poly_feat[1855] = pow(input_x[0], 3) * pow(input_x[1], 1) * pow(input_x[6], 3);
        idvd_poly_feat[1856] = pow(input_x[0], 3) * pow(input_x[2], 4);
        idvd_poly_feat[1857] = pow(input_x[0], 3) * pow(input_x[2], 3) * pow(input_x[3], 1);
        idvd_poly_feat[1858] = pow(input_x[0], 3) * pow(input_x[2], 3) * pow(input_x[4], 1);
        idvd_poly_feat[1859] = pow(input_x[0], 3) * pow(input_x[2], 3) * pow(input_x[5], 1);
        idvd_poly_feat[1860] = pow(input_x[0], 3) * pow(input_x[2], 3) * pow(input_x[6], 1);
        idvd_poly_feat[1861] = pow(input_x[0], 3) * pow(input_x[2], 2) * pow(input_x[3], 2);
        idvd_poly_feat[1862] = pow(input_x[0], 3) * pow(input_x[2], 2) * pow(input_x[3], 1) * pow(input_x[4], 1);
        idvd_poly_feat[1863] = pow(input_x[0], 3) * pow(input_x[2], 2) * pow(input_x[3], 1) * pow(input_x[5], 1);
        idvd_poly_feat[1864] = pow(input_x[0], 3) * pow(input_x[2], 2) * pow(input_x[3], 1) * pow(input_x[6], 1);
        idvd_poly_feat[1865] = pow(input_x[0], 3) * pow(input_x[2], 2) * pow(input_x[4], 2);
        idvd_poly_feat[1866] = pow(input_x[0], 3) * pow(input_x[2], 2) * pow(input_x[4], 1) * pow(input_x[5], 1);
        idvd_poly_feat[1867] = pow(input_x[0], 3) * pow(input_x[2], 2) * pow(input_x[4], 1) * pow(input_x[6], 1);
        idvd_poly_feat[1868] = pow(input_x[0], 3) * pow(input_x[2], 2) * pow(input_x[5], 2);
        idvd_poly_feat[1869] = pow(input_x[0], 3) * pow(input_x[2], 2) * pow(input_x[5], 1) * pow(input_x[6], 1);
        idvd_poly_feat[1870] = pow(input_x[0], 3) * pow(input_x[2], 2) * pow(input_x[6], 2);
        idvd_poly_feat[1871] = pow(input_x[0], 3) * pow(input_x[2], 1) * pow(input_x[3], 3);
        idvd_poly_feat[1872] = pow(input_x[0], 3) * pow(input_x[2], 1) * pow(input_x[3], 2) * pow(input_x[4], 1);
        idvd_poly_feat[1873] = pow(input_x[0], 3) * pow(input_x[2], 1) * pow(input_x[3], 2) * pow(input_x[5], 1);
        idvd_poly_feat[1874] = pow(input_x[0], 3) * pow(input_x[2], 1) * pow(input_x[3], 2) * pow(input_x[6], 1);
        idvd_poly_feat[1875] = pow(input_x[0], 3) * pow(input_x[2], 1) * pow(input_x[3], 1) * pow(input_x[4], 2);
        idvd_poly_feat[1876] = pow(input_x[0], 3) * pow(input_x[2], 1) * pow(input_x[3], 1) * pow(input_x[4], 1) * pow(input_x[5], 1);
        idvd_poly_feat[1877] = pow(input_x[0], 3) * pow(input_x[2], 1) * pow(input_x[3], 1) * pow(input_x[4], 1) * pow(input_x[6], 1);
        idvd_poly_feat[1878] = pow(input_x[0], 3) * pow(input_x[2], 1) * pow(input_x[3], 1) * pow(input_x[5], 2);
        idvd_poly_feat[1879] = pow(input_x[0], 3) * pow(input_x[2], 1) * pow(input_x[3], 1) * pow(input_x[5], 1) * pow(input_x[6], 1);
        idvd_poly_feat[1880] = pow(input_x[0], 3) * pow(input_x[2], 1) * pow(input_x[3], 1) * pow(input_x[6], 2);
        idvd_poly_feat[1881] = pow(input_x[0], 3) * pow(input_x[2], 1) * pow(input_x[4], 3);
        idvd_poly_feat[1882] = pow(input_x[0], 3) * pow(input_x[2], 1) * pow(input_x[4], 2) * pow(input_x[5], 1);
        idvd_poly_feat[1883] = pow(input_x[0], 3) * pow(input_x[2], 1) * pow(input_x[4], 2) * pow(input_x[6], 1);
        idvd_poly_feat[1884] = pow(input_x[0], 3) * pow(input_x[2], 1) * pow(input_x[4], 1) * pow(input_x[5], 2);
        idvd_poly_feat[1885] = pow(input_x[0], 3) * pow(input_x[2], 1) * pow(input_x[4], 1) * pow(input_x[5], 1) * pow(input_x[6], 1);
        idvd_poly_feat[1886] = pow(input_x[0], 3) * pow(input_x[2], 1) * pow(input_x[4], 1) * pow(input_x[6], 2);
        idvd_poly_feat[1887] = pow(input_x[0], 3) * pow(input_x[2], 1) * pow(input_x[5], 3);
        idvd_poly_feat[1888] = pow(input_x[0], 3) * pow(input_x[2], 1) * pow(input_x[5], 2) * pow(input_x[6], 1);
        idvd_poly_feat[1889] = pow(input_x[0], 3) * pow(input_x[2], 1) * pow(input_x[5], 1) * pow(input_x[6], 2);
        idvd_poly_feat[1890] = pow(input_x[0], 3) * pow(input_x[2], 1) * pow(input_x[6], 3);
        idvd_poly_feat[1891] = pow(input_x[0], 3) * pow(input_x[3], 4);
        idvd_poly_feat[1892] = pow(input_x[0], 3) * pow(input_x[3], 3) * pow(input_x[4], 1);
        idvd_poly_feat[1893] = pow(input_x[0], 3) * pow(input_x[3], 3) * pow(input_x[5], 1);
        idvd_poly_feat[1894] = pow(input_x[0], 3) * pow(input_x[3], 3) * pow(input_x[6], 1);
        idvd_poly_feat[1895] = pow(input_x[0], 3) * pow(input_x[3], 2) * pow(input_x[4], 2);
        idvd_poly_feat[1896] = pow(input_x[0], 3) * pow(input_x[3], 2) * pow(input_x[4], 1) * pow(input_x[5], 1);
        idvd_poly_feat[1897] = pow(input_x[0], 3) * pow(input_x[3], 2) * pow(input_x[4], 1) * pow(input_x[6], 1);
        idvd_poly_feat[1898] = pow(input_x[0], 3) * pow(input_x[3], 2) * pow(input_x[5], 2);
        idvd_poly_feat[1899] = pow(input_x[0], 3) * pow(input_x[3], 2) * pow(input_x[5], 1) * pow(input_x[6], 1);
        idvd_poly_feat[1900] = pow(input_x[0], 3) * pow(input_x[3], 2) * pow(input_x[6], 2);
        idvd_poly_feat[1901] = pow(input_x[0], 3) * pow(input_x[3], 1) * pow(input_x[4], 3);
        idvd_poly_feat[1902] = pow(input_x[0], 3) * pow(input_x[3], 1) * pow(input_x[4], 2) * pow(input_x[5], 1);
        idvd_poly_feat[1903] = pow(input_x[0], 3) * pow(input_x[3], 1) * pow(input_x[4], 2) * pow(input_x[6], 1);
        idvd_poly_feat[1904] = pow(input_x[0], 3) * pow(input_x[3], 1) * pow(input_x[4], 1) * pow(input_x[5], 2);
        idvd_poly_feat[1905] = pow(input_x[0], 3) * pow(input_x[3], 1) * pow(input_x[4], 1) * pow(input_x[5], 1) * pow(input_x[6], 1);
        idvd_poly_feat[1906] = pow(input_x[0], 3) * pow(input_x[3], 1) * pow(input_x[4], 1) * pow(input_x[6], 2);
        idvd_poly_feat[1907] = pow(input_x[0], 3) * pow(input_x[3], 1) * pow(input_x[5], 3);
        idvd_poly_feat[1908] = pow(input_x[0], 3) * pow(input_x[3], 1) * pow(input_x[5], 2) * pow(input_x[6], 1);
        idvd_poly_feat[1909] = pow(input_x[0], 3) * pow(input_x[3], 1) * pow(input_x[5], 1) * pow(input_x[6], 2);
        idvd_poly_feat[1910] = pow(input_x[0], 3) * pow(input_x[3], 1) * pow(input_x[6], 3);
        idvd_poly_feat[1911] = pow(input_x[0], 3) * pow(input_x[4], 4);
        idvd_poly_feat[1912] = pow(input_x[0], 3) * pow(input_x[4], 3) * pow(input_x[5], 1);
        idvd_poly_feat[1913] = pow(input_x[0], 3) * pow(input_x[4], 3) * pow(input_x[6], 1);
        idvd_poly_feat[1914] = pow(input_x[0], 3) * pow(input_x[4], 2) * pow(input_x[5], 2);
        idvd_poly_feat[1915] = pow(input_x[0], 3) * pow(input_x[4], 2) * pow(input_x[5], 1) * pow(input_x[6], 1);
        idvd_poly_feat[1916] = pow(input_x[0], 3) * pow(input_x[4], 2) * pow(input_x[6], 2);
        idvd_poly_feat[1917] = pow(input_x[0], 3) * pow(input_x[4], 1) * pow(input_x[5], 3);
        idvd_poly_feat[1918] = pow(input_x[0], 3) * pow(input_x[4], 1) * pow(input_x[5], 2) * pow(input_x[6], 1);
        idvd_poly_feat[1919] = pow(input_x[0], 3) * pow(input_x[4], 1) * pow(input_x[5], 1) * pow(input_x[6], 2);
        idvd_poly_feat[1920] = pow(input_x[0], 3) * pow(input_x[4], 1) * pow(input_x[6], 3);
        idvd_poly_feat[1921] = pow(input_x[0], 3) * pow(input_x[5], 4);
        idvd_poly_feat[1922] = pow(input_x[0], 3) * pow(input_x[5], 3) * pow(input_x[6], 1);
        idvd_poly_feat[1923] = pow(input_x[0], 3) * pow(input_x[5], 2) * pow(input_x[6], 2);
        idvd_poly_feat[1924] = pow(input_x[0], 3) * pow(input_x[5], 1) * pow(input_x[6], 3);
        idvd_poly_feat[1925] = pow(input_x[0], 3) * pow(input_x[6], 4);
        idvd_poly_feat[1926] = pow(input_x[0], 2) * pow(input_x[1], 5);
        idvd_poly_feat[1927] = pow(input_x[0], 2) * pow(input_x[1], 4) * pow(input_x[2], 1);
        idvd_poly_feat[1928] = pow(input_x[0], 2) * pow(input_x[1], 4) * pow(input_x[3], 1);
        idvd_poly_feat[1929] = pow(input_x[0], 2) * pow(input_x[1], 4) * pow(input_x[4], 1);
        idvd_poly_feat[1930] = pow(input_x[0], 2) * pow(input_x[1], 4) * pow(input_x[5], 1);
        idvd_poly_feat[1931] = pow(input_x[0], 2) * pow(input_x[1], 4) * pow(input_x[6], 1);
        idvd_poly_feat[1932] = pow(input_x[0], 2) * pow(input_x[1], 3) * pow(input_x[2], 2);
        idvd_poly_feat[1933] = pow(input_x[0], 2) * pow(input_x[1], 3) * pow(input_x[2], 1) * pow(input_x[3], 1);
        idvd_poly_feat[1934] = pow(input_x[0], 2) * pow(input_x[1], 3) * pow(input_x[2], 1) * pow(input_x[4], 1);
        idvd_poly_feat[1935] = pow(input_x[0], 2) * pow(input_x[1], 3) * pow(input_x[2], 1) * pow(input_x[5], 1);
        idvd_poly_feat[1936] = pow(input_x[0], 2) * pow(input_x[1], 3) * pow(input_x[2], 1) * pow(input_x[6], 1);
        idvd_poly_feat[1937] = pow(input_x[0], 2) * pow(input_x[1], 3) * pow(input_x[3], 2);
        idvd_poly_feat[1938] = pow(input_x[0], 2) * pow(input_x[1], 3) * pow(input_x[3], 1) * pow(input_x[4], 1);
        idvd_poly_feat[1939] = pow(input_x[0], 2) * pow(input_x[1], 3) * pow(input_x[3], 1) * pow(input_x[5], 1);
        idvd_poly_feat[1940] = pow(input_x[0], 2) * pow(input_x[1], 3) * pow(input_x[3], 1) * pow(input_x[6], 1);
        idvd_poly_feat[1941] = pow(input_x[0], 2) * pow(input_x[1], 3) * pow(input_x[4], 2);
        idvd_poly_feat[1942] = pow(input_x[0], 2) * pow(input_x[1], 3) * pow(input_x[4], 1) * pow(input_x[5], 1);
        idvd_poly_feat[1943] = pow(input_x[0], 2) * pow(input_x[1], 3) * pow(input_x[4], 1) * pow(input_x[6], 1);
        idvd_poly_feat[1944] = pow(input_x[0], 2) * pow(input_x[1], 3) * pow(input_x[5], 2);
        idvd_poly_feat[1945] = pow(input_x[0], 2) * pow(input_x[1], 3) * pow(input_x[5], 1) * pow(input_x[6], 1);
        idvd_poly_feat[1946] = pow(input_x[0], 2) * pow(input_x[1], 3) * pow(input_x[6], 2);
        idvd_poly_feat[1947] = pow(input_x[0], 2) * pow(input_x[1], 2) * pow(input_x[2], 3);
        idvd_poly_feat[1948] = pow(input_x[0], 2) * pow(input_x[1], 2) * pow(input_x[2], 2) * pow(input_x[3], 1);
        idvd_poly_feat[1949] = pow(input_x[0], 2) * pow(input_x[1], 2) * pow(input_x[2], 2) * pow(input_x[4], 1);
        idvd_poly_feat[1950] = pow(input_x[0], 2) * pow(input_x[1], 2) * pow(input_x[2], 2) * pow(input_x[5], 1);
        idvd_poly_feat[1951] = pow(input_x[0], 2) * pow(input_x[1], 2) * pow(input_x[2], 2) * pow(input_x[6], 1);
        idvd_poly_feat[1952] = pow(input_x[0], 2) * pow(input_x[1], 2) * pow(input_x[2], 1) * pow(input_x[3], 2);
        idvd_poly_feat[1953] = pow(input_x[0], 2) * pow(input_x[1], 2) * pow(input_x[2], 1) * pow(input_x[3], 1) * pow(input_x[4], 1);
        idvd_poly_feat[1954] = pow(input_x[0], 2) * pow(input_x[1], 2) * pow(input_x[2], 1) * pow(input_x[3], 1) * pow(input_x[5], 1);
        idvd_poly_feat[1955] = pow(input_x[0], 2) * pow(input_x[1], 2) * pow(input_x[2], 1) * pow(input_x[3], 1) * pow(input_x[6], 1);
        idvd_poly_feat[1956] = pow(input_x[0], 2) * pow(input_x[1], 2) * pow(input_x[2], 1) * pow(input_x[4], 2);
        idvd_poly_feat[1957] = pow(input_x[0], 2) * pow(input_x[1], 2) * pow(input_x[2], 1) * pow(input_x[4], 1) * pow(input_x[5], 1);
        idvd_poly_feat[1958] = pow(input_x[0], 2) * pow(input_x[1], 2) * pow(input_x[2], 1) * pow(input_x[4], 1) * pow(input_x[6], 1);
        idvd_poly_feat[1959] = pow(input_x[0], 2) * pow(input_x[1], 2) * pow(input_x[2], 1) * pow(input_x[5], 2);
        idvd_poly_feat[1960] = pow(input_x[0], 2) * pow(input_x[1], 2) * pow(input_x[2], 1) * pow(input_x[5], 1) * pow(input_x[6], 1);
        idvd_poly_feat[1961] = pow(input_x[0], 2) * pow(input_x[1], 2) * pow(input_x[2], 1) * pow(input_x[6], 2);
        idvd_poly_feat[1962] = pow(input_x[0], 2) * pow(input_x[1], 2) * pow(input_x[3], 3);
        idvd_poly_feat[1963] = pow(input_x[0], 2) * pow(input_x[1], 2) * pow(input_x[3], 2) * pow(input_x[4], 1);
        idvd_poly_feat[1964] = pow(input_x[0], 2) * pow(input_x[1], 2) * pow(input_x[3], 2) * pow(input_x[5], 1);
        idvd_poly_feat[1965] = pow(input_x[0], 2) * pow(input_x[1], 2) * pow(input_x[3], 2) * pow(input_x[6], 1);
        idvd_poly_feat[1966] = pow(input_x[0], 2) * pow(input_x[1], 2) * pow(input_x[3], 1) * pow(input_x[4], 2);
        idvd_poly_feat[1967] = pow(input_x[0], 2) * pow(input_x[1], 2) * pow(input_x[3], 1) * pow(input_x[4], 1) * pow(input_x[5], 1);
        idvd_poly_feat[1968] = pow(input_x[0], 2) * pow(input_x[1], 2) * pow(input_x[3], 1) * pow(input_x[4], 1) * pow(input_x[6], 1);
        idvd_poly_feat[1969] = pow(input_x[0], 2) * pow(input_x[1], 2) * pow(input_x[3], 1) * pow(input_x[5], 2);
        idvd_poly_feat[1970] = pow(input_x[0], 2) * pow(input_x[1], 2) * pow(input_x[3], 1) * pow(input_x[5], 1) * pow(input_x[6], 1);
        idvd_poly_feat[1971] = pow(input_x[0], 2) * pow(input_x[1], 2) * pow(input_x[3], 1) * pow(input_x[6], 2);
        idvd_poly_feat[1972] = pow(input_x[0], 2) * pow(input_x[1], 2) * pow(input_x[4], 3);
        idvd_poly_feat[1973] = pow(input_x[0], 2) * pow(input_x[1], 2) * pow(input_x[4], 2) * pow(input_x[5], 1);
        idvd_poly_feat[1974] = pow(input_x[0], 2) * pow(input_x[1], 2) * pow(input_x[4], 2) * pow(input_x[6], 1);
        idvd_poly_feat[1975] = pow(input_x[0], 2) * pow(input_x[1], 2) * pow(input_x[4], 1) * pow(input_x[5], 2);
        idvd_poly_feat[1976] = pow(input_x[0], 2) * pow(input_x[1], 2) * pow(input_x[4], 1) * pow(input_x[5], 1) * pow(input_x[6], 1);
        idvd_poly_feat[1977] = pow(input_x[0], 2) * pow(input_x[1], 2) * pow(input_x[4], 1) * pow(input_x[6], 2);
        idvd_poly_feat[1978] = pow(input_x[0], 2) * pow(input_x[1], 2) * pow(input_x[5], 3);
        idvd_poly_feat[1979] = pow(input_x[0], 2) * pow(input_x[1], 2) * pow(input_x[5], 2) * pow(input_x[6], 1);
        idvd_poly_feat[1980] = pow(input_x[0], 2) * pow(input_x[1], 2) * pow(input_x[5], 1) * pow(input_x[6], 2);
        idvd_poly_feat[1981] = pow(input_x[0], 2) * pow(input_x[1], 2) * pow(input_x[6], 3);
        idvd_poly_feat[1982] = pow(input_x[0], 2) * pow(input_x[1], 1) * pow(input_x[2], 4);
        idvd_poly_feat[1983] = pow(input_x[0], 2) * pow(input_x[1], 1) * pow(input_x[2], 3) * pow(input_x[3], 1);
        idvd_poly_feat[1984] = pow(input_x[0], 2) * pow(input_x[1], 1) * pow(input_x[2], 3) * pow(input_x[4], 1);
        idvd_poly_feat[1985] = pow(input_x[0], 2) * pow(input_x[1], 1) * pow(input_x[2], 3) * pow(input_x[5], 1);
        idvd_poly_feat[1986] = pow(input_x[0], 2) * pow(input_x[1], 1) * pow(input_x[2], 3) * pow(input_x[6], 1);
        idvd_poly_feat[1987] = pow(input_x[0], 2) * pow(input_x[1], 1) * pow(input_x[2], 2) * pow(input_x[3], 2);
        idvd_poly_feat[1988] = pow(input_x[0], 2) * pow(input_x[1], 1) * pow(input_x[2], 2) * pow(input_x[3], 1) * pow(input_x[4], 1);
        idvd_poly_feat[1989] = pow(input_x[0], 2) * pow(input_x[1], 1) * pow(input_x[2], 2) * pow(input_x[3], 1) * pow(input_x[5], 1);
        idvd_poly_feat[1990] = pow(input_x[0], 2) * pow(input_x[1], 1) * pow(input_x[2], 2) * pow(input_x[3], 1) * pow(input_x[6], 1);
        idvd_poly_feat[1991] = pow(input_x[0], 2) * pow(input_x[1], 1) * pow(input_x[2], 2) * pow(input_x[4], 2);
        idvd_poly_feat[1992] = pow(input_x[0], 2) * pow(input_x[1], 1) * pow(input_x[2], 2) * pow(input_x[4], 1) * pow(input_x[5], 1);
        idvd_poly_feat[1993] = pow(input_x[0], 2) * pow(input_x[1], 1) * pow(input_x[2], 2) * pow(input_x[4], 1) * pow(input_x[6], 1);
        idvd_poly_feat[1994] = pow(input_x[0], 2) * pow(input_x[1], 1) * pow(input_x[2], 2) * pow(input_x[5], 2);
        idvd_poly_feat[1995] = pow(input_x[0], 2) * pow(input_x[1], 1) * pow(input_x[2], 2) * pow(input_x[5], 1) * pow(input_x[6], 1);
        idvd_poly_feat[1996] = pow(input_x[0], 2) * pow(input_x[1], 1) * pow(input_x[2], 2) * pow(input_x[6], 2);
        idvd_poly_feat[1997] = pow(input_x[0], 2) * pow(input_x[1], 1) * pow(input_x[2], 1) * pow(input_x[3], 3);
        idvd_poly_feat[1998] = pow(input_x[0], 2) * pow(input_x[1], 1) * pow(input_x[2], 1) * pow(input_x[3], 2) * pow(input_x[4], 1);
        idvd_poly_feat[1999] = pow(input_x[0], 2) * pow(input_x[1], 1) * pow(input_x[2], 1) * pow(input_x[3], 2) * pow(input_x[5], 1);
        idvd_poly_feat[2000] = pow(input_x[0], 2) * pow(input_x[1], 1) * pow(input_x[2], 1) * pow(input_x[3], 2) * pow(input_x[6], 1);
        idvd_poly_feat[2001] = pow(input_x[0], 2) * pow(input_x[1], 1) * pow(input_x[2], 1) * pow(input_x[3], 1) * pow(input_x[4], 2);
        idvd_poly_feat[2002] = pow(input_x[0], 2) * pow(input_x[1], 1) * pow(input_x[2], 1) * pow(input_x[3], 1) * pow(input_x[4], 1) * pow(input_x[5], 1);
        idvd_poly_feat[2003] = pow(input_x[0], 2) * pow(input_x[1], 1) * pow(input_x[2], 1) * pow(input_x[3], 1) * pow(input_x[4], 1) * pow(input_x[6], 1);
        idvd_poly_feat[2004] = pow(input_x[0], 2) * pow(input_x[1], 1) * pow(input_x[2], 1) * pow(input_x[3], 1) * pow(input_x[5], 2);
        idvd_poly_feat[2005] = pow(input_x[0], 2) * pow(input_x[1], 1) * pow(input_x[2], 1) * pow(input_x[3], 1) * pow(input_x[5], 1) * pow(input_x[6], 1);
        idvd_poly_feat[2006] = pow(input_x[0], 2) * pow(input_x[1], 1) * pow(input_x[2], 1) * pow(input_x[3], 1) * pow(input_x[6], 2);
        idvd_poly_feat[2007] = pow(input_x[0], 2) * pow(input_x[1], 1) * pow(input_x[2], 1) * pow(input_x[4], 3);
        idvd_poly_feat[2008] = pow(input_x[0], 2) * pow(input_x[1], 1) * pow(input_x[2], 1) * pow(input_x[4], 2) * pow(input_x[5], 1);
        idvd_poly_feat[2009] = pow(input_x[0], 2) * pow(input_x[1], 1) * pow(input_x[2], 1) * pow(input_x[4], 2) * pow(input_x[6], 1);
        idvd_poly_feat[2010] = pow(input_x[0], 2) * pow(input_x[1], 1) * pow(input_x[2], 1) * pow(input_x[4], 1) * pow(input_x[5], 2);
        idvd_poly_feat[2011] = pow(input_x[0], 2) * pow(input_x[1], 1) * pow(input_x[2], 1) * pow(input_x[4], 1) * pow(input_x[5], 1) * pow(input_x[6], 1);
        idvd_poly_feat[2012] = pow(input_x[0], 2) * pow(input_x[1], 1) * pow(input_x[2], 1) * pow(input_x[4], 1) * pow(input_x[6], 2);
        idvd_poly_feat[2013] = pow(input_x[0], 2) * pow(input_x[1], 1) * pow(input_x[2], 1) * pow(input_x[5], 3);
        idvd_poly_feat[2014] = pow(input_x[0], 2) * pow(input_x[1], 1) * pow(input_x[2], 1) * pow(input_x[5], 2) * pow(input_x[6], 1);
        idvd_poly_feat[2015] = pow(input_x[0], 2) * pow(input_x[1], 1) * pow(input_x[2], 1) * pow(input_x[5], 1) * pow(input_x[6], 2);
        idvd_poly_feat[2016] = pow(input_x[0], 2) * pow(input_x[1], 1) * pow(input_x[2], 1) * pow(input_x[6], 3);
        idvd_poly_feat[2017] = pow(input_x[0], 2) * pow(input_x[1], 1) * pow(input_x[3], 4);
        idvd_poly_feat[2018] = pow(input_x[0], 2) * pow(input_x[1], 1) * pow(input_x[3], 3) * pow(input_x[4], 1);
        idvd_poly_feat[2019] = pow(input_x[0], 2) * pow(input_x[1], 1) * pow(input_x[3], 3) * pow(input_x[5], 1);
        idvd_poly_feat[2020] = pow(input_x[0], 2) * pow(input_x[1], 1) * pow(input_x[3], 3) * pow(input_x[6], 1);
        idvd_poly_feat[2021] = pow(input_x[0], 2) * pow(input_x[1], 1) * pow(input_x[3], 2) * pow(input_x[4], 2);
        idvd_poly_feat[2022] = pow(input_x[0], 2) * pow(input_x[1], 1) * pow(input_x[3], 2) * pow(input_x[4], 1) * pow(input_x[5], 1);
        idvd_poly_feat[2023] = pow(input_x[0], 2) * pow(input_x[1], 1) * pow(input_x[3], 2) * pow(input_x[4], 1) * pow(input_x[6], 1);
        idvd_poly_feat[2024] = pow(input_x[0], 2) * pow(input_x[1], 1) * pow(input_x[3], 2) * pow(input_x[5], 2);
        idvd_poly_feat[2025] = pow(input_x[0], 2) * pow(input_x[1], 1) * pow(input_x[3], 2) * pow(input_x[5], 1) * pow(input_x[6], 1);
        idvd_poly_feat[2026] = pow(input_x[0], 2) * pow(input_x[1], 1) * pow(input_x[3], 2) * pow(input_x[6], 2);
        idvd_poly_feat[2027] = pow(input_x[0], 2) * pow(input_x[1], 1) * pow(input_x[3], 1) * pow(input_x[4], 3);
        idvd_poly_feat[2028] = pow(input_x[0], 2) * pow(input_x[1], 1) * pow(input_x[3], 1) * pow(input_x[4], 2) * pow(input_x[5], 1);
        idvd_poly_feat[2029] = pow(input_x[0], 2) * pow(input_x[1], 1) * pow(input_x[3], 1) * pow(input_x[4], 2) * pow(input_x[6], 1);
        idvd_poly_feat[2030] = pow(input_x[0], 2) * pow(input_x[1], 1) * pow(input_x[3], 1) * pow(input_x[4], 1) * pow(input_x[5], 2);
        idvd_poly_feat[2031] = pow(input_x[0], 2) * pow(input_x[1], 1) * pow(input_x[3], 1) * pow(input_x[4], 1) * pow(input_x[5], 1) * pow(input_x[6], 1);
        idvd_poly_feat[2032] = pow(input_x[0], 2) * pow(input_x[1], 1) * pow(input_x[3], 1) * pow(input_x[4], 1) * pow(input_x[6], 2);
        idvd_poly_feat[2033] = pow(input_x[0], 2) * pow(input_x[1], 1) * pow(input_x[3], 1) * pow(input_x[5], 3);
        idvd_poly_feat[2034] = pow(input_x[0], 2) * pow(input_x[1], 1) * pow(input_x[3], 1) * pow(input_x[5], 2) * pow(input_x[6], 1);
        idvd_poly_feat[2035] = pow(input_x[0], 2) * pow(input_x[1], 1) * pow(input_x[3], 1) * pow(input_x[5], 1) * pow(input_x[6], 2);
        idvd_poly_feat[2036] = pow(input_x[0], 2) * pow(input_x[1], 1) * pow(input_x[3], 1) * pow(input_x[6], 3);
        idvd_poly_feat[2037] = pow(input_x[0], 2) * pow(input_x[1], 1) * pow(input_x[4], 4);
        idvd_poly_feat[2038] = pow(input_x[0], 2) * pow(input_x[1], 1) * pow(input_x[4], 3) * pow(input_x[5], 1);
        idvd_poly_feat[2039] = pow(input_x[0], 2) * pow(input_x[1], 1) * pow(input_x[4], 3) * pow(input_x[6], 1);
        idvd_poly_feat[2040] = pow(input_x[0], 2) * pow(input_x[1], 1) * pow(input_x[4], 2) * pow(input_x[5], 2);
        idvd_poly_feat[2041] = pow(input_x[0], 2) * pow(input_x[1], 1) * pow(input_x[4], 2) * pow(input_x[5], 1) * pow(input_x[6], 1);
        idvd_poly_feat[2042] = pow(input_x[0], 2) * pow(input_x[1], 1) * pow(input_x[4], 2) * pow(input_x[6], 2);
        idvd_poly_feat[2043] = pow(input_x[0], 2) * pow(input_x[1], 1) * pow(input_x[4], 1) * pow(input_x[5], 3);
        idvd_poly_feat[2044] = pow(input_x[0], 2) * pow(input_x[1], 1) * pow(input_x[4], 1) * pow(input_x[5], 2) * pow(input_x[6], 1);
        idvd_poly_feat[2045] = pow(input_x[0], 2) * pow(input_x[1], 1) * pow(input_x[4], 1) * pow(input_x[5], 1) * pow(input_x[6], 2);
        idvd_poly_feat[2046] = pow(input_x[0], 2) * pow(input_x[1], 1) * pow(input_x[4], 1) * pow(input_x[6], 3);
        idvd_poly_feat[2047] = pow(input_x[0], 2) * pow(input_x[1], 1) * pow(input_x[5], 4);
        idvd_poly_feat[2048] = pow(input_x[0], 2) * pow(input_x[1], 1) * pow(input_x[5], 3) * pow(input_x[6], 1);
        idvd_poly_feat[2049] = pow(input_x[0], 2) * pow(input_x[1], 1) * pow(input_x[5], 2) * pow(input_x[6], 2);
        idvd_poly_feat[2050] = pow(input_x[0], 2) * pow(input_x[1], 1) * pow(input_x[5], 1) * pow(input_x[6], 3);
        idvd_poly_feat[2051] = pow(input_x[0], 2) * pow(input_x[1], 1) * pow(input_x[6], 4);
        idvd_poly_feat[2052] = pow(input_x[0], 2) * pow(input_x[2], 5);
        idvd_poly_feat[2053] = pow(input_x[0], 2) * pow(input_x[2], 4) * pow(input_x[3], 1);
        idvd_poly_feat[2054] = pow(input_x[0], 2) * pow(input_x[2], 4) * pow(input_x[4], 1);
        idvd_poly_feat[2055] = pow(input_x[0], 2) * pow(input_x[2], 4) * pow(input_x[5], 1);
        idvd_poly_feat[2056] = pow(input_x[0], 2) * pow(input_x[2], 4) * pow(input_x[6], 1);
        idvd_poly_feat[2057] = pow(input_x[0], 2) * pow(input_x[2], 3) * pow(input_x[3], 2);
        idvd_poly_feat[2058] = pow(input_x[0], 2) * pow(input_x[2], 3) * pow(input_x[3], 1) * pow(input_x[4], 1);
        idvd_poly_feat[2059] = pow(input_x[0], 2) * pow(input_x[2], 3) * pow(input_x[3], 1) * pow(input_x[5], 1);
        idvd_poly_feat[2060] = pow(input_x[0], 2) * pow(input_x[2], 3) * pow(input_x[3], 1) * pow(input_x[6], 1);
        idvd_poly_feat[2061] = pow(input_x[0], 2) * pow(input_x[2], 3) * pow(input_x[4], 2);
        idvd_poly_feat[2062] = pow(input_x[0], 2) * pow(input_x[2], 3) * pow(input_x[4], 1) * pow(input_x[5], 1);
        idvd_poly_feat[2063] = pow(input_x[0], 2) * pow(input_x[2], 3) * pow(input_x[4], 1) * pow(input_x[6], 1);
        idvd_poly_feat[2064] = pow(input_x[0], 2) * pow(input_x[2], 3) * pow(input_x[5], 2);
        idvd_poly_feat[2065] = pow(input_x[0], 2) * pow(input_x[2], 3) * pow(input_x[5], 1) * pow(input_x[6], 1);
        idvd_poly_feat[2066] = pow(input_x[0], 2) * pow(input_x[2], 3) * pow(input_x[6], 2);
        idvd_poly_feat[2067] = pow(input_x[0], 2) * pow(input_x[2], 2) * pow(input_x[3], 3);
        idvd_poly_feat[2068] = pow(input_x[0], 2) * pow(input_x[2], 2) * pow(input_x[3], 2) * pow(input_x[4], 1);
        idvd_poly_feat[2069] = pow(input_x[0], 2) * pow(input_x[2], 2) * pow(input_x[3], 2) * pow(input_x[5], 1);
        idvd_poly_feat[2070] = pow(input_x[0], 2) * pow(input_x[2], 2) * pow(input_x[3], 2) * pow(input_x[6], 1);
        idvd_poly_feat[2071] = pow(input_x[0], 2) * pow(input_x[2], 2) * pow(input_x[3], 1) * pow(input_x[4], 2);
        idvd_poly_feat[2072] = pow(input_x[0], 2) * pow(input_x[2], 2) * pow(input_x[3], 1) * pow(input_x[4], 1) * pow(input_x[5], 1);
        idvd_poly_feat[2073] = pow(input_x[0], 2) * pow(input_x[2], 2) * pow(input_x[3], 1) * pow(input_x[4], 1) * pow(input_x[6], 1);
        idvd_poly_feat[2074] = pow(input_x[0], 2) * pow(input_x[2], 2) * pow(input_x[3], 1) * pow(input_x[5], 2);
        idvd_poly_feat[2075] = pow(input_x[0], 2) * pow(input_x[2], 2) * pow(input_x[3], 1) * pow(input_x[5], 1) * pow(input_x[6], 1);
        idvd_poly_feat[2076] = pow(input_x[0], 2) * pow(input_x[2], 2) * pow(input_x[3], 1) * pow(input_x[6], 2);
        idvd_poly_feat[2077] = pow(input_x[0], 2) * pow(input_x[2], 2) * pow(input_x[4], 3);
        idvd_poly_feat[2078] = pow(input_x[0], 2) * pow(input_x[2], 2) * pow(input_x[4], 2) * pow(input_x[5], 1);
        idvd_poly_feat[2079] = pow(input_x[0], 2) * pow(input_x[2], 2) * pow(input_x[4], 2) * pow(input_x[6], 1);
        idvd_poly_feat[2080] = pow(input_x[0], 2) * pow(input_x[2], 2) * pow(input_x[4], 1) * pow(input_x[5], 2);
        idvd_poly_feat[2081] = pow(input_x[0], 2) * pow(input_x[2], 2) * pow(input_x[4], 1) * pow(input_x[5], 1) * pow(input_x[6], 1);
        idvd_poly_feat[2082] = pow(input_x[0], 2) * pow(input_x[2], 2) * pow(input_x[4], 1) * pow(input_x[6], 2);
        idvd_poly_feat[2083] = pow(input_x[0], 2) * pow(input_x[2], 2) * pow(input_x[5], 3);
        idvd_poly_feat[2084] = pow(input_x[0], 2) * pow(input_x[2], 2) * pow(input_x[5], 2) * pow(input_x[6], 1);
        idvd_poly_feat[2085] = pow(input_x[0], 2) * pow(input_x[2], 2) * pow(input_x[5], 1) * pow(input_x[6], 2);
        idvd_poly_feat[2086] = pow(input_x[0], 2) * pow(input_x[2], 2) * pow(input_x[6], 3);
        idvd_poly_feat[2087] = pow(input_x[0], 2) * pow(input_x[2], 1) * pow(input_x[3], 4);
        idvd_poly_feat[2088] = pow(input_x[0], 2) * pow(input_x[2], 1) * pow(input_x[3], 3) * pow(input_x[4], 1);
        idvd_poly_feat[2089] = pow(input_x[0], 2) * pow(input_x[2], 1) * pow(input_x[3], 3) * pow(input_x[5], 1);
        idvd_poly_feat[2090] = pow(input_x[0], 2) * pow(input_x[2], 1) * pow(input_x[3], 3) * pow(input_x[6], 1);
        idvd_poly_feat[2091] = pow(input_x[0], 2) * pow(input_x[2], 1) * pow(input_x[3], 2) * pow(input_x[4], 2);
        idvd_poly_feat[2092] = pow(input_x[0], 2) * pow(input_x[2], 1) * pow(input_x[3], 2) * pow(input_x[4], 1) * pow(input_x[5], 1);
        idvd_poly_feat[2093] = pow(input_x[0], 2) * pow(input_x[2], 1) * pow(input_x[3], 2) * pow(input_x[4], 1) * pow(input_x[6], 1);
        idvd_poly_feat[2094] = pow(input_x[0], 2) * pow(input_x[2], 1) * pow(input_x[3], 2) * pow(input_x[5], 2);
        idvd_poly_feat[2095] = pow(input_x[0], 2) * pow(input_x[2], 1) * pow(input_x[3], 2) * pow(input_x[5], 1) * pow(input_x[6], 1);
        idvd_poly_feat[2096] = pow(input_x[0], 2) * pow(input_x[2], 1) * pow(input_x[3], 2) * pow(input_x[6], 2);
        idvd_poly_feat[2097] = pow(input_x[0], 2) * pow(input_x[2], 1) * pow(input_x[3], 1) * pow(input_x[4], 3);
        idvd_poly_feat[2098] = pow(input_x[0], 2) * pow(input_x[2], 1) * pow(input_x[3], 1) * pow(input_x[4], 2) * pow(input_x[5], 1);
        idvd_poly_feat[2099] = pow(input_x[0], 2) * pow(input_x[2], 1) * pow(input_x[3], 1) * pow(input_x[4], 2) * pow(input_x[6], 1);
        idvd_poly_feat[2100] = pow(input_x[0], 2) * pow(input_x[2], 1) * pow(input_x[3], 1) * pow(input_x[4], 1) * pow(input_x[5], 2);
        idvd_poly_feat[2101] = pow(input_x[0], 2) * pow(input_x[2], 1) * pow(input_x[3], 1) * pow(input_x[4], 1) * pow(input_x[5], 1) * pow(input_x[6], 1);
        idvd_poly_feat[2102] = pow(input_x[0], 2) * pow(input_x[2], 1) * pow(input_x[3], 1) * pow(input_x[4], 1) * pow(input_x[6], 2);
        idvd_poly_feat[2103] = pow(input_x[0], 2) * pow(input_x[2], 1) * pow(input_x[3], 1) * pow(input_x[5], 3);
        idvd_poly_feat[2104] = pow(input_x[0], 2) * pow(input_x[2], 1) * pow(input_x[3], 1) * pow(input_x[5], 2) * pow(input_x[6], 1);
        idvd_poly_feat[2105] = pow(input_x[0], 2) * pow(input_x[2], 1) * pow(input_x[3], 1) * pow(input_x[5], 1) * pow(input_x[6], 2);
        idvd_poly_feat[2106] = pow(input_x[0], 2) * pow(input_x[2], 1) * pow(input_x[3], 1) * pow(input_x[6], 3);
        idvd_poly_feat[2107] = pow(input_x[0], 2) * pow(input_x[2], 1) * pow(input_x[4], 4);
        idvd_poly_feat[2108] = pow(input_x[0], 2) * pow(input_x[2], 1) * pow(input_x[4], 3) * pow(input_x[5], 1);
        idvd_poly_feat[2109] = pow(input_x[0], 2) * pow(input_x[2], 1) * pow(input_x[4], 3) * pow(input_x[6], 1);
        idvd_poly_feat[2110] = pow(input_x[0], 2) * pow(input_x[2], 1) * pow(input_x[4], 2) * pow(input_x[5], 2);
        idvd_poly_feat[2111] = pow(input_x[0], 2) * pow(input_x[2], 1) * pow(input_x[4], 2) * pow(input_x[5], 1) * pow(input_x[6], 1);
        idvd_poly_feat[2112] = pow(input_x[0], 2) * pow(input_x[2], 1) * pow(input_x[4], 2) * pow(input_x[6], 2);
        idvd_poly_feat[2113] = pow(input_x[0], 2) * pow(input_x[2], 1) * pow(input_x[4], 1) * pow(input_x[5], 3);
        idvd_poly_feat[2114] = pow(input_x[0], 2) * pow(input_x[2], 1) * pow(input_x[4], 1) * pow(input_x[5], 2) * pow(input_x[6], 1);
        idvd_poly_feat[2115] = pow(input_x[0], 2) * pow(input_x[2], 1) * pow(input_x[4], 1) * pow(input_x[5], 1) * pow(input_x[6], 2);
        idvd_poly_feat[2116] = pow(input_x[0], 2) * pow(input_x[2], 1) * pow(input_x[4], 1) * pow(input_x[6], 3);
        idvd_poly_feat[2117] = pow(input_x[0], 2) * pow(input_x[2], 1) * pow(input_x[5], 4);
        idvd_poly_feat[2118] = pow(input_x[0], 2) * pow(input_x[2], 1) * pow(input_x[5], 3) * pow(input_x[6], 1);
        idvd_poly_feat[2119] = pow(input_x[0], 2) * pow(input_x[2], 1) * pow(input_x[5], 2) * pow(input_x[6], 2);
        idvd_poly_feat[2120] = pow(input_x[0], 2) * pow(input_x[2], 1) * pow(input_x[5], 1) * pow(input_x[6], 3);
        idvd_poly_feat[2121] = pow(input_x[0], 2) * pow(input_x[2], 1) * pow(input_x[6], 4);
        idvd_poly_feat[2122] = pow(input_x[0], 2) * pow(input_x[3], 5);
        idvd_poly_feat[2123] = pow(input_x[0], 2) * pow(input_x[3], 4) * pow(input_x[4], 1);
        idvd_poly_feat[2124] = pow(input_x[0], 2) * pow(input_x[3], 4) * pow(input_x[5], 1);
        idvd_poly_feat[2125] = pow(input_x[0], 2) * pow(input_x[3], 4) * pow(input_x[6], 1);
        idvd_poly_feat[2126] = pow(input_x[0], 2) * pow(input_x[3], 3) * pow(input_x[4], 2);
        idvd_poly_feat[2127] = pow(input_x[0], 2) * pow(input_x[3], 3) * pow(input_x[4], 1) * pow(input_x[5], 1);
        idvd_poly_feat[2128] = pow(input_x[0], 2) * pow(input_x[3], 3) * pow(input_x[4], 1) * pow(input_x[6], 1);
        idvd_poly_feat[2129] = pow(input_x[0], 2) * pow(input_x[3], 3) * pow(input_x[5], 2);
        idvd_poly_feat[2130] = pow(input_x[0], 2) * pow(input_x[3], 3) * pow(input_x[5], 1) * pow(input_x[6], 1);
        idvd_poly_feat[2131] = pow(input_x[0], 2) * pow(input_x[3], 3) * pow(input_x[6], 2);
        idvd_poly_feat[2132] = pow(input_x[0], 2) * pow(input_x[3], 2) * pow(input_x[4], 3);
        idvd_poly_feat[2133] = pow(input_x[0], 2) * pow(input_x[3], 2) * pow(input_x[4], 2) * pow(input_x[5], 1);
        idvd_poly_feat[2134] = pow(input_x[0], 2) * pow(input_x[3], 2) * pow(input_x[4], 2) * pow(input_x[6], 1);
        idvd_poly_feat[2135] = pow(input_x[0], 2) * pow(input_x[3], 2) * pow(input_x[4], 1) * pow(input_x[5], 2);
        idvd_poly_feat[2136] = pow(input_x[0], 2) * pow(input_x[3], 2) * pow(input_x[4], 1) * pow(input_x[5], 1) * pow(input_x[6], 1);
        idvd_poly_feat[2137] = pow(input_x[0], 2) * pow(input_x[3], 2) * pow(input_x[4], 1) * pow(input_x[6], 2);
        idvd_poly_feat[2138] = pow(input_x[0], 2) * pow(input_x[3], 2) * pow(input_x[5], 3);
        idvd_poly_feat[2139] = pow(input_x[0], 2) * pow(input_x[3], 2) * pow(input_x[5], 2) * pow(input_x[6], 1);
        idvd_poly_feat[2140] = pow(input_x[0], 2) * pow(input_x[3], 2) * pow(input_x[5], 1) * pow(input_x[6], 2);
        idvd_poly_feat[2141] = pow(input_x[0], 2) * pow(input_x[3], 2) * pow(input_x[6], 3);
        idvd_poly_feat[2142] = pow(input_x[0], 2) * pow(input_x[3], 1) * pow(input_x[4], 4);
        idvd_poly_feat[2143] = pow(input_x[0], 2) * pow(input_x[3], 1) * pow(input_x[4], 3) * pow(input_x[5], 1);
        idvd_poly_feat[2144] = pow(input_x[0], 2) * pow(input_x[3], 1) * pow(input_x[4], 3) * pow(input_x[6], 1);
        idvd_poly_feat[2145] = pow(input_x[0], 2) * pow(input_x[3], 1) * pow(input_x[4], 2) * pow(input_x[5], 2);
        idvd_poly_feat[2146] = pow(input_x[0], 2) * pow(input_x[3], 1) * pow(input_x[4], 2) * pow(input_x[5], 1) * pow(input_x[6], 1);
        idvd_poly_feat[2147] = pow(input_x[0], 2) * pow(input_x[3], 1) * pow(input_x[4], 2) * pow(input_x[6], 2);
        idvd_poly_feat[2148] = pow(input_x[0], 2) * pow(input_x[3], 1) * pow(input_x[4], 1) * pow(input_x[5], 3);
        idvd_poly_feat[2149] = pow(input_x[0], 2) * pow(input_x[3], 1) * pow(input_x[4], 1) * pow(input_x[5], 2) * pow(input_x[6], 1);
        idvd_poly_feat[2150] = pow(input_x[0], 2) * pow(input_x[3], 1) * pow(input_x[4], 1) * pow(input_x[5], 1) * pow(input_x[6], 2);
        idvd_poly_feat[2151] = pow(input_x[0], 2) * pow(input_x[3], 1) * pow(input_x[4], 1) * pow(input_x[6], 3);
        idvd_poly_feat[2152] = pow(input_x[0], 2) * pow(input_x[3], 1) * pow(input_x[5], 4);
        idvd_poly_feat[2153] = pow(input_x[0], 2) * pow(input_x[3], 1) * pow(input_x[5], 3) * pow(input_x[6], 1);
        idvd_poly_feat[2154] = pow(input_x[0], 2) * pow(input_x[3], 1) * pow(input_x[5], 2) * pow(input_x[6], 2);
        idvd_poly_feat[2155] = pow(input_x[0], 2) * pow(input_x[3], 1) * pow(input_x[5], 1) * pow(input_x[6], 3);
        idvd_poly_feat[2156] = pow(input_x[0], 2) * pow(input_x[3], 1) * pow(input_x[6], 4);
        idvd_poly_feat[2157] = pow(input_x[0], 2) * pow(input_x[4], 5);
        idvd_poly_feat[2158] = pow(input_x[0], 2) * pow(input_x[4], 4) * pow(input_x[5], 1);
        idvd_poly_feat[2159] = pow(input_x[0], 2) * pow(input_x[4], 4) * pow(input_x[6], 1);
        idvd_poly_feat[2160] = pow(input_x[0], 2) * pow(input_x[4], 3) * pow(input_x[5], 2);
        idvd_poly_feat[2161] = pow(input_x[0], 2) * pow(input_x[4], 3) * pow(input_x[5], 1) * pow(input_x[6], 1);
        idvd_poly_feat[2162] = pow(input_x[0], 2) * pow(input_x[4], 3) * pow(input_x[6], 2);
        idvd_poly_feat[2163] = pow(input_x[0], 2) * pow(input_x[4], 2) * pow(input_x[5], 3);
        idvd_poly_feat[2164] = pow(input_x[0], 2) * pow(input_x[4], 2) * pow(input_x[5], 2) * pow(input_x[6], 1);
        idvd_poly_feat[2165] = pow(input_x[0], 2) * pow(input_x[4], 2) * pow(input_x[5], 1) * pow(input_x[6], 2);
        idvd_poly_feat[2166] = pow(input_x[0], 2) * pow(input_x[4], 2) * pow(input_x[6], 3);
        idvd_poly_feat[2167] = pow(input_x[0], 2) * pow(input_x[4], 1) * pow(input_x[5], 4);
        idvd_poly_feat[2168] = pow(input_x[0], 2) * pow(input_x[4], 1) * pow(input_x[5], 3) * pow(input_x[6], 1);
        idvd_poly_feat[2169] = pow(input_x[0], 2) * pow(input_x[4], 1) * pow(input_x[5], 2) * pow(input_x[6], 2);
        idvd_poly_feat[2170] = pow(input_x[0], 2) * pow(input_x[4], 1) * pow(input_x[5], 1) * pow(input_x[6], 3);
        idvd_poly_feat[2171] = pow(input_x[0], 2) * pow(input_x[4], 1) * pow(input_x[6], 4);
        idvd_poly_feat[2172] = pow(input_x[0], 2) * pow(input_x[5], 5);
        idvd_poly_feat[2173] = pow(input_x[0], 2) * pow(input_x[5], 4) * pow(input_x[6], 1);
        idvd_poly_feat[2174] = pow(input_x[0], 2) * pow(input_x[5], 3) * pow(input_x[6], 2);
        idvd_poly_feat[2175] = pow(input_x[0], 2) * pow(input_x[5], 2) * pow(input_x[6], 3);
        idvd_poly_feat[2176] = pow(input_x[0], 2) * pow(input_x[5], 1) * pow(input_x[6], 4);
        idvd_poly_feat[2177] = pow(input_x[0], 2) * pow(input_x[6], 5);
        idvd_poly_feat[2178] = pow(input_x[0], 1) * pow(input_x[1], 6);
        idvd_poly_feat[2179] = pow(input_x[0], 1) * pow(input_x[1], 5) * pow(input_x[2], 1);
        idvd_poly_feat[2180] = pow(input_x[0], 1) * pow(input_x[1], 5) * pow(input_x[3], 1);
        idvd_poly_feat[2181] = pow(input_x[0], 1) * pow(input_x[1], 5) * pow(input_x[4], 1);
        idvd_poly_feat[2182] = pow(input_x[0], 1) * pow(input_x[1], 5) * pow(input_x[5], 1);
        idvd_poly_feat[2183] = pow(input_x[0], 1) * pow(input_x[1], 5) * pow(input_x[6], 1);
        idvd_poly_feat[2184] = pow(input_x[0], 1) * pow(input_x[1], 4) * pow(input_x[2], 2);
        idvd_poly_feat[2185] = pow(input_x[0], 1) * pow(input_x[1], 4) * pow(input_x[2], 1) * pow(input_x[3], 1);
        idvd_poly_feat[2186] = pow(input_x[0], 1) * pow(input_x[1], 4) * pow(input_x[2], 1) * pow(input_x[4], 1);
        idvd_poly_feat[2187] = pow(input_x[0], 1) * pow(input_x[1], 4) * pow(input_x[2], 1) * pow(input_x[5], 1);
        idvd_poly_feat[2188] = pow(input_x[0], 1) * pow(input_x[1], 4) * pow(input_x[2], 1) * pow(input_x[6], 1);
        idvd_poly_feat[2189] = pow(input_x[0], 1) * pow(input_x[1], 4) * pow(input_x[3], 2);
        idvd_poly_feat[2190] = pow(input_x[0], 1) * pow(input_x[1], 4) * pow(input_x[3], 1) * pow(input_x[4], 1);
        idvd_poly_feat[2191] = pow(input_x[0], 1) * pow(input_x[1], 4) * pow(input_x[3], 1) * pow(input_x[5], 1);
        idvd_poly_feat[2192] = pow(input_x[0], 1) * pow(input_x[1], 4) * pow(input_x[3], 1) * pow(input_x[6], 1);
        idvd_poly_feat[2193] = pow(input_x[0], 1) * pow(input_x[1], 4) * pow(input_x[4], 2);
        idvd_poly_feat[2194] = pow(input_x[0], 1) * pow(input_x[1], 4) * pow(input_x[4], 1) * pow(input_x[5], 1);
        idvd_poly_feat[2195] = pow(input_x[0], 1) * pow(input_x[1], 4) * pow(input_x[4], 1) * pow(input_x[6], 1);
        idvd_poly_feat[2196] = pow(input_x[0], 1) * pow(input_x[1], 4) * pow(input_x[5], 2);
        idvd_poly_feat[2197] = pow(input_x[0], 1) * pow(input_x[1], 4) * pow(input_x[5], 1) * pow(input_x[6], 1);
        idvd_poly_feat[2198] = pow(input_x[0], 1) * pow(input_x[1], 4) * pow(input_x[6], 2);
        idvd_poly_feat[2199] = pow(input_x[0], 1) * pow(input_x[1], 3) * pow(input_x[2], 3);
        idvd_poly_feat[2200] = pow(input_x[0], 1) * pow(input_x[1], 3) * pow(input_x[2], 2) * pow(input_x[3], 1);
        idvd_poly_feat[2201] = pow(input_x[0], 1) * pow(input_x[1], 3) * pow(input_x[2], 2) * pow(input_x[4], 1);
        idvd_poly_feat[2202] = pow(input_x[0], 1) * pow(input_x[1], 3) * pow(input_x[2], 2) * pow(input_x[5], 1);
        idvd_poly_feat[2203] = pow(input_x[0], 1) * pow(input_x[1], 3) * pow(input_x[2], 2) * pow(input_x[6], 1);
        idvd_poly_feat[2204] = pow(input_x[0], 1) * pow(input_x[1], 3) * pow(input_x[2], 1) * pow(input_x[3], 2);
        idvd_poly_feat[2205] = pow(input_x[0], 1) * pow(input_x[1], 3) * pow(input_x[2], 1) * pow(input_x[3], 1) * pow(input_x[4], 1);
        idvd_poly_feat[2206] = pow(input_x[0], 1) * pow(input_x[1], 3) * pow(input_x[2], 1) * pow(input_x[3], 1) * pow(input_x[5], 1);
        idvd_poly_feat[2207] = pow(input_x[0], 1) * pow(input_x[1], 3) * pow(input_x[2], 1) * pow(input_x[3], 1) * pow(input_x[6], 1);
        idvd_poly_feat[2208] = pow(input_x[0], 1) * pow(input_x[1], 3) * pow(input_x[2], 1) * pow(input_x[4], 2);
        idvd_poly_feat[2209] = pow(input_x[0], 1) * pow(input_x[1], 3) * pow(input_x[2], 1) * pow(input_x[4], 1) * pow(input_x[5], 1);
        idvd_poly_feat[2210] = pow(input_x[0], 1) * pow(input_x[1], 3) * pow(input_x[2], 1) * pow(input_x[4], 1) * pow(input_x[6], 1);
        idvd_poly_feat[2211] = pow(input_x[0], 1) * pow(input_x[1], 3) * pow(input_x[2], 1) * pow(input_x[5], 2);
        idvd_poly_feat[2212] = pow(input_x[0], 1) * pow(input_x[1], 3) * pow(input_x[2], 1) * pow(input_x[5], 1) * pow(input_x[6], 1);
        idvd_poly_feat[2213] = pow(input_x[0], 1) * pow(input_x[1], 3) * pow(input_x[2], 1) * pow(input_x[6], 2);
        idvd_poly_feat[2214] = pow(input_x[0], 1) * pow(input_x[1], 3) * pow(input_x[3], 3);
        idvd_poly_feat[2215] = pow(input_x[0], 1) * pow(input_x[1], 3) * pow(input_x[3], 2) * pow(input_x[4], 1);
        idvd_poly_feat[2216] = pow(input_x[0], 1) * pow(input_x[1], 3) * pow(input_x[3], 2) * pow(input_x[5], 1);
        idvd_poly_feat[2217] = pow(input_x[0], 1) * pow(input_x[1], 3) * pow(input_x[3], 2) * pow(input_x[6], 1);
        idvd_poly_feat[2218] = pow(input_x[0], 1) * pow(input_x[1], 3) * pow(input_x[3], 1) * pow(input_x[4], 2);
        idvd_poly_feat[2219] = pow(input_x[0], 1) * pow(input_x[1], 3) * pow(input_x[3], 1) * pow(input_x[4], 1) * pow(input_x[5], 1);
        idvd_poly_feat[2220] = pow(input_x[0], 1) * pow(input_x[1], 3) * pow(input_x[3], 1) * pow(input_x[4], 1) * pow(input_x[6], 1);
        idvd_poly_feat[2221] = pow(input_x[0], 1) * pow(input_x[1], 3) * pow(input_x[3], 1) * pow(input_x[5], 2);
        idvd_poly_feat[2222] = pow(input_x[0], 1) * pow(input_x[1], 3) * pow(input_x[3], 1) * pow(input_x[5], 1) * pow(input_x[6], 1);
        idvd_poly_feat[2223] = pow(input_x[0], 1) * pow(input_x[1], 3) * pow(input_x[3], 1) * pow(input_x[6], 2);
        idvd_poly_feat[2224] = pow(input_x[0], 1) * pow(input_x[1], 3) * pow(input_x[4], 3);
        idvd_poly_feat[2225] = pow(input_x[0], 1) * pow(input_x[1], 3) * pow(input_x[4], 2) * pow(input_x[5], 1);
        idvd_poly_feat[2226] = pow(input_x[0], 1) * pow(input_x[1], 3) * pow(input_x[4], 2) * pow(input_x[6], 1);
        idvd_poly_feat[2227] = pow(input_x[0], 1) * pow(input_x[1], 3) * pow(input_x[4], 1) * pow(input_x[5], 2);
        idvd_poly_feat[2228] = pow(input_x[0], 1) * pow(input_x[1], 3) * pow(input_x[4], 1) * pow(input_x[5], 1) * pow(input_x[6], 1);
        idvd_poly_feat[2229] = pow(input_x[0], 1) * pow(input_x[1], 3) * pow(input_x[4], 1) * pow(input_x[6], 2);
        idvd_poly_feat[2230] = pow(input_x[0], 1) * pow(input_x[1], 3) * pow(input_x[5], 3);
        idvd_poly_feat[2231] = pow(input_x[0], 1) * pow(input_x[1], 3) * pow(input_x[5], 2) * pow(input_x[6], 1);
        idvd_poly_feat[2232] = pow(input_x[0], 1) * pow(input_x[1], 3) * pow(input_x[5], 1) * pow(input_x[6], 2);
        idvd_poly_feat[2233] = pow(input_x[0], 1) * pow(input_x[1], 3) * pow(input_x[6], 3);
        idvd_poly_feat[2234] = pow(input_x[0], 1) * pow(input_x[1], 2) * pow(input_x[2], 4);
        idvd_poly_feat[2235] = pow(input_x[0], 1) * pow(input_x[1], 2) * pow(input_x[2], 3) * pow(input_x[3], 1);
        idvd_poly_feat[2236] = pow(input_x[0], 1) * pow(input_x[1], 2) * pow(input_x[2], 3) * pow(input_x[4], 1);
        idvd_poly_feat[2237] = pow(input_x[0], 1) * pow(input_x[1], 2) * pow(input_x[2], 3) * pow(input_x[5], 1);
        idvd_poly_feat[2238] = pow(input_x[0], 1) * pow(input_x[1], 2) * pow(input_x[2], 3) * pow(input_x[6], 1);
        idvd_poly_feat[2239] = pow(input_x[0], 1) * pow(input_x[1], 2) * pow(input_x[2], 2) * pow(input_x[3], 2);
        idvd_poly_feat[2240] = pow(input_x[0], 1) * pow(input_x[1], 2) * pow(input_x[2], 2) * pow(input_x[3], 1) * pow(input_x[4], 1);
        idvd_poly_feat[2241] = pow(input_x[0], 1) * pow(input_x[1], 2) * pow(input_x[2], 2) * pow(input_x[3], 1) * pow(input_x[5], 1);
        idvd_poly_feat[2242] = pow(input_x[0], 1) * pow(input_x[1], 2) * pow(input_x[2], 2) * pow(input_x[3], 1) * pow(input_x[6], 1);
        idvd_poly_feat[2243] = pow(input_x[0], 1) * pow(input_x[1], 2) * pow(input_x[2], 2) * pow(input_x[4], 2);
        idvd_poly_feat[2244] = pow(input_x[0], 1) * pow(input_x[1], 2) * pow(input_x[2], 2) * pow(input_x[4], 1) * pow(input_x[5], 1);
        idvd_poly_feat[2245] = pow(input_x[0], 1) * pow(input_x[1], 2) * pow(input_x[2], 2) * pow(input_x[4], 1) * pow(input_x[6], 1);
        idvd_poly_feat[2246] = pow(input_x[0], 1) * pow(input_x[1], 2) * pow(input_x[2], 2) * pow(input_x[5], 2);
        idvd_poly_feat[2247] = pow(input_x[0], 1) * pow(input_x[1], 2) * pow(input_x[2], 2) * pow(input_x[5], 1) * pow(input_x[6], 1);
        idvd_poly_feat[2248] = pow(input_x[0], 1) * pow(input_x[1], 2) * pow(input_x[2], 2) * pow(input_x[6], 2);
        idvd_poly_feat[2249] = pow(input_x[0], 1) * pow(input_x[1], 2) * pow(input_x[2], 1) * pow(input_x[3], 3);
        idvd_poly_feat[2250] = pow(input_x[0], 1) * pow(input_x[1], 2) * pow(input_x[2], 1) * pow(input_x[3], 2) * pow(input_x[4], 1);
        idvd_poly_feat[2251] = pow(input_x[0], 1) * pow(input_x[1], 2) * pow(input_x[2], 1) * pow(input_x[3], 2) * pow(input_x[5], 1);
        idvd_poly_feat[2252] = pow(input_x[0], 1) * pow(input_x[1], 2) * pow(input_x[2], 1) * pow(input_x[3], 2) * pow(input_x[6], 1);
        idvd_poly_feat[2253] = pow(input_x[0], 1) * pow(input_x[1], 2) * pow(input_x[2], 1) * pow(input_x[3], 1) * pow(input_x[4], 2);
        idvd_poly_feat[2254] = pow(input_x[0], 1) * pow(input_x[1], 2) * pow(input_x[2], 1) * pow(input_x[3], 1) * pow(input_x[4], 1) * pow(input_x[5], 1);
        idvd_poly_feat[2255] = pow(input_x[0], 1) * pow(input_x[1], 2) * pow(input_x[2], 1) * pow(input_x[3], 1) * pow(input_x[4], 1) * pow(input_x[6], 1);
        idvd_poly_feat[2256] = pow(input_x[0], 1) * pow(input_x[1], 2) * pow(input_x[2], 1) * pow(input_x[3], 1) * pow(input_x[5], 2);
        idvd_poly_feat[2257] = pow(input_x[0], 1) * pow(input_x[1], 2) * pow(input_x[2], 1) * pow(input_x[3], 1) * pow(input_x[5], 1) * pow(input_x[6], 1);
        idvd_poly_feat[2258] = pow(input_x[0], 1) * pow(input_x[1], 2) * pow(input_x[2], 1) * pow(input_x[3], 1) * pow(input_x[6], 2);
        idvd_poly_feat[2259] = pow(input_x[0], 1) * pow(input_x[1], 2) * pow(input_x[2], 1) * pow(input_x[4], 3);
        idvd_poly_feat[2260] = pow(input_x[0], 1) * pow(input_x[1], 2) * pow(input_x[2], 1) * pow(input_x[4], 2) * pow(input_x[5], 1);
        idvd_poly_feat[2261] = pow(input_x[0], 1) * pow(input_x[1], 2) * pow(input_x[2], 1) * pow(input_x[4], 2) * pow(input_x[6], 1);
        idvd_poly_feat[2262] = pow(input_x[0], 1) * pow(input_x[1], 2) * pow(input_x[2], 1) * pow(input_x[4], 1) * pow(input_x[5], 2);
        idvd_poly_feat[2263] = pow(input_x[0], 1) * pow(input_x[1], 2) * pow(input_x[2], 1) * pow(input_x[4], 1) * pow(input_x[5], 1) * pow(input_x[6], 1);
        idvd_poly_feat[2264] = pow(input_x[0], 1) * pow(input_x[1], 2) * pow(input_x[2], 1) * pow(input_x[4], 1) * pow(input_x[6], 2);
        idvd_poly_feat[2265] = pow(input_x[0], 1) * pow(input_x[1], 2) * pow(input_x[2], 1) * pow(input_x[5], 3);
        idvd_poly_feat[2266] = pow(input_x[0], 1) * pow(input_x[1], 2) * pow(input_x[2], 1) * pow(input_x[5], 2) * pow(input_x[6], 1);
        idvd_poly_feat[2267] = pow(input_x[0], 1) * pow(input_x[1], 2) * pow(input_x[2], 1) * pow(input_x[5], 1) * pow(input_x[6], 2);
        idvd_poly_feat[2268] = pow(input_x[0], 1) * pow(input_x[1], 2) * pow(input_x[2], 1) * pow(input_x[6], 3);
        idvd_poly_feat[2269] = pow(input_x[0], 1) * pow(input_x[1], 2) * pow(input_x[3], 4);
        idvd_poly_feat[2270] = pow(input_x[0], 1) * pow(input_x[1], 2) * pow(input_x[3], 3) * pow(input_x[4], 1);
        idvd_poly_feat[2271] = pow(input_x[0], 1) * pow(input_x[1], 2) * pow(input_x[3], 3) * pow(input_x[5], 1);
        idvd_poly_feat[2272] = pow(input_x[0], 1) * pow(input_x[1], 2) * pow(input_x[3], 3) * pow(input_x[6], 1);
        idvd_poly_feat[2273] = pow(input_x[0], 1) * pow(input_x[1], 2) * pow(input_x[3], 2) * pow(input_x[4], 2);
        idvd_poly_feat[2274] = pow(input_x[0], 1) * pow(input_x[1], 2) * pow(input_x[3], 2) * pow(input_x[4], 1) * pow(input_x[5], 1);
        idvd_poly_feat[2275] = pow(input_x[0], 1) * pow(input_x[1], 2) * pow(input_x[3], 2) * pow(input_x[4], 1) * pow(input_x[6], 1);
        idvd_poly_feat[2276] = pow(input_x[0], 1) * pow(input_x[1], 2) * pow(input_x[3], 2) * pow(input_x[5], 2);
        idvd_poly_feat[2277] = pow(input_x[0], 1) * pow(input_x[1], 2) * pow(input_x[3], 2) * pow(input_x[5], 1) * pow(input_x[6], 1);
        idvd_poly_feat[2278] = pow(input_x[0], 1) * pow(input_x[1], 2) * pow(input_x[3], 2) * pow(input_x[6], 2);
        idvd_poly_feat[2279] = pow(input_x[0], 1) * pow(input_x[1], 2) * pow(input_x[3], 1) * pow(input_x[4], 3);
        idvd_poly_feat[2280] = pow(input_x[0], 1) * pow(input_x[1], 2) * pow(input_x[3], 1) * pow(input_x[4], 2) * pow(input_x[5], 1);
        idvd_poly_feat[2281] = pow(input_x[0], 1) * pow(input_x[1], 2) * pow(input_x[3], 1) * pow(input_x[4], 2) * pow(input_x[6], 1);
        idvd_poly_feat[2282] = pow(input_x[0], 1) * pow(input_x[1], 2) * pow(input_x[3], 1) * pow(input_x[4], 1) * pow(input_x[5], 2);
        idvd_poly_feat[2283] = pow(input_x[0], 1) * pow(input_x[1], 2) * pow(input_x[3], 1) * pow(input_x[4], 1) * pow(input_x[5], 1) * pow(input_x[6], 1);
        idvd_poly_feat[2284] = pow(input_x[0], 1) * pow(input_x[1], 2) * pow(input_x[3], 1) * pow(input_x[4], 1) * pow(input_x[6], 2);
        idvd_poly_feat[2285] = pow(input_x[0], 1) * pow(input_x[1], 2) * pow(input_x[3], 1) * pow(input_x[5], 3);
        idvd_poly_feat[2286] = pow(input_x[0], 1) * pow(input_x[1], 2) * pow(input_x[3], 1) * pow(input_x[5], 2) * pow(input_x[6], 1);
        idvd_poly_feat[2287] = pow(input_x[0], 1) * pow(input_x[1], 2) * pow(input_x[3], 1) * pow(input_x[5], 1) * pow(input_x[6], 2);
        idvd_poly_feat[2288] = pow(input_x[0], 1) * pow(input_x[1], 2) * pow(input_x[3], 1) * pow(input_x[6], 3);
        idvd_poly_feat[2289] = pow(input_x[0], 1) * pow(input_x[1], 2) * pow(input_x[4], 4);
        idvd_poly_feat[2290] = pow(input_x[0], 1) * pow(input_x[1], 2) * pow(input_x[4], 3) * pow(input_x[5], 1);
        idvd_poly_feat[2291] = pow(input_x[0], 1) * pow(input_x[1], 2) * pow(input_x[4], 3) * pow(input_x[6], 1);
        idvd_poly_feat[2292] = pow(input_x[0], 1) * pow(input_x[1], 2) * pow(input_x[4], 2) * pow(input_x[5], 2);
        idvd_poly_feat[2293] = pow(input_x[0], 1) * pow(input_x[1], 2) * pow(input_x[4], 2) * pow(input_x[5], 1) * pow(input_x[6], 1);
        idvd_poly_feat[2294] = pow(input_x[0], 1) * pow(input_x[1], 2) * pow(input_x[4], 2) * pow(input_x[6], 2);
        idvd_poly_feat[2295] = pow(input_x[0], 1) * pow(input_x[1], 2) * pow(input_x[4], 1) * pow(input_x[5], 3);
        idvd_poly_feat[2296] = pow(input_x[0], 1) * pow(input_x[1], 2) * pow(input_x[4], 1) * pow(input_x[5], 2) * pow(input_x[6], 1);
        idvd_poly_feat[2297] = pow(input_x[0], 1) * pow(input_x[1], 2) * pow(input_x[4], 1) * pow(input_x[5], 1) * pow(input_x[6], 2);
        idvd_poly_feat[2298] = pow(input_x[0], 1) * pow(input_x[1], 2) * pow(input_x[4], 1) * pow(input_x[6], 3);
        idvd_poly_feat[2299] = pow(input_x[0], 1) * pow(input_x[1], 2) * pow(input_x[5], 4);
        idvd_poly_feat[2300] = pow(input_x[0], 1) * pow(input_x[1], 2) * pow(input_x[5], 3) * pow(input_x[6], 1);
        idvd_poly_feat[2301] = pow(input_x[0], 1) * pow(input_x[1], 2) * pow(input_x[5], 2) * pow(input_x[6], 2);
        idvd_poly_feat[2302] = pow(input_x[0], 1) * pow(input_x[1], 2) * pow(input_x[5], 1) * pow(input_x[6], 3);
        idvd_poly_feat[2303] = pow(input_x[0], 1) * pow(input_x[1], 2) * pow(input_x[6], 4);
        idvd_poly_feat[2304] = pow(input_x[0], 1) * pow(input_x[1], 1) * pow(input_x[2], 5);
        idvd_poly_feat[2305] = pow(input_x[0], 1) * pow(input_x[1], 1) * pow(input_x[2], 4) * pow(input_x[3], 1);
        idvd_poly_feat[2306] = pow(input_x[0], 1) * pow(input_x[1], 1) * pow(input_x[2], 4) * pow(input_x[4], 1);
        idvd_poly_feat[2307] = pow(input_x[0], 1) * pow(input_x[1], 1) * pow(input_x[2], 4) * pow(input_x[5], 1);
        idvd_poly_feat[2308] = pow(input_x[0], 1) * pow(input_x[1], 1) * pow(input_x[2], 4) * pow(input_x[6], 1);
        idvd_poly_feat[2309] = pow(input_x[0], 1) * pow(input_x[1], 1) * pow(input_x[2], 3) * pow(input_x[3], 2);
        idvd_poly_feat[2310] = pow(input_x[0], 1) * pow(input_x[1], 1) * pow(input_x[2], 3) * pow(input_x[3], 1) * pow(input_x[4], 1);
        idvd_poly_feat[2311] = pow(input_x[0], 1) * pow(input_x[1], 1) * pow(input_x[2], 3) * pow(input_x[3], 1) * pow(input_x[5], 1);
        idvd_poly_feat[2312] = pow(input_x[0], 1) * pow(input_x[1], 1) * pow(input_x[2], 3) * pow(input_x[3], 1) * pow(input_x[6], 1);
        idvd_poly_feat[2313] = pow(input_x[0], 1) * pow(input_x[1], 1) * pow(input_x[2], 3) * pow(input_x[4], 2);
        idvd_poly_feat[2314] = pow(input_x[0], 1) * pow(input_x[1], 1) * pow(input_x[2], 3) * pow(input_x[4], 1) * pow(input_x[5], 1);
        idvd_poly_feat[2315] = pow(input_x[0], 1) * pow(input_x[1], 1) * pow(input_x[2], 3) * pow(input_x[4], 1) * pow(input_x[6], 1);
        idvd_poly_feat[2316] = pow(input_x[0], 1) * pow(input_x[1], 1) * pow(input_x[2], 3) * pow(input_x[5], 2);
        idvd_poly_feat[2317] = pow(input_x[0], 1) * pow(input_x[1], 1) * pow(input_x[2], 3) * pow(input_x[5], 1) * pow(input_x[6], 1);
        idvd_poly_feat[2318] = pow(input_x[0], 1) * pow(input_x[1], 1) * pow(input_x[2], 3) * pow(input_x[6], 2);
        idvd_poly_feat[2319] = pow(input_x[0], 1) * pow(input_x[1], 1) * pow(input_x[2], 2) * pow(input_x[3], 3);
        idvd_poly_feat[2320] = pow(input_x[0], 1) * pow(input_x[1], 1) * pow(input_x[2], 2) * pow(input_x[3], 2) * pow(input_x[4], 1);
        idvd_poly_feat[2321] = pow(input_x[0], 1) * pow(input_x[1], 1) * pow(input_x[2], 2) * pow(input_x[3], 2) * pow(input_x[5], 1);
        idvd_poly_feat[2322] = pow(input_x[0], 1) * pow(input_x[1], 1) * pow(input_x[2], 2) * pow(input_x[3], 2) * pow(input_x[6], 1);
        idvd_poly_feat[2323] = pow(input_x[0], 1) * pow(input_x[1], 1) * pow(input_x[2], 2) * pow(input_x[3], 1) * pow(input_x[4], 2);
        idvd_poly_feat[2324] = pow(input_x[0], 1) * pow(input_x[1], 1) * pow(input_x[2], 2) * pow(input_x[3], 1) * pow(input_x[4], 1) * pow(input_x[5], 1);
        idvd_poly_feat[2325] = pow(input_x[0], 1) * pow(input_x[1], 1) * pow(input_x[2], 2) * pow(input_x[3], 1) * pow(input_x[4], 1) * pow(input_x[6], 1);
        idvd_poly_feat[2326] = pow(input_x[0], 1) * pow(input_x[1], 1) * pow(input_x[2], 2) * pow(input_x[3], 1) * pow(input_x[5], 2);
        idvd_poly_feat[2327] = pow(input_x[0], 1) * pow(input_x[1], 1) * pow(input_x[2], 2) * pow(input_x[3], 1) * pow(input_x[5], 1) * pow(input_x[6], 1);
        idvd_poly_feat[2328] = pow(input_x[0], 1) * pow(input_x[1], 1) * pow(input_x[2], 2) * pow(input_x[3], 1) * pow(input_x[6], 2);
        idvd_poly_feat[2329] = pow(input_x[0], 1) * pow(input_x[1], 1) * pow(input_x[2], 2) * pow(input_x[4], 3);
        idvd_poly_feat[2330] = pow(input_x[0], 1) * pow(input_x[1], 1) * pow(input_x[2], 2) * pow(input_x[4], 2) * pow(input_x[5], 1);
        idvd_poly_feat[2331] = pow(input_x[0], 1) * pow(input_x[1], 1) * pow(input_x[2], 2) * pow(input_x[4], 2) * pow(input_x[6], 1);
        idvd_poly_feat[2332] = pow(input_x[0], 1) * pow(input_x[1], 1) * pow(input_x[2], 2) * pow(input_x[4], 1) * pow(input_x[5], 2);
        idvd_poly_feat[2333] = pow(input_x[0], 1) * pow(input_x[1], 1) * pow(input_x[2], 2) * pow(input_x[4], 1) * pow(input_x[5], 1) * pow(input_x[6], 1);
        idvd_poly_feat[2334] = pow(input_x[0], 1) * pow(input_x[1], 1) * pow(input_x[2], 2) * pow(input_x[4], 1) * pow(input_x[6], 2);
        idvd_poly_feat[2335] = pow(input_x[0], 1) * pow(input_x[1], 1) * pow(input_x[2], 2) * pow(input_x[5], 3);
        idvd_poly_feat[2336] = pow(input_x[0], 1) * pow(input_x[1], 1) * pow(input_x[2], 2) * pow(input_x[5], 2) * pow(input_x[6], 1);
        idvd_poly_feat[2337] = pow(input_x[0], 1) * pow(input_x[1], 1) * pow(input_x[2], 2) * pow(input_x[5], 1) * pow(input_x[6], 2);
        idvd_poly_feat[2338] = pow(input_x[0], 1) * pow(input_x[1], 1) * pow(input_x[2], 2) * pow(input_x[6], 3);
        idvd_poly_feat[2339] = pow(input_x[0], 1) * pow(input_x[1], 1) * pow(input_x[2], 1) * pow(input_x[3], 4);
        idvd_poly_feat[2340] = pow(input_x[0], 1) * pow(input_x[1], 1) * pow(input_x[2], 1) * pow(input_x[3], 3) * pow(input_x[4], 1);
        idvd_poly_feat[2341] = pow(input_x[0], 1) * pow(input_x[1], 1) * pow(input_x[2], 1) * pow(input_x[3], 3) * pow(input_x[5], 1);
        idvd_poly_feat[2342] = pow(input_x[0], 1) * pow(input_x[1], 1) * pow(input_x[2], 1) * pow(input_x[3], 3) * pow(input_x[6], 1);
        idvd_poly_feat[2343] = pow(input_x[0], 1) * pow(input_x[1], 1) * pow(input_x[2], 1) * pow(input_x[3], 2) * pow(input_x[4], 2);
        idvd_poly_feat[2344] = pow(input_x[0], 1) * pow(input_x[1], 1) * pow(input_x[2], 1) * pow(input_x[3], 2) * pow(input_x[4], 1) * pow(input_x[5], 1);
        idvd_poly_feat[2345] = pow(input_x[0], 1) * pow(input_x[1], 1) * pow(input_x[2], 1) * pow(input_x[3], 2) * pow(input_x[4], 1) * pow(input_x[6], 1);
        idvd_poly_feat[2346] = pow(input_x[0], 1) * pow(input_x[1], 1) * pow(input_x[2], 1) * pow(input_x[3], 2) * pow(input_x[5], 2);
        idvd_poly_feat[2347] = pow(input_x[0], 1) * pow(input_x[1], 1) * pow(input_x[2], 1) * pow(input_x[3], 2) * pow(input_x[5], 1) * pow(input_x[6], 1);
        idvd_poly_feat[2348] = pow(input_x[0], 1) * pow(input_x[1], 1) * pow(input_x[2], 1) * pow(input_x[3], 2) * pow(input_x[6], 2);
        idvd_poly_feat[2349] = pow(input_x[0], 1) * pow(input_x[1], 1) * pow(input_x[2], 1) * pow(input_x[3], 1) * pow(input_x[4], 3);
        idvd_poly_feat[2350] = pow(input_x[0], 1) * pow(input_x[1], 1) * pow(input_x[2], 1) * pow(input_x[3], 1) * pow(input_x[4], 2) * pow(input_x[5], 1);
        idvd_poly_feat[2351] = pow(input_x[0], 1) * pow(input_x[1], 1) * pow(input_x[2], 1) * pow(input_x[3], 1) * pow(input_x[4], 2) * pow(input_x[6], 1);
        idvd_poly_feat[2352] = pow(input_x[0], 1) * pow(input_x[1], 1) * pow(input_x[2], 1) * pow(input_x[3], 1) * pow(input_x[4], 1) * pow(input_x[5], 2);
        idvd_poly_feat[2353] = pow(input_x[0], 1) * pow(input_x[1], 1) * pow(input_x[2], 1) * pow(input_x[3], 1) * pow(input_x[4], 1) * pow(input_x[5], 1) * pow(input_x[6], 1);
        idvd_poly_feat[2354] = pow(input_x[0], 1) * pow(input_x[1], 1) * pow(input_x[2], 1) * pow(input_x[3], 1) * pow(input_x[4], 1) * pow(input_x[6], 2);
        idvd_poly_feat[2355] = pow(input_x[0], 1) * pow(input_x[1], 1) * pow(input_x[2], 1) * pow(input_x[3], 1) * pow(input_x[5], 3);
        idvd_poly_feat[2356] = pow(input_x[0], 1) * pow(input_x[1], 1) * pow(input_x[2], 1) * pow(input_x[3], 1) * pow(input_x[5], 2) * pow(input_x[6], 1);
        idvd_poly_feat[2357] = pow(input_x[0], 1) * pow(input_x[1], 1) * pow(input_x[2], 1) * pow(input_x[3], 1) * pow(input_x[5], 1) * pow(input_x[6], 2);
        idvd_poly_feat[2358] = pow(input_x[0], 1) * pow(input_x[1], 1) * pow(input_x[2], 1) * pow(input_x[3], 1) * pow(input_x[6], 3);
        idvd_poly_feat[2359] = pow(input_x[0], 1) * pow(input_x[1], 1) * pow(input_x[2], 1) * pow(input_x[4], 4);
        idvd_poly_feat[2360] = pow(input_x[0], 1) * pow(input_x[1], 1) * pow(input_x[2], 1) * pow(input_x[4], 3) * pow(input_x[5], 1);
        idvd_poly_feat[2361] = pow(input_x[0], 1) * pow(input_x[1], 1) * pow(input_x[2], 1) * pow(input_x[4], 3) * pow(input_x[6], 1);
        idvd_poly_feat[2362] = pow(input_x[0], 1) * pow(input_x[1], 1) * pow(input_x[2], 1) * pow(input_x[4], 2) * pow(input_x[5], 2);
        idvd_poly_feat[2363] = pow(input_x[0], 1) * pow(input_x[1], 1) * pow(input_x[2], 1) * pow(input_x[4], 2) * pow(input_x[5], 1) * pow(input_x[6], 1);
        idvd_poly_feat[2364] = pow(input_x[0], 1) * pow(input_x[1], 1) * pow(input_x[2], 1) * pow(input_x[4], 2) * pow(input_x[6], 2);
        idvd_poly_feat[2365] = pow(input_x[0], 1) * pow(input_x[1], 1) * pow(input_x[2], 1) * pow(input_x[4], 1) * pow(input_x[5], 3);
        idvd_poly_feat[2366] = pow(input_x[0], 1) * pow(input_x[1], 1) * pow(input_x[2], 1) * pow(input_x[4], 1) * pow(input_x[5], 2) * pow(input_x[6], 1);
        idvd_poly_feat[2367] = pow(input_x[0], 1) * pow(input_x[1], 1) * pow(input_x[2], 1) * pow(input_x[4], 1) * pow(input_x[5], 1) * pow(input_x[6], 2);
        idvd_poly_feat[2368] = pow(input_x[0], 1) * pow(input_x[1], 1) * pow(input_x[2], 1) * pow(input_x[4], 1) * pow(input_x[6], 3);
        idvd_poly_feat[2369] = pow(input_x[0], 1) * pow(input_x[1], 1) * pow(input_x[2], 1) * pow(input_x[5], 4);
        idvd_poly_feat[2370] = pow(input_x[0], 1) * pow(input_x[1], 1) * pow(input_x[2], 1) * pow(input_x[5], 3) * pow(input_x[6], 1);
        idvd_poly_feat[2371] = pow(input_x[0], 1) * pow(input_x[1], 1) * pow(input_x[2], 1) * pow(input_x[5], 2) * pow(input_x[6], 2);
        idvd_poly_feat[2372] = pow(input_x[0], 1) * pow(input_x[1], 1) * pow(input_x[2], 1) * pow(input_x[5], 1) * pow(input_x[6], 3);
        idvd_poly_feat[2373] = pow(input_x[0], 1) * pow(input_x[1], 1) * pow(input_x[2], 1) * pow(input_x[6], 4);
        idvd_poly_feat[2374] = pow(input_x[0], 1) * pow(input_x[1], 1) * pow(input_x[3], 5);
        idvd_poly_feat[2375] = pow(input_x[0], 1) * pow(input_x[1], 1) * pow(input_x[3], 4) * pow(input_x[4], 1);
        idvd_poly_feat[2376] = pow(input_x[0], 1) * pow(input_x[1], 1) * pow(input_x[3], 4) * pow(input_x[5], 1);
        idvd_poly_feat[2377] = pow(input_x[0], 1) * pow(input_x[1], 1) * pow(input_x[3], 4) * pow(input_x[6], 1);
        idvd_poly_feat[2378] = pow(input_x[0], 1) * pow(input_x[1], 1) * pow(input_x[3], 3) * pow(input_x[4], 2);
        idvd_poly_feat[2379] = pow(input_x[0], 1) * pow(input_x[1], 1) * pow(input_x[3], 3) * pow(input_x[4], 1) * pow(input_x[5], 1);
        idvd_poly_feat[2380] = pow(input_x[0], 1) * pow(input_x[1], 1) * pow(input_x[3], 3) * pow(input_x[4], 1) * pow(input_x[6], 1);
        idvd_poly_feat[2381] = pow(input_x[0], 1) * pow(input_x[1], 1) * pow(input_x[3], 3) * pow(input_x[5], 2);
        idvd_poly_feat[2382] = pow(input_x[0], 1) * pow(input_x[1], 1) * pow(input_x[3], 3) * pow(input_x[5], 1) * pow(input_x[6], 1);
        idvd_poly_feat[2383] = pow(input_x[0], 1) * pow(input_x[1], 1) * pow(input_x[3], 3) * pow(input_x[6], 2);
        idvd_poly_feat[2384] = pow(input_x[0], 1) * pow(input_x[1], 1) * pow(input_x[3], 2) * pow(input_x[4], 3);
        idvd_poly_feat[2385] = pow(input_x[0], 1) * pow(input_x[1], 1) * pow(input_x[3], 2) * pow(input_x[4], 2) * pow(input_x[5], 1);
        idvd_poly_feat[2386] = pow(input_x[0], 1) * pow(input_x[1], 1) * pow(input_x[3], 2) * pow(input_x[4], 2) * pow(input_x[6], 1);
        idvd_poly_feat[2387] = pow(input_x[0], 1) * pow(input_x[1], 1) * pow(input_x[3], 2) * pow(input_x[4], 1) * pow(input_x[5], 2);
        idvd_poly_feat[2388] = pow(input_x[0], 1) * pow(input_x[1], 1) * pow(input_x[3], 2) * pow(input_x[4], 1) * pow(input_x[5], 1) * pow(input_x[6], 1);
        idvd_poly_feat[2389] = pow(input_x[0], 1) * pow(input_x[1], 1) * pow(input_x[3], 2) * pow(input_x[4], 1) * pow(input_x[6], 2);
        idvd_poly_feat[2390] = pow(input_x[0], 1) * pow(input_x[1], 1) * pow(input_x[3], 2) * pow(input_x[5], 3);
        idvd_poly_feat[2391] = pow(input_x[0], 1) * pow(input_x[1], 1) * pow(input_x[3], 2) * pow(input_x[5], 2) * pow(input_x[6], 1);
        idvd_poly_feat[2392] = pow(input_x[0], 1) * pow(input_x[1], 1) * pow(input_x[3], 2) * pow(input_x[5], 1) * pow(input_x[6], 2);
        idvd_poly_feat[2393] = pow(input_x[0], 1) * pow(input_x[1], 1) * pow(input_x[3], 2) * pow(input_x[6], 3);
        idvd_poly_feat[2394] = pow(input_x[0], 1) * pow(input_x[1], 1) * pow(input_x[3], 1) * pow(input_x[4], 4);
        idvd_poly_feat[2395] = pow(input_x[0], 1) * pow(input_x[1], 1) * pow(input_x[3], 1) * pow(input_x[4], 3) * pow(input_x[5], 1);
        idvd_poly_feat[2396] = pow(input_x[0], 1) * pow(input_x[1], 1) * pow(input_x[3], 1) * pow(input_x[4], 3) * pow(input_x[6], 1);
        idvd_poly_feat[2397] = pow(input_x[0], 1) * pow(input_x[1], 1) * pow(input_x[3], 1) * pow(input_x[4], 2) * pow(input_x[5], 2);
        idvd_poly_feat[2398] = pow(input_x[0], 1) * pow(input_x[1], 1) * pow(input_x[3], 1) * pow(input_x[4], 2) * pow(input_x[5], 1) * pow(input_x[6], 1);
        idvd_poly_feat[2399] = pow(input_x[0], 1) * pow(input_x[1], 1) * pow(input_x[3], 1) * pow(input_x[4], 2) * pow(input_x[6], 2);
        idvd_poly_feat[2400] = pow(input_x[0], 1) * pow(input_x[1], 1) * pow(input_x[3], 1) * pow(input_x[4], 1) * pow(input_x[5], 3);
        idvd_poly_feat[2401] = pow(input_x[0], 1) * pow(input_x[1], 1) * pow(input_x[3], 1) * pow(input_x[4], 1) * pow(input_x[5], 2) * pow(input_x[6], 1);
        idvd_poly_feat[2402] = pow(input_x[0], 1) * pow(input_x[1], 1) * pow(input_x[3], 1) * pow(input_x[4], 1) * pow(input_x[5], 1) * pow(input_x[6], 2);
        idvd_poly_feat[2403] = pow(input_x[0], 1) * pow(input_x[1], 1) * pow(input_x[3], 1) * pow(input_x[4], 1) * pow(input_x[6], 3);
        idvd_poly_feat[2404] = pow(input_x[0], 1) * pow(input_x[1], 1) * pow(input_x[3], 1) * pow(input_x[5], 4);
        idvd_poly_feat[2405] = pow(input_x[0], 1) * pow(input_x[1], 1) * pow(input_x[3], 1) * pow(input_x[5], 3) * pow(input_x[6], 1);
        idvd_poly_feat[2406] = pow(input_x[0], 1) * pow(input_x[1], 1) * pow(input_x[3], 1) * pow(input_x[5], 2) * pow(input_x[6], 2);
        idvd_poly_feat[2407] = pow(input_x[0], 1) * pow(input_x[1], 1) * pow(input_x[3], 1) * pow(input_x[5], 1) * pow(input_x[6], 3);
        idvd_poly_feat[2408] = pow(input_x[0], 1) * pow(input_x[1], 1) * pow(input_x[3], 1) * pow(input_x[6], 4);
        idvd_poly_feat[2409] = pow(input_x[0], 1) * pow(input_x[1], 1) * pow(input_x[4], 5);
        idvd_poly_feat[2410] = pow(input_x[0], 1) * pow(input_x[1], 1) * pow(input_x[4], 4) * pow(input_x[5], 1);
        idvd_poly_feat[2411] = pow(input_x[0], 1) * pow(input_x[1], 1) * pow(input_x[4], 4) * pow(input_x[6], 1);
        idvd_poly_feat[2412] = pow(input_x[0], 1) * pow(input_x[1], 1) * pow(input_x[4], 3) * pow(input_x[5], 2);
        idvd_poly_feat[2413] = pow(input_x[0], 1) * pow(input_x[1], 1) * pow(input_x[4], 3) * pow(input_x[5], 1) * pow(input_x[6], 1);
        idvd_poly_feat[2414] = pow(input_x[0], 1) * pow(input_x[1], 1) * pow(input_x[4], 3) * pow(input_x[6], 2);
        idvd_poly_feat[2415] = pow(input_x[0], 1) * pow(input_x[1], 1) * pow(input_x[4], 2) * pow(input_x[5], 3);
        idvd_poly_feat[2416] = pow(input_x[0], 1) * pow(input_x[1], 1) * pow(input_x[4], 2) * pow(input_x[5], 2) * pow(input_x[6], 1);
        idvd_poly_feat[2417] = pow(input_x[0], 1) * pow(input_x[1], 1) * pow(input_x[4], 2) * pow(input_x[5], 1) * pow(input_x[6], 2);
        idvd_poly_feat[2418] = pow(input_x[0], 1) * pow(input_x[1], 1) * pow(input_x[4], 2) * pow(input_x[6], 3);
        idvd_poly_feat[2419] = pow(input_x[0], 1) * pow(input_x[1], 1) * pow(input_x[4], 1) * pow(input_x[5], 4);
        idvd_poly_feat[2420] = pow(input_x[0], 1) * pow(input_x[1], 1) * pow(input_x[4], 1) * pow(input_x[5], 3) * pow(input_x[6], 1);
        idvd_poly_feat[2421] = pow(input_x[0], 1) * pow(input_x[1], 1) * pow(input_x[4], 1) * pow(input_x[5], 2) * pow(input_x[6], 2);
        idvd_poly_feat[2422] = pow(input_x[0], 1) * pow(input_x[1], 1) * pow(input_x[4], 1) * pow(input_x[5], 1) * pow(input_x[6], 3);
        idvd_poly_feat[2423] = pow(input_x[0], 1) * pow(input_x[1], 1) * pow(input_x[4], 1) * pow(input_x[6], 4);
        idvd_poly_feat[2424] = pow(input_x[0], 1) * pow(input_x[1], 1) * pow(input_x[5], 5);
        idvd_poly_feat[2425] = pow(input_x[0], 1) * pow(input_x[1], 1) * pow(input_x[5], 4) * pow(input_x[6], 1);
        idvd_poly_feat[2426] = pow(input_x[0], 1) * pow(input_x[1], 1) * pow(input_x[5], 3) * pow(input_x[6], 2);
        idvd_poly_feat[2427] = pow(input_x[0], 1) * pow(input_x[1], 1) * pow(input_x[5], 2) * pow(input_x[6], 3);
        idvd_poly_feat[2428] = pow(input_x[0], 1) * pow(input_x[1], 1) * pow(input_x[5], 1) * pow(input_x[6], 4);
        idvd_poly_feat[2429] = pow(input_x[0], 1) * pow(input_x[1], 1) * pow(input_x[6], 5);
        idvd_poly_feat[2430] = pow(input_x[0], 1) * pow(input_x[2], 6);
        idvd_poly_feat[2431] = pow(input_x[0], 1) * pow(input_x[2], 5) * pow(input_x[3], 1);
        idvd_poly_feat[2432] = pow(input_x[0], 1) * pow(input_x[2], 5) * pow(input_x[4], 1);
        idvd_poly_feat[2433] = pow(input_x[0], 1) * pow(input_x[2], 5) * pow(input_x[5], 1);
        idvd_poly_feat[2434] = pow(input_x[0], 1) * pow(input_x[2], 5) * pow(input_x[6], 1);
        idvd_poly_feat[2435] = pow(input_x[0], 1) * pow(input_x[2], 4) * pow(input_x[3], 2);
        idvd_poly_feat[2436] = pow(input_x[0], 1) * pow(input_x[2], 4) * pow(input_x[3], 1) * pow(input_x[4], 1);
        idvd_poly_feat[2437] = pow(input_x[0], 1) * pow(input_x[2], 4) * pow(input_x[3], 1) * pow(input_x[5], 1);
        idvd_poly_feat[2438] = pow(input_x[0], 1) * pow(input_x[2], 4) * pow(input_x[3], 1) * pow(input_x[6], 1);
        idvd_poly_feat[2439] = pow(input_x[0], 1) * pow(input_x[2], 4) * pow(input_x[4], 2);
        idvd_poly_feat[2440] = pow(input_x[0], 1) * pow(input_x[2], 4) * pow(input_x[4], 1) * pow(input_x[5], 1);
        idvd_poly_feat[2441] = pow(input_x[0], 1) * pow(input_x[2], 4) * pow(input_x[4], 1) * pow(input_x[6], 1);
        idvd_poly_feat[2442] = pow(input_x[0], 1) * pow(input_x[2], 4) * pow(input_x[5], 2);
        idvd_poly_feat[2443] = pow(input_x[0], 1) * pow(input_x[2], 4) * pow(input_x[5], 1) * pow(input_x[6], 1);
        idvd_poly_feat[2444] = pow(input_x[0], 1) * pow(input_x[2], 4) * pow(input_x[6], 2);
        idvd_poly_feat[2445] = pow(input_x[0], 1) * pow(input_x[2], 3) * pow(input_x[3], 3);
        idvd_poly_feat[2446] = pow(input_x[0], 1) * pow(input_x[2], 3) * pow(input_x[3], 2) * pow(input_x[4], 1);
        idvd_poly_feat[2447] = pow(input_x[0], 1) * pow(input_x[2], 3) * pow(input_x[3], 2) * pow(input_x[5], 1);
        idvd_poly_feat[2448] = pow(input_x[0], 1) * pow(input_x[2], 3) * pow(input_x[3], 2) * pow(input_x[6], 1);
        idvd_poly_feat[2449] = pow(input_x[0], 1) * pow(input_x[2], 3) * pow(input_x[3], 1) * pow(input_x[4], 2);
        idvd_poly_feat[2450] = pow(input_x[0], 1) * pow(input_x[2], 3) * pow(input_x[3], 1) * pow(input_x[4], 1) * pow(input_x[5], 1);
        idvd_poly_feat[2451] = pow(input_x[0], 1) * pow(input_x[2], 3) * pow(input_x[3], 1) * pow(input_x[4], 1) * pow(input_x[6], 1);
        idvd_poly_feat[2452] = pow(input_x[0], 1) * pow(input_x[2], 3) * pow(input_x[3], 1) * pow(input_x[5], 2);
        idvd_poly_feat[2453] = pow(input_x[0], 1) * pow(input_x[2], 3) * pow(input_x[3], 1) * pow(input_x[5], 1) * pow(input_x[6], 1);
        idvd_poly_feat[2454] = pow(input_x[0], 1) * pow(input_x[2], 3) * pow(input_x[3], 1) * pow(input_x[6], 2);
        idvd_poly_feat[2455] = pow(input_x[0], 1) * pow(input_x[2], 3) * pow(input_x[4], 3);
        idvd_poly_feat[2456] = pow(input_x[0], 1) * pow(input_x[2], 3) * pow(input_x[4], 2) * pow(input_x[5], 1);
        idvd_poly_feat[2457] = pow(input_x[0], 1) * pow(input_x[2], 3) * pow(input_x[4], 2) * pow(input_x[6], 1);
        idvd_poly_feat[2458] = pow(input_x[0], 1) * pow(input_x[2], 3) * pow(input_x[4], 1) * pow(input_x[5], 2);
        idvd_poly_feat[2459] = pow(input_x[0], 1) * pow(input_x[2], 3) * pow(input_x[4], 1) * pow(input_x[5], 1) * pow(input_x[6], 1);
        idvd_poly_feat[2460] = pow(input_x[0], 1) * pow(input_x[2], 3) * pow(input_x[4], 1) * pow(input_x[6], 2);
        idvd_poly_feat[2461] = pow(input_x[0], 1) * pow(input_x[2], 3) * pow(input_x[5], 3);
        idvd_poly_feat[2462] = pow(input_x[0], 1) * pow(input_x[2], 3) * pow(input_x[5], 2) * pow(input_x[6], 1);
        idvd_poly_feat[2463] = pow(input_x[0], 1) * pow(input_x[2], 3) * pow(input_x[5], 1) * pow(input_x[6], 2);
        idvd_poly_feat[2464] = pow(input_x[0], 1) * pow(input_x[2], 3) * pow(input_x[6], 3);
        idvd_poly_feat[2465] = pow(input_x[0], 1) * pow(input_x[2], 2) * pow(input_x[3], 4);
        idvd_poly_feat[2466] = pow(input_x[0], 1) * pow(input_x[2], 2) * pow(input_x[3], 3) * pow(input_x[4], 1);
        idvd_poly_feat[2467] = pow(input_x[0], 1) * pow(input_x[2], 2) * pow(input_x[3], 3) * pow(input_x[5], 1);
        idvd_poly_feat[2468] = pow(input_x[0], 1) * pow(input_x[2], 2) * pow(input_x[3], 3) * pow(input_x[6], 1);
        idvd_poly_feat[2469] = pow(input_x[0], 1) * pow(input_x[2], 2) * pow(input_x[3], 2) * pow(input_x[4], 2);
        idvd_poly_feat[2470] = pow(input_x[0], 1) * pow(input_x[2], 2) * pow(input_x[3], 2) * pow(input_x[4], 1) * pow(input_x[5], 1);
        idvd_poly_feat[2471] = pow(input_x[0], 1) * pow(input_x[2], 2) * pow(input_x[3], 2) * pow(input_x[4], 1) * pow(input_x[6], 1);
        idvd_poly_feat[2472] = pow(input_x[0], 1) * pow(input_x[2], 2) * pow(input_x[3], 2) * pow(input_x[5], 2);
        idvd_poly_feat[2473] = pow(input_x[0], 1) * pow(input_x[2], 2) * pow(input_x[3], 2) * pow(input_x[5], 1) * pow(input_x[6], 1);
        idvd_poly_feat[2474] = pow(input_x[0], 1) * pow(input_x[2], 2) * pow(input_x[3], 2) * pow(input_x[6], 2);
        idvd_poly_feat[2475] = pow(input_x[0], 1) * pow(input_x[2], 2) * pow(input_x[3], 1) * pow(input_x[4], 3);
        idvd_poly_feat[2476] = pow(input_x[0], 1) * pow(input_x[2], 2) * pow(input_x[3], 1) * pow(input_x[4], 2) * pow(input_x[5], 1);
        idvd_poly_feat[2477] = pow(input_x[0], 1) * pow(input_x[2], 2) * pow(input_x[3], 1) * pow(input_x[4], 2) * pow(input_x[6], 1);
        idvd_poly_feat[2478] = pow(input_x[0], 1) * pow(input_x[2], 2) * pow(input_x[3], 1) * pow(input_x[4], 1) * pow(input_x[5], 2);
        idvd_poly_feat[2479] = pow(input_x[0], 1) * pow(input_x[2], 2) * pow(input_x[3], 1) * pow(input_x[4], 1) * pow(input_x[5], 1) * pow(input_x[6], 1);
        idvd_poly_feat[2480] = pow(input_x[0], 1) * pow(input_x[2], 2) * pow(input_x[3], 1) * pow(input_x[4], 1) * pow(input_x[6], 2);
        idvd_poly_feat[2481] = pow(input_x[0], 1) * pow(input_x[2], 2) * pow(input_x[3], 1) * pow(input_x[5], 3);
        idvd_poly_feat[2482] = pow(input_x[0], 1) * pow(input_x[2], 2) * pow(input_x[3], 1) * pow(input_x[5], 2) * pow(input_x[6], 1);
        idvd_poly_feat[2483] = pow(input_x[0], 1) * pow(input_x[2], 2) * pow(input_x[3], 1) * pow(input_x[5], 1) * pow(input_x[6], 2);
        idvd_poly_feat[2484] = pow(input_x[0], 1) * pow(input_x[2], 2) * pow(input_x[3], 1) * pow(input_x[6], 3);
        idvd_poly_feat[2485] = pow(input_x[0], 1) * pow(input_x[2], 2) * pow(input_x[4], 4);
        idvd_poly_feat[2486] = pow(input_x[0], 1) * pow(input_x[2], 2) * pow(input_x[4], 3) * pow(input_x[5], 1);
        idvd_poly_feat[2487] = pow(input_x[0], 1) * pow(input_x[2], 2) * pow(input_x[4], 3) * pow(input_x[6], 1);
        idvd_poly_feat[2488] = pow(input_x[0], 1) * pow(input_x[2], 2) * pow(input_x[4], 2) * pow(input_x[5], 2);
        idvd_poly_feat[2489] = pow(input_x[0], 1) * pow(input_x[2], 2) * pow(input_x[4], 2) * pow(input_x[5], 1) * pow(input_x[6], 1);
        idvd_poly_feat[2490] = pow(input_x[0], 1) * pow(input_x[2], 2) * pow(input_x[4], 2) * pow(input_x[6], 2);
        idvd_poly_feat[2491] = pow(input_x[0], 1) * pow(input_x[2], 2) * pow(input_x[4], 1) * pow(input_x[5], 3);
        idvd_poly_feat[2492] = pow(input_x[0], 1) * pow(input_x[2], 2) * pow(input_x[4], 1) * pow(input_x[5], 2) * pow(input_x[6], 1);
        idvd_poly_feat[2493] = pow(input_x[0], 1) * pow(input_x[2], 2) * pow(input_x[4], 1) * pow(input_x[5], 1) * pow(input_x[6], 2);
        idvd_poly_feat[2494] = pow(input_x[0], 1) * pow(input_x[2], 2) * pow(input_x[4], 1) * pow(input_x[6], 3);
        idvd_poly_feat[2495] = pow(input_x[0], 1) * pow(input_x[2], 2) * pow(input_x[5], 4);
        idvd_poly_feat[2496] = pow(input_x[0], 1) * pow(input_x[2], 2) * pow(input_x[5], 3) * pow(input_x[6], 1);
        idvd_poly_feat[2497] = pow(input_x[0], 1) * pow(input_x[2], 2) * pow(input_x[5], 2) * pow(input_x[6], 2);
        idvd_poly_feat[2498] = pow(input_x[0], 1) * pow(input_x[2], 2) * pow(input_x[5], 1) * pow(input_x[6], 3);
        idvd_poly_feat[2499] = pow(input_x[0], 1) * pow(input_x[2], 2) * pow(input_x[6], 4);
        idvd_poly_feat[2500] = pow(input_x[0], 1) * pow(input_x[2], 1) * pow(input_x[3], 5);
        idvd_poly_feat[2501] = pow(input_x[0], 1) * pow(input_x[2], 1) * pow(input_x[3], 4) * pow(input_x[4], 1);
        idvd_poly_feat[2502] = pow(input_x[0], 1) * pow(input_x[2], 1) * pow(input_x[3], 4) * pow(input_x[5], 1);
        idvd_poly_feat[2503] = pow(input_x[0], 1) * pow(input_x[2], 1) * pow(input_x[3], 4) * pow(input_x[6], 1);
        idvd_poly_feat[2504] = pow(input_x[0], 1) * pow(input_x[2], 1) * pow(input_x[3], 3) * pow(input_x[4], 2);
        idvd_poly_feat[2505] = pow(input_x[0], 1) * pow(input_x[2], 1) * pow(input_x[3], 3) * pow(input_x[4], 1) * pow(input_x[5], 1);
        idvd_poly_feat[2506] = pow(input_x[0], 1) * pow(input_x[2], 1) * pow(input_x[3], 3) * pow(input_x[4], 1) * pow(input_x[6], 1);
        idvd_poly_feat[2507] = pow(input_x[0], 1) * pow(input_x[2], 1) * pow(input_x[3], 3) * pow(input_x[5], 2);
        idvd_poly_feat[2508] = pow(input_x[0], 1) * pow(input_x[2], 1) * pow(input_x[3], 3) * pow(input_x[5], 1) * pow(input_x[6], 1);
        idvd_poly_feat[2509] = pow(input_x[0], 1) * pow(input_x[2], 1) * pow(input_x[3], 3) * pow(input_x[6], 2);
        idvd_poly_feat[2510] = pow(input_x[0], 1) * pow(input_x[2], 1) * pow(input_x[3], 2) * pow(input_x[4], 3);
        idvd_poly_feat[2511] = pow(input_x[0], 1) * pow(input_x[2], 1) * pow(input_x[3], 2) * pow(input_x[4], 2) * pow(input_x[5], 1);
        idvd_poly_feat[2512] = pow(input_x[0], 1) * pow(input_x[2], 1) * pow(input_x[3], 2) * pow(input_x[4], 2) * pow(input_x[6], 1);
        idvd_poly_feat[2513] = pow(input_x[0], 1) * pow(input_x[2], 1) * pow(input_x[3], 2) * pow(input_x[4], 1) * pow(input_x[5], 2);
        idvd_poly_feat[2514] = pow(input_x[0], 1) * pow(input_x[2], 1) * pow(input_x[3], 2) * pow(input_x[4], 1) * pow(input_x[5], 1) * pow(input_x[6], 1);
        idvd_poly_feat[2515] = pow(input_x[0], 1) * pow(input_x[2], 1) * pow(input_x[3], 2) * pow(input_x[4], 1) * pow(input_x[6], 2);
        idvd_poly_feat[2516] = pow(input_x[0], 1) * pow(input_x[2], 1) * pow(input_x[3], 2) * pow(input_x[5], 3);
        idvd_poly_feat[2517] = pow(input_x[0], 1) * pow(input_x[2], 1) * pow(input_x[3], 2) * pow(input_x[5], 2) * pow(input_x[6], 1);
        idvd_poly_feat[2518] = pow(input_x[0], 1) * pow(input_x[2], 1) * pow(input_x[3], 2) * pow(input_x[5], 1) * pow(input_x[6], 2);
        idvd_poly_feat[2519] = pow(input_x[0], 1) * pow(input_x[2], 1) * pow(input_x[3], 2) * pow(input_x[6], 3);
        idvd_poly_feat[2520] = pow(input_x[0], 1) * pow(input_x[2], 1) * pow(input_x[3], 1) * pow(input_x[4], 4);
        idvd_poly_feat[2521] = pow(input_x[0], 1) * pow(input_x[2], 1) * pow(input_x[3], 1) * pow(input_x[4], 3) * pow(input_x[5], 1);
        idvd_poly_feat[2522] = pow(input_x[0], 1) * pow(input_x[2], 1) * pow(input_x[3], 1) * pow(input_x[4], 3) * pow(input_x[6], 1);
        idvd_poly_feat[2523] = pow(input_x[0], 1) * pow(input_x[2], 1) * pow(input_x[3], 1) * pow(input_x[4], 2) * pow(input_x[5], 2);
        idvd_poly_feat[2524] = pow(input_x[0], 1) * pow(input_x[2], 1) * pow(input_x[3], 1) * pow(input_x[4], 2) * pow(input_x[5], 1) * pow(input_x[6], 1);
        idvd_poly_feat[2525] = pow(input_x[0], 1) * pow(input_x[2], 1) * pow(input_x[3], 1) * pow(input_x[4], 2) * pow(input_x[6], 2);
        idvd_poly_feat[2526] = pow(input_x[0], 1) * pow(input_x[2], 1) * pow(input_x[3], 1) * pow(input_x[4], 1) * pow(input_x[5], 3);
        idvd_poly_feat[2527] = pow(input_x[0], 1) * pow(input_x[2], 1) * pow(input_x[3], 1) * pow(input_x[4], 1) * pow(input_x[5], 2) * pow(input_x[6], 1);
        idvd_poly_feat[2528] = pow(input_x[0], 1) * pow(input_x[2], 1) * pow(input_x[3], 1) * pow(input_x[4], 1) * pow(input_x[5], 1) * pow(input_x[6], 2);
        idvd_poly_feat[2529] = pow(input_x[0], 1) * pow(input_x[2], 1) * pow(input_x[3], 1) * pow(input_x[4], 1) * pow(input_x[6], 3);
        idvd_poly_feat[2530] = pow(input_x[0], 1) * pow(input_x[2], 1) * pow(input_x[3], 1) * pow(input_x[5], 4);
        idvd_poly_feat[2531] = pow(input_x[0], 1) * pow(input_x[2], 1) * pow(input_x[3], 1) * pow(input_x[5], 3) * pow(input_x[6], 1);
        idvd_poly_feat[2532] = pow(input_x[0], 1) * pow(input_x[2], 1) * pow(input_x[3], 1) * pow(input_x[5], 2) * pow(input_x[6], 2);
        idvd_poly_feat[2533] = pow(input_x[0], 1) * pow(input_x[2], 1) * pow(input_x[3], 1) * pow(input_x[5], 1) * pow(input_x[6], 3);
        idvd_poly_feat[2534] = pow(input_x[0], 1) * pow(input_x[2], 1) * pow(input_x[3], 1) * pow(input_x[6], 4);
        idvd_poly_feat[2535] = pow(input_x[0], 1) * pow(input_x[2], 1) * pow(input_x[4], 5);
        idvd_poly_feat[2536] = pow(input_x[0], 1) * pow(input_x[2], 1) * pow(input_x[4], 4) * pow(input_x[5], 1);
        idvd_poly_feat[2537] = pow(input_x[0], 1) * pow(input_x[2], 1) * pow(input_x[4], 4) * pow(input_x[6], 1);
        idvd_poly_feat[2538] = pow(input_x[0], 1) * pow(input_x[2], 1) * pow(input_x[4], 3) * pow(input_x[5], 2);
        idvd_poly_feat[2539] = pow(input_x[0], 1) * pow(input_x[2], 1) * pow(input_x[4], 3) * pow(input_x[5], 1) * pow(input_x[6], 1);
        idvd_poly_feat[2540] = pow(input_x[0], 1) * pow(input_x[2], 1) * pow(input_x[4], 3) * pow(input_x[6], 2);
        idvd_poly_feat[2541] = pow(input_x[0], 1) * pow(input_x[2], 1) * pow(input_x[4], 2) * pow(input_x[5], 3);
        idvd_poly_feat[2542] = pow(input_x[0], 1) * pow(input_x[2], 1) * pow(input_x[4], 2) * pow(input_x[5], 2) * pow(input_x[6], 1);
        idvd_poly_feat[2543] = pow(input_x[0], 1) * pow(input_x[2], 1) * pow(input_x[4], 2) * pow(input_x[5], 1) * pow(input_x[6], 2);
        idvd_poly_feat[2544] = pow(input_x[0], 1) * pow(input_x[2], 1) * pow(input_x[4], 2) * pow(input_x[6], 3);
        idvd_poly_feat[2545] = pow(input_x[0], 1) * pow(input_x[2], 1) * pow(input_x[4], 1) * pow(input_x[5], 4);
        idvd_poly_feat[2546] = pow(input_x[0], 1) * pow(input_x[2], 1) * pow(input_x[4], 1) * pow(input_x[5], 3) * pow(input_x[6], 1);
        idvd_poly_feat[2547] = pow(input_x[0], 1) * pow(input_x[2], 1) * pow(input_x[4], 1) * pow(input_x[5], 2) * pow(input_x[6], 2);
        idvd_poly_feat[2548] = pow(input_x[0], 1) * pow(input_x[2], 1) * pow(input_x[4], 1) * pow(input_x[5], 1) * pow(input_x[6], 3);
        idvd_poly_feat[2549] = pow(input_x[0], 1) * pow(input_x[2], 1) * pow(input_x[4], 1) * pow(input_x[6], 4);
        idvd_poly_feat[2550] = pow(input_x[0], 1) * pow(input_x[2], 1) * pow(input_x[5], 5);
        idvd_poly_feat[2551] = pow(input_x[0], 1) * pow(input_x[2], 1) * pow(input_x[5], 4) * pow(input_x[6], 1);
        idvd_poly_feat[2552] = pow(input_x[0], 1) * pow(input_x[2], 1) * pow(input_x[5], 3) * pow(input_x[6], 2);
        idvd_poly_feat[2553] = pow(input_x[0], 1) * pow(input_x[2], 1) * pow(input_x[5], 2) * pow(input_x[6], 3);
        idvd_poly_feat[2554] = pow(input_x[0], 1) * pow(input_x[2], 1) * pow(input_x[5], 1) * pow(input_x[6], 4);
        idvd_poly_feat[2555] = pow(input_x[0], 1) * pow(input_x[2], 1) * pow(input_x[6], 5);
        idvd_poly_feat[2556] = pow(input_x[0], 1) * pow(input_x[3], 6);
        idvd_poly_feat[2557] = pow(input_x[0], 1) * pow(input_x[3], 5) * pow(input_x[4], 1);
        idvd_poly_feat[2558] = pow(input_x[0], 1) * pow(input_x[3], 5) * pow(input_x[5], 1);
        idvd_poly_feat[2559] = pow(input_x[0], 1) * pow(input_x[3], 5) * pow(input_x[6], 1);
        idvd_poly_feat[2560] = pow(input_x[0], 1) * pow(input_x[3], 4) * pow(input_x[4], 2);
        idvd_poly_feat[2561] = pow(input_x[0], 1) * pow(input_x[3], 4) * pow(input_x[4], 1) * pow(input_x[5], 1);
        idvd_poly_feat[2562] = pow(input_x[0], 1) * pow(input_x[3], 4) * pow(input_x[4], 1) * pow(input_x[6], 1);
        idvd_poly_feat[2563] = pow(input_x[0], 1) * pow(input_x[3], 4) * pow(input_x[5], 2);
        idvd_poly_feat[2564] = pow(input_x[0], 1) * pow(input_x[3], 4) * pow(input_x[5], 1) * pow(input_x[6], 1);
        idvd_poly_feat[2565] = pow(input_x[0], 1) * pow(input_x[3], 4) * pow(input_x[6], 2);
        idvd_poly_feat[2566] = pow(input_x[0], 1) * pow(input_x[3], 3) * pow(input_x[4], 3);
        idvd_poly_feat[2567] = pow(input_x[0], 1) * pow(input_x[3], 3) * pow(input_x[4], 2) * pow(input_x[5], 1);
        idvd_poly_feat[2568] = pow(input_x[0], 1) * pow(input_x[3], 3) * pow(input_x[4], 2) * pow(input_x[6], 1);
        idvd_poly_feat[2569] = pow(input_x[0], 1) * pow(input_x[3], 3) * pow(input_x[4], 1) * pow(input_x[5], 2);
        idvd_poly_feat[2570] = pow(input_x[0], 1) * pow(input_x[3], 3) * pow(input_x[4], 1) * pow(input_x[5], 1) * pow(input_x[6], 1);
        idvd_poly_feat[2571] = pow(input_x[0], 1) * pow(input_x[3], 3) * pow(input_x[4], 1) * pow(input_x[6], 2);
        idvd_poly_feat[2572] = pow(input_x[0], 1) * pow(input_x[3], 3) * pow(input_x[5], 3);
        idvd_poly_feat[2573] = pow(input_x[0], 1) * pow(input_x[3], 3) * pow(input_x[5], 2) * pow(input_x[6], 1);
        idvd_poly_feat[2574] = pow(input_x[0], 1) * pow(input_x[3], 3) * pow(input_x[5], 1) * pow(input_x[6], 2);
        idvd_poly_feat[2575] = pow(input_x[0], 1) * pow(input_x[3], 3) * pow(input_x[6], 3);
        idvd_poly_feat[2576] = pow(input_x[0], 1) * pow(input_x[3], 2) * pow(input_x[4], 4);
        idvd_poly_feat[2577] = pow(input_x[0], 1) * pow(input_x[3], 2) * pow(input_x[4], 3) * pow(input_x[5], 1);
        idvd_poly_feat[2578] = pow(input_x[0], 1) * pow(input_x[3], 2) * pow(input_x[4], 3) * pow(input_x[6], 1);
        idvd_poly_feat[2579] = pow(input_x[0], 1) * pow(input_x[3], 2) * pow(input_x[4], 2) * pow(input_x[5], 2);
        idvd_poly_feat[2580] = pow(input_x[0], 1) * pow(input_x[3], 2) * pow(input_x[4], 2) * pow(input_x[5], 1) * pow(input_x[6], 1);
        idvd_poly_feat[2581] = pow(input_x[0], 1) * pow(input_x[3], 2) * pow(input_x[4], 2) * pow(input_x[6], 2);
        idvd_poly_feat[2582] = pow(input_x[0], 1) * pow(input_x[3], 2) * pow(input_x[4], 1) * pow(input_x[5], 3);
        idvd_poly_feat[2583] = pow(input_x[0], 1) * pow(input_x[3], 2) * pow(input_x[4], 1) * pow(input_x[5], 2) * pow(input_x[6], 1);
        idvd_poly_feat[2584] = pow(input_x[0], 1) * pow(input_x[3], 2) * pow(input_x[4], 1) * pow(input_x[5], 1) * pow(input_x[6], 2);
        idvd_poly_feat[2585] = pow(input_x[0], 1) * pow(input_x[3], 2) * pow(input_x[4], 1) * pow(input_x[6], 3);
        idvd_poly_feat[2586] = pow(input_x[0], 1) * pow(input_x[3], 2) * pow(input_x[5], 4);
        idvd_poly_feat[2587] = pow(input_x[0], 1) * pow(input_x[3], 2) * pow(input_x[5], 3) * pow(input_x[6], 1);
        idvd_poly_feat[2588] = pow(input_x[0], 1) * pow(input_x[3], 2) * pow(input_x[5], 2) * pow(input_x[6], 2);
        idvd_poly_feat[2589] = pow(input_x[0], 1) * pow(input_x[3], 2) * pow(input_x[5], 1) * pow(input_x[6], 3);
        idvd_poly_feat[2590] = pow(input_x[0], 1) * pow(input_x[3], 2) * pow(input_x[6], 4);
        idvd_poly_feat[2591] = pow(input_x[0], 1) * pow(input_x[3], 1) * pow(input_x[4], 5);
        idvd_poly_feat[2592] = pow(input_x[0], 1) * pow(input_x[3], 1) * pow(input_x[4], 4) * pow(input_x[5], 1);
        idvd_poly_feat[2593] = pow(input_x[0], 1) * pow(input_x[3], 1) * pow(input_x[4], 4) * pow(input_x[6], 1);
        idvd_poly_feat[2594] = pow(input_x[0], 1) * pow(input_x[3], 1) * pow(input_x[4], 3) * pow(input_x[5], 2);
        idvd_poly_feat[2595] = pow(input_x[0], 1) * pow(input_x[3], 1) * pow(input_x[4], 3) * pow(input_x[5], 1) * pow(input_x[6], 1);
        idvd_poly_feat[2596] = pow(input_x[0], 1) * pow(input_x[3], 1) * pow(input_x[4], 3) * pow(input_x[6], 2);
        idvd_poly_feat[2597] = pow(input_x[0], 1) * pow(input_x[3], 1) * pow(input_x[4], 2) * pow(input_x[5], 3);
        idvd_poly_feat[2598] = pow(input_x[0], 1) * pow(input_x[3], 1) * pow(input_x[4], 2) * pow(input_x[5], 2) * pow(input_x[6], 1);
        idvd_poly_feat[2599] = pow(input_x[0], 1) * pow(input_x[3], 1) * pow(input_x[4], 2) * pow(input_x[5], 1) * pow(input_x[6], 2);
        idvd_poly_feat[2600] = pow(input_x[0], 1) * pow(input_x[3], 1) * pow(input_x[4], 2) * pow(input_x[6], 3);
        idvd_poly_feat[2601] = pow(input_x[0], 1) * pow(input_x[3], 1) * pow(input_x[4], 1) * pow(input_x[5], 4);
        idvd_poly_feat[2602] = pow(input_x[0], 1) * pow(input_x[3], 1) * pow(input_x[4], 1) * pow(input_x[5], 3) * pow(input_x[6], 1);
        idvd_poly_feat[2603] = pow(input_x[0], 1) * pow(input_x[3], 1) * pow(input_x[4], 1) * pow(input_x[5], 2) * pow(input_x[6], 2);
        idvd_poly_feat[2604] = pow(input_x[0], 1) * pow(input_x[3], 1) * pow(input_x[4], 1) * pow(input_x[5], 1) * pow(input_x[6], 3);
        idvd_poly_feat[2605] = pow(input_x[0], 1) * pow(input_x[3], 1) * pow(input_x[4], 1) * pow(input_x[6], 4);
        idvd_poly_feat[2606] = pow(input_x[0], 1) * pow(input_x[3], 1) * pow(input_x[5], 5);
        idvd_poly_feat[2607] = pow(input_x[0], 1) * pow(input_x[3], 1) * pow(input_x[5], 4) * pow(input_x[6], 1);
        idvd_poly_feat[2608] = pow(input_x[0], 1) * pow(input_x[3], 1) * pow(input_x[5], 3) * pow(input_x[6], 2);
        idvd_poly_feat[2609] = pow(input_x[0], 1) * pow(input_x[3], 1) * pow(input_x[5], 2) * pow(input_x[6], 3);
        idvd_poly_feat[2610] = pow(input_x[0], 1) * pow(input_x[3], 1) * pow(input_x[5], 1) * pow(input_x[6], 4);
        idvd_poly_feat[2611] = pow(input_x[0], 1) * pow(input_x[3], 1) * pow(input_x[6], 5);
        idvd_poly_feat[2612] = pow(input_x[0], 1) * pow(input_x[4], 6);
        idvd_poly_feat[2613] = pow(input_x[0], 1) * pow(input_x[4], 5) * pow(input_x[5], 1);
        idvd_poly_feat[2614] = pow(input_x[0], 1) * pow(input_x[4], 5) * pow(input_x[6], 1);
        idvd_poly_feat[2615] = pow(input_x[0], 1) * pow(input_x[4], 4) * pow(input_x[5], 2);
        idvd_poly_feat[2616] = pow(input_x[0], 1) * pow(input_x[4], 4) * pow(input_x[5], 1) * pow(input_x[6], 1);
        idvd_poly_feat[2617] = pow(input_x[0], 1) * pow(input_x[4], 4) * pow(input_x[6], 2);
        idvd_poly_feat[2618] = pow(input_x[0], 1) * pow(input_x[4], 3) * pow(input_x[5], 3);
        idvd_poly_feat[2619] = pow(input_x[0], 1) * pow(input_x[4], 3) * pow(input_x[5], 2) * pow(input_x[6], 1);
        idvd_poly_feat[2620] = pow(input_x[0], 1) * pow(input_x[4], 3) * pow(input_x[5], 1) * pow(input_x[6], 2);
        idvd_poly_feat[2621] = pow(input_x[0], 1) * pow(input_x[4], 3) * pow(input_x[6], 3);
        idvd_poly_feat[2622] = pow(input_x[0], 1) * pow(input_x[4], 2) * pow(input_x[5], 4);
        idvd_poly_feat[2623] = pow(input_x[0], 1) * pow(input_x[4], 2) * pow(input_x[5], 3) * pow(input_x[6], 1);
        idvd_poly_feat[2624] = pow(input_x[0], 1) * pow(input_x[4], 2) * pow(input_x[5], 2) * pow(input_x[6], 2);
        idvd_poly_feat[2625] = pow(input_x[0], 1) * pow(input_x[4], 2) * pow(input_x[5], 1) * pow(input_x[6], 3);
        idvd_poly_feat[2626] = pow(input_x[0], 1) * pow(input_x[4], 2) * pow(input_x[6], 4);
        idvd_poly_feat[2627] = pow(input_x[0], 1) * pow(input_x[4], 1) * pow(input_x[5], 5);
        idvd_poly_feat[2628] = pow(input_x[0], 1) * pow(input_x[4], 1) * pow(input_x[5], 4) * pow(input_x[6], 1);
        idvd_poly_feat[2629] = pow(input_x[0], 1) * pow(input_x[4], 1) * pow(input_x[5], 3) * pow(input_x[6], 2);
        idvd_poly_feat[2630] = pow(input_x[0], 1) * pow(input_x[4], 1) * pow(input_x[5], 2) * pow(input_x[6], 3);
        idvd_poly_feat[2631] = pow(input_x[0], 1) * pow(input_x[4], 1) * pow(input_x[5], 1) * pow(input_x[6], 4);
        idvd_poly_feat[2632] = pow(input_x[0], 1) * pow(input_x[4], 1) * pow(input_x[6], 5);
        idvd_poly_feat[2633] = pow(input_x[0], 1) * pow(input_x[5], 6);
        idvd_poly_feat[2634] = pow(input_x[0], 1) * pow(input_x[5], 5) * pow(input_x[6], 1);
        idvd_poly_feat[2635] = pow(input_x[0], 1) * pow(input_x[5], 4) * pow(input_x[6], 2);
        idvd_poly_feat[2636] = pow(input_x[0], 1) * pow(input_x[5], 3) * pow(input_x[6], 3);
        idvd_poly_feat[2637] = pow(input_x[0], 1) * pow(input_x[5], 2) * pow(input_x[6], 4);
        idvd_poly_feat[2638] = pow(input_x[0], 1) * pow(input_x[5], 1) * pow(input_x[6], 5);
        idvd_poly_feat[2639] = pow(input_x[0], 1) * pow(input_x[6], 6);
        idvd_poly_feat[2640] = pow(input_x[1], 7);
        idvd_poly_feat[2641] = pow(input_x[1], 6) * pow(input_x[2], 1);
        idvd_poly_feat[2642] = pow(input_x[1], 6) * pow(input_x[3], 1);
        idvd_poly_feat[2643] = pow(input_x[1], 6) * pow(input_x[4], 1);
        idvd_poly_feat[2644] = pow(input_x[1], 6) * pow(input_x[5], 1);
        idvd_poly_feat[2645] = pow(input_x[1], 6) * pow(input_x[6], 1);
        idvd_poly_feat[2646] = pow(input_x[1], 5) * pow(input_x[2], 2);
        idvd_poly_feat[2647] = pow(input_x[1], 5) * pow(input_x[2], 1) * pow(input_x[3], 1);
        idvd_poly_feat[2648] = pow(input_x[1], 5) * pow(input_x[2], 1) * pow(input_x[4], 1);
        idvd_poly_feat[2649] = pow(input_x[1], 5) * pow(input_x[2], 1) * pow(input_x[5], 1);
        idvd_poly_feat[2650] = pow(input_x[1], 5) * pow(input_x[2], 1) * pow(input_x[6], 1);
        idvd_poly_feat[2651] = pow(input_x[1], 5) * pow(input_x[3], 2);
        idvd_poly_feat[2652] = pow(input_x[1], 5) * pow(input_x[3], 1) * pow(input_x[4], 1);
        idvd_poly_feat[2653] = pow(input_x[1], 5) * pow(input_x[3], 1) * pow(input_x[5], 1);
        idvd_poly_feat[2654] = pow(input_x[1], 5) * pow(input_x[3], 1) * pow(input_x[6], 1);
        idvd_poly_feat[2655] = pow(input_x[1], 5) * pow(input_x[4], 2);
        idvd_poly_feat[2656] = pow(input_x[1], 5) * pow(input_x[4], 1) * pow(input_x[5], 1);
        idvd_poly_feat[2657] = pow(input_x[1], 5) * pow(input_x[4], 1) * pow(input_x[6], 1);
        idvd_poly_feat[2658] = pow(input_x[1], 5) * pow(input_x[5], 2);
        idvd_poly_feat[2659] = pow(input_x[1], 5) * pow(input_x[5], 1) * pow(input_x[6], 1);
        idvd_poly_feat[2660] = pow(input_x[1], 5) * pow(input_x[6], 2);
        idvd_poly_feat[2661] = pow(input_x[1], 4) * pow(input_x[2], 3);
        idvd_poly_feat[2662] = pow(input_x[1], 4) * pow(input_x[2], 2) * pow(input_x[3], 1);
        idvd_poly_feat[2663] = pow(input_x[1], 4) * pow(input_x[2], 2) * pow(input_x[4], 1);
        idvd_poly_feat[2664] = pow(input_x[1], 4) * pow(input_x[2], 2) * pow(input_x[5], 1);
        idvd_poly_feat[2665] = pow(input_x[1], 4) * pow(input_x[2], 2) * pow(input_x[6], 1);
        idvd_poly_feat[2666] = pow(input_x[1], 4) * pow(input_x[2], 1) * pow(input_x[3], 2);
        idvd_poly_feat[2667] = pow(input_x[1], 4) * pow(input_x[2], 1) * pow(input_x[3], 1) * pow(input_x[4], 1);
        idvd_poly_feat[2668] = pow(input_x[1], 4) * pow(input_x[2], 1) * pow(input_x[3], 1) * pow(input_x[5], 1);
        idvd_poly_feat[2669] = pow(input_x[1], 4) * pow(input_x[2], 1) * pow(input_x[3], 1) * pow(input_x[6], 1);
        idvd_poly_feat[2670] = pow(input_x[1], 4) * pow(input_x[2], 1) * pow(input_x[4], 2);
        idvd_poly_feat[2671] = pow(input_x[1], 4) * pow(input_x[2], 1) * pow(input_x[4], 1) * pow(input_x[5], 1);
        idvd_poly_feat[2672] = pow(input_x[1], 4) * pow(input_x[2], 1) * pow(input_x[4], 1) * pow(input_x[6], 1);
        idvd_poly_feat[2673] = pow(input_x[1], 4) * pow(input_x[2], 1) * pow(input_x[5], 2);
        idvd_poly_feat[2674] = pow(input_x[1], 4) * pow(input_x[2], 1) * pow(input_x[5], 1) * pow(input_x[6], 1);
        idvd_poly_feat[2675] = pow(input_x[1], 4) * pow(input_x[2], 1) * pow(input_x[6], 2);
        idvd_poly_feat[2676] = pow(input_x[1], 4) * pow(input_x[3], 3);
        idvd_poly_feat[2677] = pow(input_x[1], 4) * pow(input_x[3], 2) * pow(input_x[4], 1);
        idvd_poly_feat[2678] = pow(input_x[1], 4) * pow(input_x[3], 2) * pow(input_x[5], 1);
        idvd_poly_feat[2679] = pow(input_x[1], 4) * pow(input_x[3], 2) * pow(input_x[6], 1);
        idvd_poly_feat[2680] = pow(input_x[1], 4) * pow(input_x[3], 1) * pow(input_x[4], 2);
        idvd_poly_feat[2681] = pow(input_x[1], 4) * pow(input_x[3], 1) * pow(input_x[4], 1) * pow(input_x[5], 1);
        idvd_poly_feat[2682] = pow(input_x[1], 4) * pow(input_x[3], 1) * pow(input_x[4], 1) * pow(input_x[6], 1);
        idvd_poly_feat[2683] = pow(input_x[1], 4) * pow(input_x[3], 1) * pow(input_x[5], 2);
        idvd_poly_feat[2684] = pow(input_x[1], 4) * pow(input_x[3], 1) * pow(input_x[5], 1) * pow(input_x[6], 1);
        idvd_poly_feat[2685] = pow(input_x[1], 4) * pow(input_x[3], 1) * pow(input_x[6], 2);
        idvd_poly_feat[2686] = pow(input_x[1], 4) * pow(input_x[4], 3);
        idvd_poly_feat[2687] = pow(input_x[1], 4) * pow(input_x[4], 2) * pow(input_x[5], 1);
        idvd_poly_feat[2688] = pow(input_x[1], 4) * pow(input_x[4], 2) * pow(input_x[6], 1);
        idvd_poly_feat[2689] = pow(input_x[1], 4) * pow(input_x[4], 1) * pow(input_x[5], 2);
        idvd_poly_feat[2690] = pow(input_x[1], 4) * pow(input_x[4], 1) * pow(input_x[5], 1) * pow(input_x[6], 1);
        idvd_poly_feat[2691] = pow(input_x[1], 4) * pow(input_x[4], 1) * pow(input_x[6], 2);
        idvd_poly_feat[2692] = pow(input_x[1], 4) * pow(input_x[5], 3);
        idvd_poly_feat[2693] = pow(input_x[1], 4) * pow(input_x[5], 2) * pow(input_x[6], 1);
        idvd_poly_feat[2694] = pow(input_x[1], 4) * pow(input_x[5], 1) * pow(input_x[6], 2);
        idvd_poly_feat[2695] = pow(input_x[1], 4) * pow(input_x[6], 3);
        idvd_poly_feat[2696] = pow(input_x[1], 3) * pow(input_x[2], 4);
        idvd_poly_feat[2697] = pow(input_x[1], 3) * pow(input_x[2], 3) * pow(input_x[3], 1);
        idvd_poly_feat[2698] = pow(input_x[1], 3) * pow(input_x[2], 3) * pow(input_x[4], 1);
        idvd_poly_feat[2699] = pow(input_x[1], 3) * pow(input_x[2], 3) * pow(input_x[5], 1);
        idvd_poly_feat[2700] = pow(input_x[1], 3) * pow(input_x[2], 3) * pow(input_x[6], 1);
        idvd_poly_feat[2701] = pow(input_x[1], 3) * pow(input_x[2], 2) * pow(input_x[3], 2);
        idvd_poly_feat[2702] = pow(input_x[1], 3) * pow(input_x[2], 2) * pow(input_x[3], 1) * pow(input_x[4], 1);
        idvd_poly_feat[2703] = pow(input_x[1], 3) * pow(input_x[2], 2) * pow(input_x[3], 1) * pow(input_x[5], 1);
        idvd_poly_feat[2704] = pow(input_x[1], 3) * pow(input_x[2], 2) * pow(input_x[3], 1) * pow(input_x[6], 1);
        idvd_poly_feat[2705] = pow(input_x[1], 3) * pow(input_x[2], 2) * pow(input_x[4], 2);
        idvd_poly_feat[2706] = pow(input_x[1], 3) * pow(input_x[2], 2) * pow(input_x[4], 1) * pow(input_x[5], 1);
        idvd_poly_feat[2707] = pow(input_x[1], 3) * pow(input_x[2], 2) * pow(input_x[4], 1) * pow(input_x[6], 1);
        idvd_poly_feat[2708] = pow(input_x[1], 3) * pow(input_x[2], 2) * pow(input_x[5], 2);
        idvd_poly_feat[2709] = pow(input_x[1], 3) * pow(input_x[2], 2) * pow(input_x[5], 1) * pow(input_x[6], 1);
        idvd_poly_feat[2710] = pow(input_x[1], 3) * pow(input_x[2], 2) * pow(input_x[6], 2);
        idvd_poly_feat[2711] = pow(input_x[1], 3) * pow(input_x[2], 1) * pow(input_x[3], 3);
        idvd_poly_feat[2712] = pow(input_x[1], 3) * pow(input_x[2], 1) * pow(input_x[3], 2) * pow(input_x[4], 1);
        idvd_poly_feat[2713] = pow(input_x[1], 3) * pow(input_x[2], 1) * pow(input_x[3], 2) * pow(input_x[5], 1);
        idvd_poly_feat[2714] = pow(input_x[1], 3) * pow(input_x[2], 1) * pow(input_x[3], 2) * pow(input_x[6], 1);
        idvd_poly_feat[2715] = pow(input_x[1], 3) * pow(input_x[2], 1) * pow(input_x[3], 1) * pow(input_x[4], 2);
        idvd_poly_feat[2716] = pow(input_x[1], 3) * pow(input_x[2], 1) * pow(input_x[3], 1) * pow(input_x[4], 1) * pow(input_x[5], 1);
        idvd_poly_feat[2717] = pow(input_x[1], 3) * pow(input_x[2], 1) * pow(input_x[3], 1) * pow(input_x[4], 1) * pow(input_x[6], 1);
        idvd_poly_feat[2718] = pow(input_x[1], 3) * pow(input_x[2], 1) * pow(input_x[3], 1) * pow(input_x[5], 2);
        idvd_poly_feat[2719] = pow(input_x[1], 3) * pow(input_x[2], 1) * pow(input_x[3], 1) * pow(input_x[5], 1) * pow(input_x[6], 1);
        idvd_poly_feat[2720] = pow(input_x[1], 3) * pow(input_x[2], 1) * pow(input_x[3], 1) * pow(input_x[6], 2);
        idvd_poly_feat[2721] = pow(input_x[1], 3) * pow(input_x[2], 1) * pow(input_x[4], 3);
        idvd_poly_feat[2722] = pow(input_x[1], 3) * pow(input_x[2], 1) * pow(input_x[4], 2) * pow(input_x[5], 1);
        idvd_poly_feat[2723] = pow(input_x[1], 3) * pow(input_x[2], 1) * pow(input_x[4], 2) * pow(input_x[6], 1);
        idvd_poly_feat[2724] = pow(input_x[1], 3) * pow(input_x[2], 1) * pow(input_x[4], 1) * pow(input_x[5], 2);
        idvd_poly_feat[2725] = pow(input_x[1], 3) * pow(input_x[2], 1) * pow(input_x[4], 1) * pow(input_x[5], 1) * pow(input_x[6], 1);
        idvd_poly_feat[2726] = pow(input_x[1], 3) * pow(input_x[2], 1) * pow(input_x[4], 1) * pow(input_x[6], 2);
        idvd_poly_feat[2727] = pow(input_x[1], 3) * pow(input_x[2], 1) * pow(input_x[5], 3);
        idvd_poly_feat[2728] = pow(input_x[1], 3) * pow(input_x[2], 1) * pow(input_x[5], 2) * pow(input_x[6], 1);
        idvd_poly_feat[2729] = pow(input_x[1], 3) * pow(input_x[2], 1) * pow(input_x[5], 1) * pow(input_x[6], 2);
        idvd_poly_feat[2730] = pow(input_x[1], 3) * pow(input_x[2], 1) * pow(input_x[6], 3);
        idvd_poly_feat[2731] = pow(input_x[1], 3) * pow(input_x[3], 4);
        idvd_poly_feat[2732] = pow(input_x[1], 3) * pow(input_x[3], 3) * pow(input_x[4], 1);
        idvd_poly_feat[2733] = pow(input_x[1], 3) * pow(input_x[3], 3) * pow(input_x[5], 1);
        idvd_poly_feat[2734] = pow(input_x[1], 3) * pow(input_x[3], 3) * pow(input_x[6], 1);
        idvd_poly_feat[2735] = pow(input_x[1], 3) * pow(input_x[3], 2) * pow(input_x[4], 2);
        idvd_poly_feat[2736] = pow(input_x[1], 3) * pow(input_x[3], 2) * pow(input_x[4], 1) * pow(input_x[5], 1);
        idvd_poly_feat[2737] = pow(input_x[1], 3) * pow(input_x[3], 2) * pow(input_x[4], 1) * pow(input_x[6], 1);
        idvd_poly_feat[2738] = pow(input_x[1], 3) * pow(input_x[3], 2) * pow(input_x[5], 2);
        idvd_poly_feat[2739] = pow(input_x[1], 3) * pow(input_x[3], 2) * pow(input_x[5], 1) * pow(input_x[6], 1);
        idvd_poly_feat[2740] = pow(input_x[1], 3) * pow(input_x[3], 2) * pow(input_x[6], 2);
        idvd_poly_feat[2741] = pow(input_x[1], 3) * pow(input_x[3], 1) * pow(input_x[4], 3);
        idvd_poly_feat[2742] = pow(input_x[1], 3) * pow(input_x[3], 1) * pow(input_x[4], 2) * pow(input_x[5], 1);
        idvd_poly_feat[2743] = pow(input_x[1], 3) * pow(input_x[3], 1) * pow(input_x[4], 2) * pow(input_x[6], 1);
        idvd_poly_feat[2744] = pow(input_x[1], 3) * pow(input_x[3], 1) * pow(input_x[4], 1) * pow(input_x[5], 2);
        idvd_poly_feat[2745] = pow(input_x[1], 3) * pow(input_x[3], 1) * pow(input_x[4], 1) * pow(input_x[5], 1) * pow(input_x[6], 1);
        idvd_poly_feat[2746] = pow(input_x[1], 3) * pow(input_x[3], 1) * pow(input_x[4], 1) * pow(input_x[6], 2);
        idvd_poly_feat[2747] = pow(input_x[1], 3) * pow(input_x[3], 1) * pow(input_x[5], 3);
        idvd_poly_feat[2748] = pow(input_x[1], 3) * pow(input_x[3], 1) * pow(input_x[5], 2) * pow(input_x[6], 1);
        idvd_poly_feat[2749] = pow(input_x[1], 3) * pow(input_x[3], 1) * pow(input_x[5], 1) * pow(input_x[6], 2);
        idvd_poly_feat[2750] = pow(input_x[1], 3) * pow(input_x[3], 1) * pow(input_x[6], 3);
        idvd_poly_feat[2751] = pow(input_x[1], 3) * pow(input_x[4], 4);
        idvd_poly_feat[2752] = pow(input_x[1], 3) * pow(input_x[4], 3) * pow(input_x[5], 1);
        idvd_poly_feat[2753] = pow(input_x[1], 3) * pow(input_x[4], 3) * pow(input_x[6], 1);
        idvd_poly_feat[2754] = pow(input_x[1], 3) * pow(input_x[4], 2) * pow(input_x[5], 2);
        idvd_poly_feat[2755] = pow(input_x[1], 3) * pow(input_x[4], 2) * pow(input_x[5], 1) * pow(input_x[6], 1);
        idvd_poly_feat[2756] = pow(input_x[1], 3) * pow(input_x[4], 2) * pow(input_x[6], 2);
        idvd_poly_feat[2757] = pow(input_x[1], 3) * pow(input_x[4], 1) * pow(input_x[5], 3);
        idvd_poly_feat[2758] = pow(input_x[1], 3) * pow(input_x[4], 1) * pow(input_x[5], 2) * pow(input_x[6], 1);
        idvd_poly_feat[2759] = pow(input_x[1], 3) * pow(input_x[4], 1) * pow(input_x[5], 1) * pow(input_x[6], 2);
        idvd_poly_feat[2760] = pow(input_x[1], 3) * pow(input_x[4], 1) * pow(input_x[6], 3);
        idvd_poly_feat[2761] = pow(input_x[1], 3) * pow(input_x[5], 4);
        idvd_poly_feat[2762] = pow(input_x[1], 3) * pow(input_x[5], 3) * pow(input_x[6], 1);
        idvd_poly_feat[2763] = pow(input_x[1], 3) * pow(input_x[5], 2) * pow(input_x[6], 2);
        idvd_poly_feat[2764] = pow(input_x[1], 3) * pow(input_x[5], 1) * pow(input_x[6], 3);
        idvd_poly_feat[2765] = pow(input_x[1], 3) * pow(input_x[6], 4);
        idvd_poly_feat[2766] = pow(input_x[1], 2) * pow(input_x[2], 5);
        idvd_poly_feat[2767] = pow(input_x[1], 2) * pow(input_x[2], 4) * pow(input_x[3], 1);
        idvd_poly_feat[2768] = pow(input_x[1], 2) * pow(input_x[2], 4) * pow(input_x[4], 1);
        idvd_poly_feat[2769] = pow(input_x[1], 2) * pow(input_x[2], 4) * pow(input_x[5], 1);
        idvd_poly_feat[2770] = pow(input_x[1], 2) * pow(input_x[2], 4) * pow(input_x[6], 1);
        idvd_poly_feat[2771] = pow(input_x[1], 2) * pow(input_x[2], 3) * pow(input_x[3], 2);
        idvd_poly_feat[2772] = pow(input_x[1], 2) * pow(input_x[2], 3) * pow(input_x[3], 1) * pow(input_x[4], 1);
        idvd_poly_feat[2773] = pow(input_x[1], 2) * pow(input_x[2], 3) * pow(input_x[3], 1) * pow(input_x[5], 1);
        idvd_poly_feat[2774] = pow(input_x[1], 2) * pow(input_x[2], 3) * pow(input_x[3], 1) * pow(input_x[6], 1);
        idvd_poly_feat[2775] = pow(input_x[1], 2) * pow(input_x[2], 3) * pow(input_x[4], 2);
        idvd_poly_feat[2776] = pow(input_x[1], 2) * pow(input_x[2], 3) * pow(input_x[4], 1) * pow(input_x[5], 1);
        idvd_poly_feat[2777] = pow(input_x[1], 2) * pow(input_x[2], 3) * pow(input_x[4], 1) * pow(input_x[6], 1);
        idvd_poly_feat[2778] = pow(input_x[1], 2) * pow(input_x[2], 3) * pow(input_x[5], 2);
        idvd_poly_feat[2779] = pow(input_x[1], 2) * pow(input_x[2], 3) * pow(input_x[5], 1) * pow(input_x[6], 1);
        idvd_poly_feat[2780] = pow(input_x[1], 2) * pow(input_x[2], 3) * pow(input_x[6], 2);
        idvd_poly_feat[2781] = pow(input_x[1], 2) * pow(input_x[2], 2) * pow(input_x[3], 3);
        idvd_poly_feat[2782] = pow(input_x[1], 2) * pow(input_x[2], 2) * pow(input_x[3], 2) * pow(input_x[4], 1);
        idvd_poly_feat[2783] = pow(input_x[1], 2) * pow(input_x[2], 2) * pow(input_x[3], 2) * pow(input_x[5], 1);
        idvd_poly_feat[2784] = pow(input_x[1], 2) * pow(input_x[2], 2) * pow(input_x[3], 2) * pow(input_x[6], 1);
        idvd_poly_feat[2785] = pow(input_x[1], 2) * pow(input_x[2], 2) * pow(input_x[3], 1) * pow(input_x[4], 2);
        idvd_poly_feat[2786] = pow(input_x[1], 2) * pow(input_x[2], 2) * pow(input_x[3], 1) * pow(input_x[4], 1) * pow(input_x[5], 1);
        idvd_poly_feat[2787] = pow(input_x[1], 2) * pow(input_x[2], 2) * pow(input_x[3], 1) * pow(input_x[4], 1) * pow(input_x[6], 1);
        idvd_poly_feat[2788] = pow(input_x[1], 2) * pow(input_x[2], 2) * pow(input_x[3], 1) * pow(input_x[5], 2);
        idvd_poly_feat[2789] = pow(input_x[1], 2) * pow(input_x[2], 2) * pow(input_x[3], 1) * pow(input_x[5], 1) * pow(input_x[6], 1);
        idvd_poly_feat[2790] = pow(input_x[1], 2) * pow(input_x[2], 2) * pow(input_x[3], 1) * pow(input_x[6], 2);
        idvd_poly_feat[2791] = pow(input_x[1], 2) * pow(input_x[2], 2) * pow(input_x[4], 3);
        idvd_poly_feat[2792] = pow(input_x[1], 2) * pow(input_x[2], 2) * pow(input_x[4], 2) * pow(input_x[5], 1);
        idvd_poly_feat[2793] = pow(input_x[1], 2) * pow(input_x[2], 2) * pow(input_x[4], 2) * pow(input_x[6], 1);
        idvd_poly_feat[2794] = pow(input_x[1], 2) * pow(input_x[2], 2) * pow(input_x[4], 1) * pow(input_x[5], 2);
        idvd_poly_feat[2795] = pow(input_x[1], 2) * pow(input_x[2], 2) * pow(input_x[4], 1) * pow(input_x[5], 1) * pow(input_x[6], 1);
        idvd_poly_feat[2796] = pow(input_x[1], 2) * pow(input_x[2], 2) * pow(input_x[4], 1) * pow(input_x[6], 2);
        idvd_poly_feat[2797] = pow(input_x[1], 2) * pow(input_x[2], 2) * pow(input_x[5], 3);
        idvd_poly_feat[2798] = pow(input_x[1], 2) * pow(input_x[2], 2) * pow(input_x[5], 2) * pow(input_x[6], 1);
        idvd_poly_feat[2799] = pow(input_x[1], 2) * pow(input_x[2], 2) * pow(input_x[5], 1) * pow(input_x[6], 2);
        idvd_poly_feat[2800] = pow(input_x[1], 2) * pow(input_x[2], 2) * pow(input_x[6], 3);
        idvd_poly_feat[2801] = pow(input_x[1], 2) * pow(input_x[2], 1) * pow(input_x[3], 4);
        idvd_poly_feat[2802] = pow(input_x[1], 2) * pow(input_x[2], 1) * pow(input_x[3], 3) * pow(input_x[4], 1);
        idvd_poly_feat[2803] = pow(input_x[1], 2) * pow(input_x[2], 1) * pow(input_x[3], 3) * pow(input_x[5], 1);
        idvd_poly_feat[2804] = pow(input_x[1], 2) * pow(input_x[2], 1) * pow(input_x[3], 3) * pow(input_x[6], 1);
        idvd_poly_feat[2805] = pow(input_x[1], 2) * pow(input_x[2], 1) * pow(input_x[3], 2) * pow(input_x[4], 2);
        idvd_poly_feat[2806] = pow(input_x[1], 2) * pow(input_x[2], 1) * pow(input_x[3], 2) * pow(input_x[4], 1) * pow(input_x[5], 1);
        idvd_poly_feat[2807] = pow(input_x[1], 2) * pow(input_x[2], 1) * pow(input_x[3], 2) * pow(input_x[4], 1) * pow(input_x[6], 1);
        idvd_poly_feat[2808] = pow(input_x[1], 2) * pow(input_x[2], 1) * pow(input_x[3], 2) * pow(input_x[5], 2);
        idvd_poly_feat[2809] = pow(input_x[1], 2) * pow(input_x[2], 1) * pow(input_x[3], 2) * pow(input_x[5], 1) * pow(input_x[6], 1);
        idvd_poly_feat[2810] = pow(input_x[1], 2) * pow(input_x[2], 1) * pow(input_x[3], 2) * pow(input_x[6], 2);
        idvd_poly_feat[2811] = pow(input_x[1], 2) * pow(input_x[2], 1) * pow(input_x[3], 1) * pow(input_x[4], 3);
        idvd_poly_feat[2812] = pow(input_x[1], 2) * pow(input_x[2], 1) * pow(input_x[3], 1) * pow(input_x[4], 2) * pow(input_x[5], 1);
        idvd_poly_feat[2813] = pow(input_x[1], 2) * pow(input_x[2], 1) * pow(input_x[3], 1) * pow(input_x[4], 2) * pow(input_x[6], 1);
        idvd_poly_feat[2814] = pow(input_x[1], 2) * pow(input_x[2], 1) * pow(input_x[3], 1) * pow(input_x[4], 1) * pow(input_x[5], 2);
        idvd_poly_feat[2815] = pow(input_x[1], 2) * pow(input_x[2], 1) * pow(input_x[3], 1) * pow(input_x[4], 1) * pow(input_x[5], 1) * pow(input_x[6], 1);
        idvd_poly_feat[2816] = pow(input_x[1], 2) * pow(input_x[2], 1) * pow(input_x[3], 1) * pow(input_x[4], 1) * pow(input_x[6], 2);
        idvd_poly_feat[2817] = pow(input_x[1], 2) * pow(input_x[2], 1) * pow(input_x[3], 1) * pow(input_x[5], 3);
        idvd_poly_feat[2818] = pow(input_x[1], 2) * pow(input_x[2], 1) * pow(input_x[3], 1) * pow(input_x[5], 2) * pow(input_x[6], 1);
        idvd_poly_feat[2819] = pow(input_x[1], 2) * pow(input_x[2], 1) * pow(input_x[3], 1) * pow(input_x[5], 1) * pow(input_x[6], 2);
        idvd_poly_feat[2820] = pow(input_x[1], 2) * pow(input_x[2], 1) * pow(input_x[3], 1) * pow(input_x[6], 3);
        idvd_poly_feat[2821] = pow(input_x[1], 2) * pow(input_x[2], 1) * pow(input_x[4], 4);
        idvd_poly_feat[2822] = pow(input_x[1], 2) * pow(input_x[2], 1) * pow(input_x[4], 3) * pow(input_x[5], 1);
        idvd_poly_feat[2823] = pow(input_x[1], 2) * pow(input_x[2], 1) * pow(input_x[4], 3) * pow(input_x[6], 1);
        idvd_poly_feat[2824] = pow(input_x[1], 2) * pow(input_x[2], 1) * pow(input_x[4], 2) * pow(input_x[5], 2);
        idvd_poly_feat[2825] = pow(input_x[1], 2) * pow(input_x[2], 1) * pow(input_x[4], 2) * pow(input_x[5], 1) * pow(input_x[6], 1);
        idvd_poly_feat[2826] = pow(input_x[1], 2) * pow(input_x[2], 1) * pow(input_x[4], 2) * pow(input_x[6], 2);
        idvd_poly_feat[2827] = pow(input_x[1], 2) * pow(input_x[2], 1) * pow(input_x[4], 1) * pow(input_x[5], 3);
        idvd_poly_feat[2828] = pow(input_x[1], 2) * pow(input_x[2], 1) * pow(input_x[4], 1) * pow(input_x[5], 2) * pow(input_x[6], 1);
        idvd_poly_feat[2829] = pow(input_x[1], 2) * pow(input_x[2], 1) * pow(input_x[4], 1) * pow(input_x[5], 1) * pow(input_x[6], 2);
        idvd_poly_feat[2830] = pow(input_x[1], 2) * pow(input_x[2], 1) * pow(input_x[4], 1) * pow(input_x[6], 3);
        idvd_poly_feat[2831] = pow(input_x[1], 2) * pow(input_x[2], 1) * pow(input_x[5], 4);
        idvd_poly_feat[2832] = pow(input_x[1], 2) * pow(input_x[2], 1) * pow(input_x[5], 3) * pow(input_x[6], 1);
        idvd_poly_feat[2833] = pow(input_x[1], 2) * pow(input_x[2], 1) * pow(input_x[5], 2) * pow(input_x[6], 2);
        idvd_poly_feat[2834] = pow(input_x[1], 2) * pow(input_x[2], 1) * pow(input_x[5], 1) * pow(input_x[6], 3);
        idvd_poly_feat[2835] = pow(input_x[1], 2) * pow(input_x[2], 1) * pow(input_x[6], 4);
        idvd_poly_feat[2836] = pow(input_x[1], 2) * pow(input_x[3], 5);
        idvd_poly_feat[2837] = pow(input_x[1], 2) * pow(input_x[3], 4) * pow(input_x[4], 1);
        idvd_poly_feat[2838] = pow(input_x[1], 2) * pow(input_x[3], 4) * pow(input_x[5], 1);
        idvd_poly_feat[2839] = pow(input_x[1], 2) * pow(input_x[3], 4) * pow(input_x[6], 1);
        idvd_poly_feat[2840] = pow(input_x[1], 2) * pow(input_x[3], 3) * pow(input_x[4], 2);
        idvd_poly_feat[2841] = pow(input_x[1], 2) * pow(input_x[3], 3) * pow(input_x[4], 1) * pow(input_x[5], 1);
        idvd_poly_feat[2842] = pow(input_x[1], 2) * pow(input_x[3], 3) * pow(input_x[4], 1) * pow(input_x[6], 1);
        idvd_poly_feat[2843] = pow(input_x[1], 2) * pow(input_x[3], 3) * pow(input_x[5], 2);
        idvd_poly_feat[2844] = pow(input_x[1], 2) * pow(input_x[3], 3) * pow(input_x[5], 1) * pow(input_x[6], 1);
        idvd_poly_feat[2845] = pow(input_x[1], 2) * pow(input_x[3], 3) * pow(input_x[6], 2);
        idvd_poly_feat[2846] = pow(input_x[1], 2) * pow(input_x[3], 2) * pow(input_x[4], 3);
        idvd_poly_feat[2847] = pow(input_x[1], 2) * pow(input_x[3], 2) * pow(input_x[4], 2) * pow(input_x[5], 1);
        idvd_poly_feat[2848] = pow(input_x[1], 2) * pow(input_x[3], 2) * pow(input_x[4], 2) * pow(input_x[6], 1);
        idvd_poly_feat[2849] = pow(input_x[1], 2) * pow(input_x[3], 2) * pow(input_x[4], 1) * pow(input_x[5], 2);
        idvd_poly_feat[2850] = pow(input_x[1], 2) * pow(input_x[3], 2) * pow(input_x[4], 1) * pow(input_x[5], 1) * pow(input_x[6], 1);
        idvd_poly_feat[2851] = pow(input_x[1], 2) * pow(input_x[3], 2) * pow(input_x[4], 1) * pow(input_x[6], 2);
        idvd_poly_feat[2852] = pow(input_x[1], 2) * pow(input_x[3], 2) * pow(input_x[5], 3);
        idvd_poly_feat[2853] = pow(input_x[1], 2) * pow(input_x[3], 2) * pow(input_x[5], 2) * pow(input_x[6], 1);
        idvd_poly_feat[2854] = pow(input_x[1], 2) * pow(input_x[3], 2) * pow(input_x[5], 1) * pow(input_x[6], 2);
        idvd_poly_feat[2855] = pow(input_x[1], 2) * pow(input_x[3], 2) * pow(input_x[6], 3);
        idvd_poly_feat[2856] = pow(input_x[1], 2) * pow(input_x[3], 1) * pow(input_x[4], 4);
        idvd_poly_feat[2857] = pow(input_x[1], 2) * pow(input_x[3], 1) * pow(input_x[4], 3) * pow(input_x[5], 1);
        idvd_poly_feat[2858] = pow(input_x[1], 2) * pow(input_x[3], 1) * pow(input_x[4], 3) * pow(input_x[6], 1);
        idvd_poly_feat[2859] = pow(input_x[1], 2) * pow(input_x[3], 1) * pow(input_x[4], 2) * pow(input_x[5], 2);
        idvd_poly_feat[2860] = pow(input_x[1], 2) * pow(input_x[3], 1) * pow(input_x[4], 2) * pow(input_x[5], 1) * pow(input_x[6], 1);
        idvd_poly_feat[2861] = pow(input_x[1], 2) * pow(input_x[3], 1) * pow(input_x[4], 2) * pow(input_x[6], 2);
        idvd_poly_feat[2862] = pow(input_x[1], 2) * pow(input_x[3], 1) * pow(input_x[4], 1) * pow(input_x[5], 3);
        idvd_poly_feat[2863] = pow(input_x[1], 2) * pow(input_x[3], 1) * pow(input_x[4], 1) * pow(input_x[5], 2) * pow(input_x[6], 1);
        idvd_poly_feat[2864] = pow(input_x[1], 2) * pow(input_x[3], 1) * pow(input_x[4], 1) * pow(input_x[5], 1) * pow(input_x[6], 2);
        idvd_poly_feat[2865] = pow(input_x[1], 2) * pow(input_x[3], 1) * pow(input_x[4], 1) * pow(input_x[6], 3);
        idvd_poly_feat[2866] = pow(input_x[1], 2) * pow(input_x[3], 1) * pow(input_x[5], 4);
        idvd_poly_feat[2867] = pow(input_x[1], 2) * pow(input_x[3], 1) * pow(input_x[5], 3) * pow(input_x[6], 1);
        idvd_poly_feat[2868] = pow(input_x[1], 2) * pow(input_x[3], 1) * pow(input_x[5], 2) * pow(input_x[6], 2);
        idvd_poly_feat[2869] = pow(input_x[1], 2) * pow(input_x[3], 1) * pow(input_x[5], 1) * pow(input_x[6], 3);
        idvd_poly_feat[2870] = pow(input_x[1], 2) * pow(input_x[3], 1) * pow(input_x[6], 4);
        idvd_poly_feat[2871] = pow(input_x[1], 2) * pow(input_x[4], 5);
        idvd_poly_feat[2872] = pow(input_x[1], 2) * pow(input_x[4], 4) * pow(input_x[5], 1);
        idvd_poly_feat[2873] = pow(input_x[1], 2) * pow(input_x[4], 4) * pow(input_x[6], 1);
        idvd_poly_feat[2874] = pow(input_x[1], 2) * pow(input_x[4], 3) * pow(input_x[5], 2);
        idvd_poly_feat[2875] = pow(input_x[1], 2) * pow(input_x[4], 3) * pow(input_x[5], 1) * pow(input_x[6], 1);
        idvd_poly_feat[2876] = pow(input_x[1], 2) * pow(input_x[4], 3) * pow(input_x[6], 2);
        idvd_poly_feat[2877] = pow(input_x[1], 2) * pow(input_x[4], 2) * pow(input_x[5], 3);
        idvd_poly_feat[2878] = pow(input_x[1], 2) * pow(input_x[4], 2) * pow(input_x[5], 2) * pow(input_x[6], 1);
        idvd_poly_feat[2879] = pow(input_x[1], 2) * pow(input_x[4], 2) * pow(input_x[5], 1) * pow(input_x[6], 2);
        idvd_poly_feat[2880] = pow(input_x[1], 2) * pow(input_x[4], 2) * pow(input_x[6], 3);
        idvd_poly_feat[2881] = pow(input_x[1], 2) * pow(input_x[4], 1) * pow(input_x[5], 4);
        idvd_poly_feat[2882] = pow(input_x[1], 2) * pow(input_x[4], 1) * pow(input_x[5], 3) * pow(input_x[6], 1);
        idvd_poly_feat[2883] = pow(input_x[1], 2) * pow(input_x[4], 1) * pow(input_x[5], 2) * pow(input_x[6], 2);
        idvd_poly_feat[2884] = pow(input_x[1], 2) * pow(input_x[4], 1) * pow(input_x[5], 1) * pow(input_x[6], 3);
        idvd_poly_feat[2885] = pow(input_x[1], 2) * pow(input_x[4], 1) * pow(input_x[6], 4);
        idvd_poly_feat[2886] = pow(input_x[1], 2) * pow(input_x[5], 5);
        idvd_poly_feat[2887] = pow(input_x[1], 2) * pow(input_x[5], 4) * pow(input_x[6], 1);
        idvd_poly_feat[2888] = pow(input_x[1], 2) * pow(input_x[5], 3) * pow(input_x[6], 2);
        idvd_poly_feat[2889] = pow(input_x[1], 2) * pow(input_x[5], 2) * pow(input_x[6], 3);
        idvd_poly_feat[2890] = pow(input_x[1], 2) * pow(input_x[5], 1) * pow(input_x[6], 4);
        idvd_poly_feat[2891] = pow(input_x[1], 2) * pow(input_x[6], 5);
        idvd_poly_feat[2892] = pow(input_x[1], 1) * pow(input_x[2], 6);
        idvd_poly_feat[2893] = pow(input_x[1], 1) * pow(input_x[2], 5) * pow(input_x[3], 1);
        idvd_poly_feat[2894] = pow(input_x[1], 1) * pow(input_x[2], 5) * pow(input_x[4], 1);
        idvd_poly_feat[2895] = pow(input_x[1], 1) * pow(input_x[2], 5) * pow(input_x[5], 1);
        idvd_poly_feat[2896] = pow(input_x[1], 1) * pow(input_x[2], 5) * pow(input_x[6], 1);
        idvd_poly_feat[2897] = pow(input_x[1], 1) * pow(input_x[2], 4) * pow(input_x[3], 2);
        idvd_poly_feat[2898] = pow(input_x[1], 1) * pow(input_x[2], 4) * pow(input_x[3], 1) * pow(input_x[4], 1);
        idvd_poly_feat[2899] = pow(input_x[1], 1) * pow(input_x[2], 4) * pow(input_x[3], 1) * pow(input_x[5], 1);
        idvd_poly_feat[2900] = pow(input_x[1], 1) * pow(input_x[2], 4) * pow(input_x[3], 1) * pow(input_x[6], 1);
        idvd_poly_feat[2901] = pow(input_x[1], 1) * pow(input_x[2], 4) * pow(input_x[4], 2);
        idvd_poly_feat[2902] = pow(input_x[1], 1) * pow(input_x[2], 4) * pow(input_x[4], 1) * pow(input_x[5], 1);
        idvd_poly_feat[2903] = pow(input_x[1], 1) * pow(input_x[2], 4) * pow(input_x[4], 1) * pow(input_x[6], 1);
        idvd_poly_feat[2904] = pow(input_x[1], 1) * pow(input_x[2], 4) * pow(input_x[5], 2);
        idvd_poly_feat[2905] = pow(input_x[1], 1) * pow(input_x[2], 4) * pow(input_x[5], 1) * pow(input_x[6], 1);
        idvd_poly_feat[2906] = pow(input_x[1], 1) * pow(input_x[2], 4) * pow(input_x[6], 2);
        idvd_poly_feat[2907] = pow(input_x[1], 1) * pow(input_x[2], 3) * pow(input_x[3], 3);
        idvd_poly_feat[2908] = pow(input_x[1], 1) * pow(input_x[2], 3) * pow(input_x[3], 2) * pow(input_x[4], 1);
        idvd_poly_feat[2909] = pow(input_x[1], 1) * pow(input_x[2], 3) * pow(input_x[3], 2) * pow(input_x[5], 1);
        idvd_poly_feat[2910] = pow(input_x[1], 1) * pow(input_x[2], 3) * pow(input_x[3], 2) * pow(input_x[6], 1);
        idvd_poly_feat[2911] = pow(input_x[1], 1) * pow(input_x[2], 3) * pow(input_x[3], 1) * pow(input_x[4], 2);
        idvd_poly_feat[2912] = pow(input_x[1], 1) * pow(input_x[2], 3) * pow(input_x[3], 1) * pow(input_x[4], 1) * pow(input_x[5], 1);
        idvd_poly_feat[2913] = pow(input_x[1], 1) * pow(input_x[2], 3) * pow(input_x[3], 1) * pow(input_x[4], 1) * pow(input_x[6], 1);
        idvd_poly_feat[2914] = pow(input_x[1], 1) * pow(input_x[2], 3) * pow(input_x[3], 1) * pow(input_x[5], 2);
        idvd_poly_feat[2915] = pow(input_x[1], 1) * pow(input_x[2], 3) * pow(input_x[3], 1) * pow(input_x[5], 1) * pow(input_x[6], 1);
        idvd_poly_feat[2916] = pow(input_x[1], 1) * pow(input_x[2], 3) * pow(input_x[3], 1) * pow(input_x[6], 2);
        idvd_poly_feat[2917] = pow(input_x[1], 1) * pow(input_x[2], 3) * pow(input_x[4], 3);
        idvd_poly_feat[2918] = pow(input_x[1], 1) * pow(input_x[2], 3) * pow(input_x[4], 2) * pow(input_x[5], 1);
        idvd_poly_feat[2919] = pow(input_x[1], 1) * pow(input_x[2], 3) * pow(input_x[4], 2) * pow(input_x[6], 1);
        idvd_poly_feat[2920] = pow(input_x[1], 1) * pow(input_x[2], 3) * pow(input_x[4], 1) * pow(input_x[5], 2);
        idvd_poly_feat[2921] = pow(input_x[1], 1) * pow(input_x[2], 3) * pow(input_x[4], 1) * pow(input_x[5], 1) * pow(input_x[6], 1);
        idvd_poly_feat[2922] = pow(input_x[1], 1) * pow(input_x[2], 3) * pow(input_x[4], 1) * pow(input_x[6], 2);
        idvd_poly_feat[2923] = pow(input_x[1], 1) * pow(input_x[2], 3) * pow(input_x[5], 3);
        idvd_poly_feat[2924] = pow(input_x[1], 1) * pow(input_x[2], 3) * pow(input_x[5], 2) * pow(input_x[6], 1);
        idvd_poly_feat[2925] = pow(input_x[1], 1) * pow(input_x[2], 3) * pow(input_x[5], 1) * pow(input_x[6], 2);
        idvd_poly_feat[2926] = pow(input_x[1], 1) * pow(input_x[2], 3) * pow(input_x[6], 3);
        idvd_poly_feat[2927] = pow(input_x[1], 1) * pow(input_x[2], 2) * pow(input_x[3], 4);
        idvd_poly_feat[2928] = pow(input_x[1], 1) * pow(input_x[2], 2) * pow(input_x[3], 3) * pow(input_x[4], 1);
        idvd_poly_feat[2929] = pow(input_x[1], 1) * pow(input_x[2], 2) * pow(input_x[3], 3) * pow(input_x[5], 1);
        idvd_poly_feat[2930] = pow(input_x[1], 1) * pow(input_x[2], 2) * pow(input_x[3], 3) * pow(input_x[6], 1);
        idvd_poly_feat[2931] = pow(input_x[1], 1) * pow(input_x[2], 2) * pow(input_x[3], 2) * pow(input_x[4], 2);
        idvd_poly_feat[2932] = pow(input_x[1], 1) * pow(input_x[2], 2) * pow(input_x[3], 2) * pow(input_x[4], 1) * pow(input_x[5], 1);
        idvd_poly_feat[2933] = pow(input_x[1], 1) * pow(input_x[2], 2) * pow(input_x[3], 2) * pow(input_x[4], 1) * pow(input_x[6], 1);
        idvd_poly_feat[2934] = pow(input_x[1], 1) * pow(input_x[2], 2) * pow(input_x[3], 2) * pow(input_x[5], 2);
        idvd_poly_feat[2935] = pow(input_x[1], 1) * pow(input_x[2], 2) * pow(input_x[3], 2) * pow(input_x[5], 1) * pow(input_x[6], 1);
        idvd_poly_feat[2936] = pow(input_x[1], 1) * pow(input_x[2], 2) * pow(input_x[3], 2) * pow(input_x[6], 2);
        idvd_poly_feat[2937] = pow(input_x[1], 1) * pow(input_x[2], 2) * pow(input_x[3], 1) * pow(input_x[4], 3);
        idvd_poly_feat[2938] = pow(input_x[1], 1) * pow(input_x[2], 2) * pow(input_x[3], 1) * pow(input_x[4], 2) * pow(input_x[5], 1);
        idvd_poly_feat[2939] = pow(input_x[1], 1) * pow(input_x[2], 2) * pow(input_x[3], 1) * pow(input_x[4], 2) * pow(input_x[6], 1);
        idvd_poly_feat[2940] = pow(input_x[1], 1) * pow(input_x[2], 2) * pow(input_x[3], 1) * pow(input_x[4], 1) * pow(input_x[5], 2);
        idvd_poly_feat[2941] = pow(input_x[1], 1) * pow(input_x[2], 2) * pow(input_x[3], 1) * pow(input_x[4], 1) * pow(input_x[5], 1) * pow(input_x[6], 1);
        idvd_poly_feat[2942] = pow(input_x[1], 1) * pow(input_x[2], 2) * pow(input_x[3], 1) * pow(input_x[4], 1) * pow(input_x[6], 2);
        idvd_poly_feat[2943] = pow(input_x[1], 1) * pow(input_x[2], 2) * pow(input_x[3], 1) * pow(input_x[5], 3);
        idvd_poly_feat[2944] = pow(input_x[1], 1) * pow(input_x[2], 2) * pow(input_x[3], 1) * pow(input_x[5], 2) * pow(input_x[6], 1);
        idvd_poly_feat[2945] = pow(input_x[1], 1) * pow(input_x[2], 2) * pow(input_x[3], 1) * pow(input_x[5], 1) * pow(input_x[6], 2);
        idvd_poly_feat[2946] = pow(input_x[1], 1) * pow(input_x[2], 2) * pow(input_x[3], 1) * pow(input_x[6], 3);
        idvd_poly_feat[2947] = pow(input_x[1], 1) * pow(input_x[2], 2) * pow(input_x[4], 4);
        idvd_poly_feat[2948] = pow(input_x[1], 1) * pow(input_x[2], 2) * pow(input_x[4], 3) * pow(input_x[5], 1);
        idvd_poly_feat[2949] = pow(input_x[1], 1) * pow(input_x[2], 2) * pow(input_x[4], 3) * pow(input_x[6], 1);
        idvd_poly_feat[2950] = pow(input_x[1], 1) * pow(input_x[2], 2) * pow(input_x[4], 2) * pow(input_x[5], 2);
        idvd_poly_feat[2951] = pow(input_x[1], 1) * pow(input_x[2], 2) * pow(input_x[4], 2) * pow(input_x[5], 1) * pow(input_x[6], 1);
        idvd_poly_feat[2952] = pow(input_x[1], 1) * pow(input_x[2], 2) * pow(input_x[4], 2) * pow(input_x[6], 2);
        idvd_poly_feat[2953] = pow(input_x[1], 1) * pow(input_x[2], 2) * pow(input_x[4], 1) * pow(input_x[5], 3);
        idvd_poly_feat[2954] = pow(input_x[1], 1) * pow(input_x[2], 2) * pow(input_x[4], 1) * pow(input_x[5], 2) * pow(input_x[6], 1);
        idvd_poly_feat[2955] = pow(input_x[1], 1) * pow(input_x[2], 2) * pow(input_x[4], 1) * pow(input_x[5], 1) * pow(input_x[6], 2);
        idvd_poly_feat[2956] = pow(input_x[1], 1) * pow(input_x[2], 2) * pow(input_x[4], 1) * pow(input_x[6], 3);
        idvd_poly_feat[2957] = pow(input_x[1], 1) * pow(input_x[2], 2) * pow(input_x[5], 4);
        idvd_poly_feat[2958] = pow(input_x[1], 1) * pow(input_x[2], 2) * pow(input_x[5], 3) * pow(input_x[6], 1);
        idvd_poly_feat[2959] = pow(input_x[1], 1) * pow(input_x[2], 2) * pow(input_x[5], 2) * pow(input_x[6], 2);
        idvd_poly_feat[2960] = pow(input_x[1], 1) * pow(input_x[2], 2) * pow(input_x[5], 1) * pow(input_x[6], 3);
        idvd_poly_feat[2961] = pow(input_x[1], 1) * pow(input_x[2], 2) * pow(input_x[6], 4);
        idvd_poly_feat[2962] = pow(input_x[1], 1) * pow(input_x[2], 1) * pow(input_x[3], 5);
        idvd_poly_feat[2963] = pow(input_x[1], 1) * pow(input_x[2], 1) * pow(input_x[3], 4) * pow(input_x[4], 1);
        idvd_poly_feat[2964] = pow(input_x[1], 1) * pow(input_x[2], 1) * pow(input_x[3], 4) * pow(input_x[5], 1);
        idvd_poly_feat[2965] = pow(input_x[1], 1) * pow(input_x[2], 1) * pow(input_x[3], 4) * pow(input_x[6], 1);
        idvd_poly_feat[2966] = pow(input_x[1], 1) * pow(input_x[2], 1) * pow(input_x[3], 3) * pow(input_x[4], 2);
        idvd_poly_feat[2967] = pow(input_x[1], 1) * pow(input_x[2], 1) * pow(input_x[3], 3) * pow(input_x[4], 1) * pow(input_x[5], 1);
        idvd_poly_feat[2968] = pow(input_x[1], 1) * pow(input_x[2], 1) * pow(input_x[3], 3) * pow(input_x[4], 1) * pow(input_x[6], 1);
        idvd_poly_feat[2969] = pow(input_x[1], 1) * pow(input_x[2], 1) * pow(input_x[3], 3) * pow(input_x[5], 2);
        idvd_poly_feat[2970] = pow(input_x[1], 1) * pow(input_x[2], 1) * pow(input_x[3], 3) * pow(input_x[5], 1) * pow(input_x[6], 1);
        idvd_poly_feat[2971] = pow(input_x[1], 1) * pow(input_x[2], 1) * pow(input_x[3], 3) * pow(input_x[6], 2);
        idvd_poly_feat[2972] = pow(input_x[1], 1) * pow(input_x[2], 1) * pow(input_x[3], 2) * pow(input_x[4], 3);
        idvd_poly_feat[2973] = pow(input_x[1], 1) * pow(input_x[2], 1) * pow(input_x[3], 2) * pow(input_x[4], 2) * pow(input_x[5], 1);
        idvd_poly_feat[2974] = pow(input_x[1], 1) * pow(input_x[2], 1) * pow(input_x[3], 2) * pow(input_x[4], 2) * pow(input_x[6], 1);
        idvd_poly_feat[2975] = pow(input_x[1], 1) * pow(input_x[2], 1) * pow(input_x[3], 2) * pow(input_x[4], 1) * pow(input_x[5], 2);
        idvd_poly_feat[2976] = pow(input_x[1], 1) * pow(input_x[2], 1) * pow(input_x[3], 2) * pow(input_x[4], 1) * pow(input_x[5], 1) * pow(input_x[6], 1);
        idvd_poly_feat[2977] = pow(input_x[1], 1) * pow(input_x[2], 1) * pow(input_x[3], 2) * pow(input_x[4], 1) * pow(input_x[6], 2);
        idvd_poly_feat[2978] = pow(input_x[1], 1) * pow(input_x[2], 1) * pow(input_x[3], 2) * pow(input_x[5], 3);
        idvd_poly_feat[2979] = pow(input_x[1], 1) * pow(input_x[2], 1) * pow(input_x[3], 2) * pow(input_x[5], 2) * pow(input_x[6], 1);
        idvd_poly_feat[2980] = pow(input_x[1], 1) * pow(input_x[2], 1) * pow(input_x[3], 2) * pow(input_x[5], 1) * pow(input_x[6], 2);
        idvd_poly_feat[2981] = pow(input_x[1], 1) * pow(input_x[2], 1) * pow(input_x[3], 2) * pow(input_x[6], 3);
        idvd_poly_feat[2982] = pow(input_x[1], 1) * pow(input_x[2], 1) * pow(input_x[3], 1) * pow(input_x[4], 4);
        idvd_poly_feat[2983] = pow(input_x[1], 1) * pow(input_x[2], 1) * pow(input_x[3], 1) * pow(input_x[4], 3) * pow(input_x[5], 1);
        idvd_poly_feat[2984] = pow(input_x[1], 1) * pow(input_x[2], 1) * pow(input_x[3], 1) * pow(input_x[4], 3) * pow(input_x[6], 1);
        idvd_poly_feat[2985] = pow(input_x[1], 1) * pow(input_x[2], 1) * pow(input_x[3], 1) * pow(input_x[4], 2) * pow(input_x[5], 2);
        idvd_poly_feat[2986] = pow(input_x[1], 1) * pow(input_x[2], 1) * pow(input_x[3], 1) * pow(input_x[4], 2) * pow(input_x[5], 1) * pow(input_x[6], 1);
        idvd_poly_feat[2987] = pow(input_x[1], 1) * pow(input_x[2], 1) * pow(input_x[3], 1) * pow(input_x[4], 2) * pow(input_x[6], 2);
        idvd_poly_feat[2988] = pow(input_x[1], 1) * pow(input_x[2], 1) * pow(input_x[3], 1) * pow(input_x[4], 1) * pow(input_x[5], 3);
        idvd_poly_feat[2989] = pow(input_x[1], 1) * pow(input_x[2], 1) * pow(input_x[3], 1) * pow(input_x[4], 1) * pow(input_x[5], 2) * pow(input_x[6], 1);
        idvd_poly_feat[2990] = pow(input_x[1], 1) * pow(input_x[2], 1) * pow(input_x[3], 1) * pow(input_x[4], 1) * pow(input_x[5], 1) * pow(input_x[6], 2);
        idvd_poly_feat[2991] = pow(input_x[1], 1) * pow(input_x[2], 1) * pow(input_x[3], 1) * pow(input_x[4], 1) * pow(input_x[6], 3);
        idvd_poly_feat[2992] = pow(input_x[1], 1) * pow(input_x[2], 1) * pow(input_x[3], 1) * pow(input_x[5], 4);
        idvd_poly_feat[2993] = pow(input_x[1], 1) * pow(input_x[2], 1) * pow(input_x[3], 1) * pow(input_x[5], 3) * pow(input_x[6], 1);
        idvd_poly_feat[2994] = pow(input_x[1], 1) * pow(input_x[2], 1) * pow(input_x[3], 1) * pow(input_x[5], 2) * pow(input_x[6], 2);
        idvd_poly_feat[2995] = pow(input_x[1], 1) * pow(input_x[2], 1) * pow(input_x[3], 1) * pow(input_x[5], 1) * pow(input_x[6], 3);
        idvd_poly_feat[2996] = pow(input_x[1], 1) * pow(input_x[2], 1) * pow(input_x[3], 1) * pow(input_x[6], 4);
        idvd_poly_feat[2997] = pow(input_x[1], 1) * pow(input_x[2], 1) * pow(input_x[4], 5);
        idvd_poly_feat[2998] = pow(input_x[1], 1) * pow(input_x[2], 1) * pow(input_x[4], 4) * pow(input_x[5], 1);
        idvd_poly_feat[2999] = pow(input_x[1], 1) * pow(input_x[2], 1) * pow(input_x[4], 4) * pow(input_x[6], 1);
        idvd_poly_feat[3000] = pow(input_x[1], 1) * pow(input_x[2], 1) * pow(input_x[4], 3) * pow(input_x[5], 2);
        idvd_poly_feat[3001] = pow(input_x[1], 1) * pow(input_x[2], 1) * pow(input_x[4], 3) * pow(input_x[5], 1) * pow(input_x[6], 1);
        idvd_poly_feat[3002] = pow(input_x[1], 1) * pow(input_x[2], 1) * pow(input_x[4], 3) * pow(input_x[6], 2);
        idvd_poly_feat[3003] = pow(input_x[1], 1) * pow(input_x[2], 1) * pow(input_x[4], 2) * pow(input_x[5], 3);
        idvd_poly_feat[3004] = pow(input_x[1], 1) * pow(input_x[2], 1) * pow(input_x[4], 2) * pow(input_x[5], 2) * pow(input_x[6], 1);
        idvd_poly_feat[3005] = pow(input_x[1], 1) * pow(input_x[2], 1) * pow(input_x[4], 2) * pow(input_x[5], 1) * pow(input_x[6], 2);
        idvd_poly_feat[3006] = pow(input_x[1], 1) * pow(input_x[2], 1) * pow(input_x[4], 2) * pow(input_x[6], 3);
        idvd_poly_feat[3007] = pow(input_x[1], 1) * pow(input_x[2], 1) * pow(input_x[4], 1) * pow(input_x[5], 4);
        idvd_poly_feat[3008] = pow(input_x[1], 1) * pow(input_x[2], 1) * pow(input_x[4], 1) * pow(input_x[5], 3) * pow(input_x[6], 1);
        idvd_poly_feat[3009] = pow(input_x[1], 1) * pow(input_x[2], 1) * pow(input_x[4], 1) * pow(input_x[5], 2) * pow(input_x[6], 2);
        idvd_poly_feat[3010] = pow(input_x[1], 1) * pow(input_x[2], 1) * pow(input_x[4], 1) * pow(input_x[5], 1) * pow(input_x[6], 3);
        idvd_poly_feat[3011] = pow(input_x[1], 1) * pow(input_x[2], 1) * pow(input_x[4], 1) * pow(input_x[6], 4);
        idvd_poly_feat[3012] = pow(input_x[1], 1) * pow(input_x[2], 1) * pow(input_x[5], 5);
        idvd_poly_feat[3013] = pow(input_x[1], 1) * pow(input_x[2], 1) * pow(input_x[5], 4) * pow(input_x[6], 1);
        idvd_poly_feat[3014] = pow(input_x[1], 1) * pow(input_x[2], 1) * pow(input_x[5], 3) * pow(input_x[6], 2);
        idvd_poly_feat[3015] = pow(input_x[1], 1) * pow(input_x[2], 1) * pow(input_x[5], 2) * pow(input_x[6], 3);
        idvd_poly_feat[3016] = pow(input_x[1], 1) * pow(input_x[2], 1) * pow(input_x[5], 1) * pow(input_x[6], 4);
        idvd_poly_feat[3017] = pow(input_x[1], 1) * pow(input_x[2], 1) * pow(input_x[6], 5);
        idvd_poly_feat[3018] = pow(input_x[1], 1) * pow(input_x[3], 6);
        idvd_poly_feat[3019] = pow(input_x[1], 1) * pow(input_x[3], 5) * pow(input_x[4], 1);
        idvd_poly_feat[3020] = pow(input_x[1], 1) * pow(input_x[3], 5) * pow(input_x[5], 1);
        idvd_poly_feat[3021] = pow(input_x[1], 1) * pow(input_x[3], 5) * pow(input_x[6], 1);
        idvd_poly_feat[3022] = pow(input_x[1], 1) * pow(input_x[3], 4) * pow(input_x[4], 2);
        idvd_poly_feat[3023] = pow(input_x[1], 1) * pow(input_x[3], 4) * pow(input_x[4], 1) * pow(input_x[5], 1);
        idvd_poly_feat[3024] = pow(input_x[1], 1) * pow(input_x[3], 4) * pow(input_x[4], 1) * pow(input_x[6], 1);
        idvd_poly_feat[3025] = pow(input_x[1], 1) * pow(input_x[3], 4) * pow(input_x[5], 2);
        idvd_poly_feat[3026] = pow(input_x[1], 1) * pow(input_x[3], 4) * pow(input_x[5], 1) * pow(input_x[6], 1);
        idvd_poly_feat[3027] = pow(input_x[1], 1) * pow(input_x[3], 4) * pow(input_x[6], 2);
        idvd_poly_feat[3028] = pow(input_x[1], 1) * pow(input_x[3], 3) * pow(input_x[4], 3);
        idvd_poly_feat[3029] = pow(input_x[1], 1) * pow(input_x[3], 3) * pow(input_x[4], 2) * pow(input_x[5], 1);
        idvd_poly_feat[3030] = pow(input_x[1], 1) * pow(input_x[3], 3) * pow(input_x[4], 2) * pow(input_x[6], 1);
        idvd_poly_feat[3031] = pow(input_x[1], 1) * pow(input_x[3], 3) * pow(input_x[4], 1) * pow(input_x[5], 2);
        idvd_poly_feat[3032] = pow(input_x[1], 1) * pow(input_x[3], 3) * pow(input_x[4], 1) * pow(input_x[5], 1) * pow(input_x[6], 1);
        idvd_poly_feat[3033] = pow(input_x[1], 1) * pow(input_x[3], 3) * pow(input_x[4], 1) * pow(input_x[6], 2);
        idvd_poly_feat[3034] = pow(input_x[1], 1) * pow(input_x[3], 3) * pow(input_x[5], 3);
        idvd_poly_feat[3035] = pow(input_x[1], 1) * pow(input_x[3], 3) * pow(input_x[5], 2) * pow(input_x[6], 1);
        idvd_poly_feat[3036] = pow(input_x[1], 1) * pow(input_x[3], 3) * pow(input_x[5], 1) * pow(input_x[6], 2);
        idvd_poly_feat[3037] = pow(input_x[1], 1) * pow(input_x[3], 3) * pow(input_x[6], 3);
        idvd_poly_feat[3038] = pow(input_x[1], 1) * pow(input_x[3], 2) * pow(input_x[4], 4);
        idvd_poly_feat[3039] = pow(input_x[1], 1) * pow(input_x[3], 2) * pow(input_x[4], 3) * pow(input_x[5], 1);
        idvd_poly_feat[3040] = pow(input_x[1], 1) * pow(input_x[3], 2) * pow(input_x[4], 3) * pow(input_x[6], 1);
        idvd_poly_feat[3041] = pow(input_x[1], 1) * pow(input_x[3], 2) * pow(input_x[4], 2) * pow(input_x[5], 2);
        idvd_poly_feat[3042] = pow(input_x[1], 1) * pow(input_x[3], 2) * pow(input_x[4], 2) * pow(input_x[5], 1) * pow(input_x[6], 1);
        idvd_poly_feat[3043] = pow(input_x[1], 1) * pow(input_x[3], 2) * pow(input_x[4], 2) * pow(input_x[6], 2);
        idvd_poly_feat[3044] = pow(input_x[1], 1) * pow(input_x[3], 2) * pow(input_x[4], 1) * pow(input_x[5], 3);
        idvd_poly_feat[3045] = pow(input_x[1], 1) * pow(input_x[3], 2) * pow(input_x[4], 1) * pow(input_x[5], 2) * pow(input_x[6], 1);
        idvd_poly_feat[3046] = pow(input_x[1], 1) * pow(input_x[3], 2) * pow(input_x[4], 1) * pow(input_x[5], 1) * pow(input_x[6], 2);
        idvd_poly_feat[3047] = pow(input_x[1], 1) * pow(input_x[3], 2) * pow(input_x[4], 1) * pow(input_x[6], 3);
        idvd_poly_feat[3048] = pow(input_x[1], 1) * pow(input_x[3], 2) * pow(input_x[5], 4);
        idvd_poly_feat[3049] = pow(input_x[1], 1) * pow(input_x[3], 2) * pow(input_x[5], 3) * pow(input_x[6], 1);
        idvd_poly_feat[3050] = pow(input_x[1], 1) * pow(input_x[3], 2) * pow(input_x[5], 2) * pow(input_x[6], 2);
        idvd_poly_feat[3051] = pow(input_x[1], 1) * pow(input_x[3], 2) * pow(input_x[5], 1) * pow(input_x[6], 3);
        idvd_poly_feat[3052] = pow(input_x[1], 1) * pow(input_x[3], 2) * pow(input_x[6], 4);
        idvd_poly_feat[3053] = pow(input_x[1], 1) * pow(input_x[3], 1) * pow(input_x[4], 5);
        idvd_poly_feat[3054] = pow(input_x[1], 1) * pow(input_x[3], 1) * pow(input_x[4], 4) * pow(input_x[5], 1);
        idvd_poly_feat[3055] = pow(input_x[1], 1) * pow(input_x[3], 1) * pow(input_x[4], 4) * pow(input_x[6], 1);
        idvd_poly_feat[3056] = pow(input_x[1], 1) * pow(input_x[3], 1) * pow(input_x[4], 3) * pow(input_x[5], 2);
        idvd_poly_feat[3057] = pow(input_x[1], 1) * pow(input_x[3], 1) * pow(input_x[4], 3) * pow(input_x[5], 1) * pow(input_x[6], 1);
        idvd_poly_feat[3058] = pow(input_x[1], 1) * pow(input_x[3], 1) * pow(input_x[4], 3) * pow(input_x[6], 2);
        idvd_poly_feat[3059] = pow(input_x[1], 1) * pow(input_x[3], 1) * pow(input_x[4], 2) * pow(input_x[5], 3);
        idvd_poly_feat[3060] = pow(input_x[1], 1) * pow(input_x[3], 1) * pow(input_x[4], 2) * pow(input_x[5], 2) * pow(input_x[6], 1);
        idvd_poly_feat[3061] = pow(input_x[1], 1) * pow(input_x[3], 1) * pow(input_x[4], 2) * pow(input_x[5], 1) * pow(input_x[6], 2);
        idvd_poly_feat[3062] = pow(input_x[1], 1) * pow(input_x[3], 1) * pow(input_x[4], 2) * pow(input_x[6], 3);
        idvd_poly_feat[3063] = pow(input_x[1], 1) * pow(input_x[3], 1) * pow(input_x[4], 1) * pow(input_x[5], 4);
        idvd_poly_feat[3064] = pow(input_x[1], 1) * pow(input_x[3], 1) * pow(input_x[4], 1) * pow(input_x[5], 3) * pow(input_x[6], 1);
        idvd_poly_feat[3065] = pow(input_x[1], 1) * pow(input_x[3], 1) * pow(input_x[4], 1) * pow(input_x[5], 2) * pow(input_x[6], 2);
        idvd_poly_feat[3066] = pow(input_x[1], 1) * pow(input_x[3], 1) * pow(input_x[4], 1) * pow(input_x[5], 1) * pow(input_x[6], 3);
        idvd_poly_feat[3067] = pow(input_x[1], 1) * pow(input_x[3], 1) * pow(input_x[4], 1) * pow(input_x[6], 4);
        idvd_poly_feat[3068] = pow(input_x[1], 1) * pow(input_x[3], 1) * pow(input_x[5], 5);
        idvd_poly_feat[3069] = pow(input_x[1], 1) * pow(input_x[3], 1) * pow(input_x[5], 4) * pow(input_x[6], 1);
        idvd_poly_feat[3070] = pow(input_x[1], 1) * pow(input_x[3], 1) * pow(input_x[5], 3) * pow(input_x[6], 2);
        idvd_poly_feat[3071] = pow(input_x[1], 1) * pow(input_x[3], 1) * pow(input_x[5], 2) * pow(input_x[6], 3);
        idvd_poly_feat[3072] = pow(input_x[1], 1) * pow(input_x[3], 1) * pow(input_x[5], 1) * pow(input_x[6], 4);
        idvd_poly_feat[3073] = pow(input_x[1], 1) * pow(input_x[3], 1) * pow(input_x[6], 5);
        idvd_poly_feat[3074] = pow(input_x[1], 1) * pow(input_x[4], 6);
        idvd_poly_feat[3075] = pow(input_x[1], 1) * pow(input_x[4], 5) * pow(input_x[5], 1);
        idvd_poly_feat[3076] = pow(input_x[1], 1) * pow(input_x[4], 5) * pow(input_x[6], 1);
        idvd_poly_feat[3077] = pow(input_x[1], 1) * pow(input_x[4], 4) * pow(input_x[5], 2);
        idvd_poly_feat[3078] = pow(input_x[1], 1) * pow(input_x[4], 4) * pow(input_x[5], 1) * pow(input_x[6], 1);
        idvd_poly_feat[3079] = pow(input_x[1], 1) * pow(input_x[4], 4) * pow(input_x[6], 2);
        idvd_poly_feat[3080] = pow(input_x[1], 1) * pow(input_x[4], 3) * pow(input_x[5], 3);
        idvd_poly_feat[3081] = pow(input_x[1], 1) * pow(input_x[4], 3) * pow(input_x[5], 2) * pow(input_x[6], 1);
        idvd_poly_feat[3082] = pow(input_x[1], 1) * pow(input_x[4], 3) * pow(input_x[5], 1) * pow(input_x[6], 2);
        idvd_poly_feat[3083] = pow(input_x[1], 1) * pow(input_x[4], 3) * pow(input_x[6], 3);
        idvd_poly_feat[3084] = pow(input_x[1], 1) * pow(input_x[4], 2) * pow(input_x[5], 4);
        idvd_poly_feat[3085] = pow(input_x[1], 1) * pow(input_x[4], 2) * pow(input_x[5], 3) * pow(input_x[6], 1);
        idvd_poly_feat[3086] = pow(input_x[1], 1) * pow(input_x[4], 2) * pow(input_x[5], 2) * pow(input_x[6], 2);
        idvd_poly_feat[3087] = pow(input_x[1], 1) * pow(input_x[4], 2) * pow(input_x[5], 1) * pow(input_x[6], 3);
        idvd_poly_feat[3088] = pow(input_x[1], 1) * pow(input_x[4], 2) * pow(input_x[6], 4);
        idvd_poly_feat[3089] = pow(input_x[1], 1) * pow(input_x[4], 1) * pow(input_x[5], 5);
        idvd_poly_feat[3090] = pow(input_x[1], 1) * pow(input_x[4], 1) * pow(input_x[5], 4) * pow(input_x[6], 1);
        idvd_poly_feat[3091] = pow(input_x[1], 1) * pow(input_x[4], 1) * pow(input_x[5], 3) * pow(input_x[6], 2);
        idvd_poly_feat[3092] = pow(input_x[1], 1) * pow(input_x[4], 1) * pow(input_x[5], 2) * pow(input_x[6], 3);
        idvd_poly_feat[3093] = pow(input_x[1], 1) * pow(input_x[4], 1) * pow(input_x[5], 1) * pow(input_x[6], 4);
        idvd_poly_feat[3094] = pow(input_x[1], 1) * pow(input_x[4], 1) * pow(input_x[6], 5);
        idvd_poly_feat[3095] = pow(input_x[1], 1) * pow(input_x[5], 6);
        idvd_poly_feat[3096] = pow(input_x[1], 1) * pow(input_x[5], 5) * pow(input_x[6], 1);
        idvd_poly_feat[3097] = pow(input_x[1], 1) * pow(input_x[5], 4) * pow(input_x[6], 2);
        idvd_poly_feat[3098] = pow(input_x[1], 1) * pow(input_x[5], 3) * pow(input_x[6], 3);
        idvd_poly_feat[3099] = pow(input_x[1], 1) * pow(input_x[5], 2) * pow(input_x[6], 4);
        idvd_poly_feat[3100] = pow(input_x[1], 1) * pow(input_x[5], 1) * pow(input_x[6], 5);
        idvd_poly_feat[3101] = pow(input_x[1], 1) * pow(input_x[6], 6);
        idvd_poly_feat[3102] = pow(input_x[2], 7);
        idvd_poly_feat[3103] = pow(input_x[2], 6) * pow(input_x[3], 1);
        idvd_poly_feat[3104] = pow(input_x[2], 6) * pow(input_x[4], 1);
        idvd_poly_feat[3105] = pow(input_x[2], 6) * pow(input_x[5], 1);
        idvd_poly_feat[3106] = pow(input_x[2], 6) * pow(input_x[6], 1);
        idvd_poly_feat[3107] = pow(input_x[2], 5) * pow(input_x[3], 2);
        idvd_poly_feat[3108] = pow(input_x[2], 5) * pow(input_x[3], 1) * pow(input_x[4], 1);
        idvd_poly_feat[3109] = pow(input_x[2], 5) * pow(input_x[3], 1) * pow(input_x[5], 1);
        idvd_poly_feat[3110] = pow(input_x[2], 5) * pow(input_x[3], 1) * pow(input_x[6], 1);
        idvd_poly_feat[3111] = pow(input_x[2], 5) * pow(input_x[4], 2);
        idvd_poly_feat[3112] = pow(input_x[2], 5) * pow(input_x[4], 1) * pow(input_x[5], 1);
        idvd_poly_feat[3113] = pow(input_x[2], 5) * pow(input_x[4], 1) * pow(input_x[6], 1);
        idvd_poly_feat[3114] = pow(input_x[2], 5) * pow(input_x[5], 2);
        idvd_poly_feat[3115] = pow(input_x[2], 5) * pow(input_x[5], 1) * pow(input_x[6], 1);
        idvd_poly_feat[3116] = pow(input_x[2], 5) * pow(input_x[6], 2);
        idvd_poly_feat[3117] = pow(input_x[2], 4) * pow(input_x[3], 3);
        idvd_poly_feat[3118] = pow(input_x[2], 4) * pow(input_x[3], 2) * pow(input_x[4], 1);
        idvd_poly_feat[3119] = pow(input_x[2], 4) * pow(input_x[3], 2) * pow(input_x[5], 1);
        idvd_poly_feat[3120] = pow(input_x[2], 4) * pow(input_x[3], 2) * pow(input_x[6], 1);
        idvd_poly_feat[3121] = pow(input_x[2], 4) * pow(input_x[3], 1) * pow(input_x[4], 2);
        idvd_poly_feat[3122] = pow(input_x[2], 4) * pow(input_x[3], 1) * pow(input_x[4], 1) * pow(input_x[5], 1);
        idvd_poly_feat[3123] = pow(input_x[2], 4) * pow(input_x[3], 1) * pow(input_x[4], 1) * pow(input_x[6], 1);
        idvd_poly_feat[3124] = pow(input_x[2], 4) * pow(input_x[3], 1) * pow(input_x[5], 2);
        idvd_poly_feat[3125] = pow(input_x[2], 4) * pow(input_x[3], 1) * pow(input_x[5], 1) * pow(input_x[6], 1);
        idvd_poly_feat[3126] = pow(input_x[2], 4) * pow(input_x[3], 1) * pow(input_x[6], 2);
        idvd_poly_feat[3127] = pow(input_x[2], 4) * pow(input_x[4], 3);
        idvd_poly_feat[3128] = pow(input_x[2], 4) * pow(input_x[4], 2) * pow(input_x[5], 1);
        idvd_poly_feat[3129] = pow(input_x[2], 4) * pow(input_x[4], 2) * pow(input_x[6], 1);
        idvd_poly_feat[3130] = pow(input_x[2], 4) * pow(input_x[4], 1) * pow(input_x[5], 2);
        idvd_poly_feat[3131] = pow(input_x[2], 4) * pow(input_x[4], 1) * pow(input_x[5], 1) * pow(input_x[6], 1);
        idvd_poly_feat[3132] = pow(input_x[2], 4) * pow(input_x[4], 1) * pow(input_x[6], 2);
        idvd_poly_feat[3133] = pow(input_x[2], 4) * pow(input_x[5], 3);
        idvd_poly_feat[3134] = pow(input_x[2], 4) * pow(input_x[5], 2) * pow(input_x[6], 1);
        idvd_poly_feat[3135] = pow(input_x[2], 4) * pow(input_x[5], 1) * pow(input_x[6], 2);
        idvd_poly_feat[3136] = pow(input_x[2], 4) * pow(input_x[6], 3);
        idvd_poly_feat[3137] = pow(input_x[2], 3) * pow(input_x[3], 4);
        idvd_poly_feat[3138] = pow(input_x[2], 3) * pow(input_x[3], 3) * pow(input_x[4], 1);
        idvd_poly_feat[3139] = pow(input_x[2], 3) * pow(input_x[3], 3) * pow(input_x[5], 1);
        idvd_poly_feat[3140] = pow(input_x[2], 3) * pow(input_x[3], 3) * pow(input_x[6], 1);
        idvd_poly_feat[3141] = pow(input_x[2], 3) * pow(input_x[3], 2) * pow(input_x[4], 2);
        idvd_poly_feat[3142] = pow(input_x[2], 3) * pow(input_x[3], 2) * pow(input_x[4], 1) * pow(input_x[5], 1);
        idvd_poly_feat[3143] = pow(input_x[2], 3) * pow(input_x[3], 2) * pow(input_x[4], 1) * pow(input_x[6], 1);
        idvd_poly_feat[3144] = pow(input_x[2], 3) * pow(input_x[3], 2) * pow(input_x[5], 2);
        idvd_poly_feat[3145] = pow(input_x[2], 3) * pow(input_x[3], 2) * pow(input_x[5], 1) * pow(input_x[6], 1);
        idvd_poly_feat[3146] = pow(input_x[2], 3) * pow(input_x[3], 2) * pow(input_x[6], 2);
        idvd_poly_feat[3147] = pow(input_x[2], 3) * pow(input_x[3], 1) * pow(input_x[4], 3);
        idvd_poly_feat[3148] = pow(input_x[2], 3) * pow(input_x[3], 1) * pow(input_x[4], 2) * pow(input_x[5], 1);
        idvd_poly_feat[3149] = pow(input_x[2], 3) * pow(input_x[3], 1) * pow(input_x[4], 2) * pow(input_x[6], 1);
        idvd_poly_feat[3150] = pow(input_x[2], 3) * pow(input_x[3], 1) * pow(input_x[4], 1) * pow(input_x[5], 2);
        idvd_poly_feat[3151] = pow(input_x[2], 3) * pow(input_x[3], 1) * pow(input_x[4], 1) * pow(input_x[5], 1) * pow(input_x[6], 1);
        idvd_poly_feat[3152] = pow(input_x[2], 3) * pow(input_x[3], 1) * pow(input_x[4], 1) * pow(input_x[6], 2);
        idvd_poly_feat[3153] = pow(input_x[2], 3) * pow(input_x[3], 1) * pow(input_x[5], 3);
        idvd_poly_feat[3154] = pow(input_x[2], 3) * pow(input_x[3], 1) * pow(input_x[5], 2) * pow(input_x[6], 1);
        idvd_poly_feat[3155] = pow(input_x[2], 3) * pow(input_x[3], 1) * pow(input_x[5], 1) * pow(input_x[6], 2);
        idvd_poly_feat[3156] = pow(input_x[2], 3) * pow(input_x[3], 1) * pow(input_x[6], 3);
        idvd_poly_feat[3157] = pow(input_x[2], 3) * pow(input_x[4], 4);
        idvd_poly_feat[3158] = pow(input_x[2], 3) * pow(input_x[4], 3) * pow(input_x[5], 1);
        idvd_poly_feat[3159] = pow(input_x[2], 3) * pow(input_x[4], 3) * pow(input_x[6], 1);
        idvd_poly_feat[3160] = pow(input_x[2], 3) * pow(input_x[4], 2) * pow(input_x[5], 2);
        idvd_poly_feat[3161] = pow(input_x[2], 3) * pow(input_x[4], 2) * pow(input_x[5], 1) * pow(input_x[6], 1);
        idvd_poly_feat[3162] = pow(input_x[2], 3) * pow(input_x[4], 2) * pow(input_x[6], 2);
        idvd_poly_feat[3163] = pow(input_x[2], 3) * pow(input_x[4], 1) * pow(input_x[5], 3);
        idvd_poly_feat[3164] = pow(input_x[2], 3) * pow(input_x[4], 1) * pow(input_x[5], 2) * pow(input_x[6], 1);
        idvd_poly_feat[3165] = pow(input_x[2], 3) * pow(input_x[4], 1) * pow(input_x[5], 1) * pow(input_x[6], 2);
        idvd_poly_feat[3166] = pow(input_x[2], 3) * pow(input_x[4], 1) * pow(input_x[6], 3);
        idvd_poly_feat[3167] = pow(input_x[2], 3) * pow(input_x[5], 4);
        idvd_poly_feat[3168] = pow(input_x[2], 3) * pow(input_x[5], 3) * pow(input_x[6], 1);
        idvd_poly_feat[3169] = pow(input_x[2], 3) * pow(input_x[5], 2) * pow(input_x[6], 2);
        idvd_poly_feat[3170] = pow(input_x[2], 3) * pow(input_x[5], 1) * pow(input_x[6], 3);
        idvd_poly_feat[3171] = pow(input_x[2], 3) * pow(input_x[6], 4);
        idvd_poly_feat[3172] = pow(input_x[2], 2) * pow(input_x[3], 5);
        idvd_poly_feat[3173] = pow(input_x[2], 2) * pow(input_x[3], 4) * pow(input_x[4], 1);
        idvd_poly_feat[3174] = pow(input_x[2], 2) * pow(input_x[3], 4) * pow(input_x[5], 1);
        idvd_poly_feat[3175] = pow(input_x[2], 2) * pow(input_x[3], 4) * pow(input_x[6], 1);
        idvd_poly_feat[3176] = pow(input_x[2], 2) * pow(input_x[3], 3) * pow(input_x[4], 2);
        idvd_poly_feat[3177] = pow(input_x[2], 2) * pow(input_x[3], 3) * pow(input_x[4], 1) * pow(input_x[5], 1);
        idvd_poly_feat[3178] = pow(input_x[2], 2) * pow(input_x[3], 3) * pow(input_x[4], 1) * pow(input_x[6], 1);
        idvd_poly_feat[3179] = pow(input_x[2], 2) * pow(input_x[3], 3) * pow(input_x[5], 2);
        idvd_poly_feat[3180] = pow(input_x[2], 2) * pow(input_x[3], 3) * pow(input_x[5], 1) * pow(input_x[6], 1);
        idvd_poly_feat[3181] = pow(input_x[2], 2) * pow(input_x[3], 3) * pow(input_x[6], 2);
        idvd_poly_feat[3182] = pow(input_x[2], 2) * pow(input_x[3], 2) * pow(input_x[4], 3);
        idvd_poly_feat[3183] = pow(input_x[2], 2) * pow(input_x[3], 2) * pow(input_x[4], 2) * pow(input_x[5], 1);
        idvd_poly_feat[3184] = pow(input_x[2], 2) * pow(input_x[3], 2) * pow(input_x[4], 2) * pow(input_x[6], 1);
        idvd_poly_feat[3185] = pow(input_x[2], 2) * pow(input_x[3], 2) * pow(input_x[4], 1) * pow(input_x[5], 2);
        idvd_poly_feat[3186] = pow(input_x[2], 2) * pow(input_x[3], 2) * pow(input_x[4], 1) * pow(input_x[5], 1) * pow(input_x[6], 1);
        idvd_poly_feat[3187] = pow(input_x[2], 2) * pow(input_x[3], 2) * pow(input_x[4], 1) * pow(input_x[6], 2);
        idvd_poly_feat[3188] = pow(input_x[2], 2) * pow(input_x[3], 2) * pow(input_x[5], 3);
        idvd_poly_feat[3189] = pow(input_x[2], 2) * pow(input_x[3], 2) * pow(input_x[5], 2) * pow(input_x[6], 1);
        idvd_poly_feat[3190] = pow(input_x[2], 2) * pow(input_x[3], 2) * pow(input_x[5], 1) * pow(input_x[6], 2);
        idvd_poly_feat[3191] = pow(input_x[2], 2) * pow(input_x[3], 2) * pow(input_x[6], 3);
        idvd_poly_feat[3192] = pow(input_x[2], 2) * pow(input_x[3], 1) * pow(input_x[4], 4);
        idvd_poly_feat[3193] = pow(input_x[2], 2) * pow(input_x[3], 1) * pow(input_x[4], 3) * pow(input_x[5], 1);
        idvd_poly_feat[3194] = pow(input_x[2], 2) * pow(input_x[3], 1) * pow(input_x[4], 3) * pow(input_x[6], 1);
        idvd_poly_feat[3195] = pow(input_x[2], 2) * pow(input_x[3], 1) * pow(input_x[4], 2) * pow(input_x[5], 2);
        idvd_poly_feat[3196] = pow(input_x[2], 2) * pow(input_x[3], 1) * pow(input_x[4], 2) * pow(input_x[5], 1) * pow(input_x[6], 1);
        idvd_poly_feat[3197] = pow(input_x[2], 2) * pow(input_x[3], 1) * pow(input_x[4], 2) * pow(input_x[6], 2);
        idvd_poly_feat[3198] = pow(input_x[2], 2) * pow(input_x[3], 1) * pow(input_x[4], 1) * pow(input_x[5], 3);
        idvd_poly_feat[3199] = pow(input_x[2], 2) * pow(input_x[3], 1) * pow(input_x[4], 1) * pow(input_x[5], 2) * pow(input_x[6], 1);
        idvd_poly_feat[3200] = pow(input_x[2], 2) * pow(input_x[3], 1) * pow(input_x[4], 1) * pow(input_x[5], 1) * pow(input_x[6], 2);
        idvd_poly_feat[3201] = pow(input_x[2], 2) * pow(input_x[3], 1) * pow(input_x[4], 1) * pow(input_x[6], 3);
        idvd_poly_feat[3202] = pow(input_x[2], 2) * pow(input_x[3], 1) * pow(input_x[5], 4);
        idvd_poly_feat[3203] = pow(input_x[2], 2) * pow(input_x[3], 1) * pow(input_x[5], 3) * pow(input_x[6], 1);
        idvd_poly_feat[3204] = pow(input_x[2], 2) * pow(input_x[3], 1) * pow(input_x[5], 2) * pow(input_x[6], 2);
        idvd_poly_feat[3205] = pow(input_x[2], 2) * pow(input_x[3], 1) * pow(input_x[5], 1) * pow(input_x[6], 3);
        idvd_poly_feat[3206] = pow(input_x[2], 2) * pow(input_x[3], 1) * pow(input_x[6], 4);
        idvd_poly_feat[3207] = pow(input_x[2], 2) * pow(input_x[4], 5);
        idvd_poly_feat[3208] = pow(input_x[2], 2) * pow(input_x[4], 4) * pow(input_x[5], 1);
        idvd_poly_feat[3209] = pow(input_x[2], 2) * pow(input_x[4], 4) * pow(input_x[6], 1);
        idvd_poly_feat[3210] = pow(input_x[2], 2) * pow(input_x[4], 3) * pow(input_x[5], 2);
        idvd_poly_feat[3211] = pow(input_x[2], 2) * pow(input_x[4], 3) * pow(input_x[5], 1) * pow(input_x[6], 1);
        idvd_poly_feat[3212] = pow(input_x[2], 2) * pow(input_x[4], 3) * pow(input_x[6], 2);
        idvd_poly_feat[3213] = pow(input_x[2], 2) * pow(input_x[4], 2) * pow(input_x[5], 3);
        idvd_poly_feat[3214] = pow(input_x[2], 2) * pow(input_x[4], 2) * pow(input_x[5], 2) * pow(input_x[6], 1);
        idvd_poly_feat[3215] = pow(input_x[2], 2) * pow(input_x[4], 2) * pow(input_x[5], 1) * pow(input_x[6], 2);
        idvd_poly_feat[3216] = pow(input_x[2], 2) * pow(input_x[4], 2) * pow(input_x[6], 3);
        idvd_poly_feat[3217] = pow(input_x[2], 2) * pow(input_x[4], 1) * pow(input_x[5], 4);
        idvd_poly_feat[3218] = pow(input_x[2], 2) * pow(input_x[4], 1) * pow(input_x[5], 3) * pow(input_x[6], 1);
        idvd_poly_feat[3219] = pow(input_x[2], 2) * pow(input_x[4], 1) * pow(input_x[5], 2) * pow(input_x[6], 2);
        idvd_poly_feat[3220] = pow(input_x[2], 2) * pow(input_x[4], 1) * pow(input_x[5], 1) * pow(input_x[6], 3);
        idvd_poly_feat[3221] = pow(input_x[2], 2) * pow(input_x[4], 1) * pow(input_x[6], 4);
        idvd_poly_feat[3222] = pow(input_x[2], 2) * pow(input_x[5], 5);
        idvd_poly_feat[3223] = pow(input_x[2], 2) * pow(input_x[5], 4) * pow(input_x[6], 1);
        idvd_poly_feat[3224] = pow(input_x[2], 2) * pow(input_x[5], 3) * pow(input_x[6], 2);
        idvd_poly_feat[3225] = pow(input_x[2], 2) * pow(input_x[5], 2) * pow(input_x[6], 3);
        idvd_poly_feat[3226] = pow(input_x[2], 2) * pow(input_x[5], 1) * pow(input_x[6], 4);
        idvd_poly_feat[3227] = pow(input_x[2], 2) * pow(input_x[6], 5);
        idvd_poly_feat[3228] = pow(input_x[2], 1) * pow(input_x[3], 6);
        idvd_poly_feat[3229] = pow(input_x[2], 1) * pow(input_x[3], 5) * pow(input_x[4], 1);
        idvd_poly_feat[3230] = pow(input_x[2], 1) * pow(input_x[3], 5) * pow(input_x[5], 1);
        idvd_poly_feat[3231] = pow(input_x[2], 1) * pow(input_x[3], 5) * pow(input_x[6], 1);
        idvd_poly_feat[3232] = pow(input_x[2], 1) * pow(input_x[3], 4) * pow(input_x[4], 2);
        idvd_poly_feat[3233] = pow(input_x[2], 1) * pow(input_x[3], 4) * pow(input_x[4], 1) * pow(input_x[5], 1);
        idvd_poly_feat[3234] = pow(input_x[2], 1) * pow(input_x[3], 4) * pow(input_x[4], 1) * pow(input_x[6], 1);
        idvd_poly_feat[3235] = pow(input_x[2], 1) * pow(input_x[3], 4) * pow(input_x[5], 2);
        idvd_poly_feat[3236] = pow(input_x[2], 1) * pow(input_x[3], 4) * pow(input_x[5], 1) * pow(input_x[6], 1);
        idvd_poly_feat[3237] = pow(input_x[2], 1) * pow(input_x[3], 4) * pow(input_x[6], 2);
        idvd_poly_feat[3238] = pow(input_x[2], 1) * pow(input_x[3], 3) * pow(input_x[4], 3);
        idvd_poly_feat[3239] = pow(input_x[2], 1) * pow(input_x[3], 3) * pow(input_x[4], 2) * pow(input_x[5], 1);
        idvd_poly_feat[3240] = pow(input_x[2], 1) * pow(input_x[3], 3) * pow(input_x[4], 2) * pow(input_x[6], 1);
        idvd_poly_feat[3241] = pow(input_x[2], 1) * pow(input_x[3], 3) * pow(input_x[4], 1) * pow(input_x[5], 2);
        idvd_poly_feat[3242] = pow(input_x[2], 1) * pow(input_x[3], 3) * pow(input_x[4], 1) * pow(input_x[5], 1) * pow(input_x[6], 1);
        idvd_poly_feat[3243] = pow(input_x[2], 1) * pow(input_x[3], 3) * pow(input_x[4], 1) * pow(input_x[6], 2);
        idvd_poly_feat[3244] = pow(input_x[2], 1) * pow(input_x[3], 3) * pow(input_x[5], 3);
        idvd_poly_feat[3245] = pow(input_x[2], 1) * pow(input_x[3], 3) * pow(input_x[5], 2) * pow(input_x[6], 1);
        idvd_poly_feat[3246] = pow(input_x[2], 1) * pow(input_x[3], 3) * pow(input_x[5], 1) * pow(input_x[6], 2);
        idvd_poly_feat[3247] = pow(input_x[2], 1) * pow(input_x[3], 3) * pow(input_x[6], 3);
        idvd_poly_feat[3248] = pow(input_x[2], 1) * pow(input_x[3], 2) * pow(input_x[4], 4);
        idvd_poly_feat[3249] = pow(input_x[2], 1) * pow(input_x[3], 2) * pow(input_x[4], 3) * pow(input_x[5], 1);
        idvd_poly_feat[3250] = pow(input_x[2], 1) * pow(input_x[3], 2) * pow(input_x[4], 3) * pow(input_x[6], 1);
        idvd_poly_feat[3251] = pow(input_x[2], 1) * pow(input_x[3], 2) * pow(input_x[4], 2) * pow(input_x[5], 2);
        idvd_poly_feat[3252] = pow(input_x[2], 1) * pow(input_x[3], 2) * pow(input_x[4], 2) * pow(input_x[5], 1) * pow(input_x[6], 1);
        idvd_poly_feat[3253] = pow(input_x[2], 1) * pow(input_x[3], 2) * pow(input_x[4], 2) * pow(input_x[6], 2);
        idvd_poly_feat[3254] = pow(input_x[2], 1) * pow(input_x[3], 2) * pow(input_x[4], 1) * pow(input_x[5], 3);
        idvd_poly_feat[3255] = pow(input_x[2], 1) * pow(input_x[3], 2) * pow(input_x[4], 1) * pow(input_x[5], 2) * pow(input_x[6], 1);
        idvd_poly_feat[3256] = pow(input_x[2], 1) * pow(input_x[3], 2) * pow(input_x[4], 1) * pow(input_x[5], 1) * pow(input_x[6], 2);
        idvd_poly_feat[3257] = pow(input_x[2], 1) * pow(input_x[3], 2) * pow(input_x[4], 1) * pow(input_x[6], 3);
        idvd_poly_feat[3258] = pow(input_x[2], 1) * pow(input_x[3], 2) * pow(input_x[5], 4);
        idvd_poly_feat[3259] = pow(input_x[2], 1) * pow(input_x[3], 2) * pow(input_x[5], 3) * pow(input_x[6], 1);
        idvd_poly_feat[3260] = pow(input_x[2], 1) * pow(input_x[3], 2) * pow(input_x[5], 2) * pow(input_x[6], 2);
        idvd_poly_feat[3261] = pow(input_x[2], 1) * pow(input_x[3], 2) * pow(input_x[5], 1) * pow(input_x[6], 3);
        idvd_poly_feat[3262] = pow(input_x[2], 1) * pow(input_x[3], 2) * pow(input_x[6], 4);
        idvd_poly_feat[3263] = pow(input_x[2], 1) * pow(input_x[3], 1) * pow(input_x[4], 5);
        idvd_poly_feat[3264] = pow(input_x[2], 1) * pow(input_x[3], 1) * pow(input_x[4], 4) * pow(input_x[5], 1);
        idvd_poly_feat[3265] = pow(input_x[2], 1) * pow(input_x[3], 1) * pow(input_x[4], 4) * pow(input_x[6], 1);
        idvd_poly_feat[3266] = pow(input_x[2], 1) * pow(input_x[3], 1) * pow(input_x[4], 3) * pow(input_x[5], 2);
        idvd_poly_feat[3267] = pow(input_x[2], 1) * pow(input_x[3], 1) * pow(input_x[4], 3) * pow(input_x[5], 1) * pow(input_x[6], 1);
        idvd_poly_feat[3268] = pow(input_x[2], 1) * pow(input_x[3], 1) * pow(input_x[4], 3) * pow(input_x[6], 2);
        idvd_poly_feat[3269] = pow(input_x[2], 1) * pow(input_x[3], 1) * pow(input_x[4], 2) * pow(input_x[5], 3);
        idvd_poly_feat[3270] = pow(input_x[2], 1) * pow(input_x[3], 1) * pow(input_x[4], 2) * pow(input_x[5], 2) * pow(input_x[6], 1);
        idvd_poly_feat[3271] = pow(input_x[2], 1) * pow(input_x[3], 1) * pow(input_x[4], 2) * pow(input_x[5], 1) * pow(input_x[6], 2);
        idvd_poly_feat[3272] = pow(input_x[2], 1) * pow(input_x[3], 1) * pow(input_x[4], 2) * pow(input_x[6], 3);
        idvd_poly_feat[3273] = pow(input_x[2], 1) * pow(input_x[3], 1) * pow(input_x[4], 1) * pow(input_x[5], 4);
        idvd_poly_feat[3274] = pow(input_x[2], 1) * pow(input_x[3], 1) * pow(input_x[4], 1) * pow(input_x[5], 3) * pow(input_x[6], 1);
        idvd_poly_feat[3275] = pow(input_x[2], 1) * pow(input_x[3], 1) * pow(input_x[4], 1) * pow(input_x[5], 2) * pow(input_x[6], 2);
        idvd_poly_feat[3276] = pow(input_x[2], 1) * pow(input_x[3], 1) * pow(input_x[4], 1) * pow(input_x[5], 1) * pow(input_x[6], 3);
        idvd_poly_feat[3277] = pow(input_x[2], 1) * pow(input_x[3], 1) * pow(input_x[4], 1) * pow(input_x[6], 4);
        idvd_poly_feat[3278] = pow(input_x[2], 1) * pow(input_x[3], 1) * pow(input_x[5], 5);
        idvd_poly_feat[3279] = pow(input_x[2], 1) * pow(input_x[3], 1) * pow(input_x[5], 4) * pow(input_x[6], 1);
        idvd_poly_feat[3280] = pow(input_x[2], 1) * pow(input_x[3], 1) * pow(input_x[5], 3) * pow(input_x[6], 2);
        idvd_poly_feat[3281] = pow(input_x[2], 1) * pow(input_x[3], 1) * pow(input_x[5], 2) * pow(input_x[6], 3);
        idvd_poly_feat[3282] = pow(input_x[2], 1) * pow(input_x[3], 1) * pow(input_x[5], 1) * pow(input_x[6], 4);
        idvd_poly_feat[3283] = pow(input_x[2], 1) * pow(input_x[3], 1) * pow(input_x[6], 5);
        idvd_poly_feat[3284] = pow(input_x[2], 1) * pow(input_x[4], 6);
        idvd_poly_feat[3285] = pow(input_x[2], 1) * pow(input_x[4], 5) * pow(input_x[5], 1);
        idvd_poly_feat[3286] = pow(input_x[2], 1) * pow(input_x[4], 5) * pow(input_x[6], 1);
        idvd_poly_feat[3287] = pow(input_x[2], 1) * pow(input_x[4], 4) * pow(input_x[5], 2);
        idvd_poly_feat[3288] = pow(input_x[2], 1) * pow(input_x[4], 4) * pow(input_x[5], 1) * pow(input_x[6], 1);
        idvd_poly_feat[3289] = pow(input_x[2], 1) * pow(input_x[4], 4) * pow(input_x[6], 2);
        idvd_poly_feat[3290] = pow(input_x[2], 1) * pow(input_x[4], 3) * pow(input_x[5], 3);
        idvd_poly_feat[3291] = pow(input_x[2], 1) * pow(input_x[4], 3) * pow(input_x[5], 2) * pow(input_x[6], 1);
        idvd_poly_feat[3292] = pow(input_x[2], 1) * pow(input_x[4], 3) * pow(input_x[5], 1) * pow(input_x[6], 2);
        idvd_poly_feat[3293] = pow(input_x[2], 1) * pow(input_x[4], 3) * pow(input_x[6], 3);
        idvd_poly_feat[3294] = pow(input_x[2], 1) * pow(input_x[4], 2) * pow(input_x[5], 4);
        idvd_poly_feat[3295] = pow(input_x[2], 1) * pow(input_x[4], 2) * pow(input_x[5], 3) * pow(input_x[6], 1);
        idvd_poly_feat[3296] = pow(input_x[2], 1) * pow(input_x[4], 2) * pow(input_x[5], 2) * pow(input_x[6], 2);
        idvd_poly_feat[3297] = pow(input_x[2], 1) * pow(input_x[4], 2) * pow(input_x[5], 1) * pow(input_x[6], 3);
        idvd_poly_feat[3298] = pow(input_x[2], 1) * pow(input_x[4], 2) * pow(input_x[6], 4);
        idvd_poly_feat[3299] = pow(input_x[2], 1) * pow(input_x[4], 1) * pow(input_x[5], 5);
        idvd_poly_feat[3300] = pow(input_x[2], 1) * pow(input_x[4], 1) * pow(input_x[5], 4) * pow(input_x[6], 1);
        idvd_poly_feat[3301] = pow(input_x[2], 1) * pow(input_x[4], 1) * pow(input_x[5], 3) * pow(input_x[6], 2);
        idvd_poly_feat[3302] = pow(input_x[2], 1) * pow(input_x[4], 1) * pow(input_x[5], 2) * pow(input_x[6], 3);
        idvd_poly_feat[3303] = pow(input_x[2], 1) * pow(input_x[4], 1) * pow(input_x[5], 1) * pow(input_x[6], 4);
        idvd_poly_feat[3304] = pow(input_x[2], 1) * pow(input_x[4], 1) * pow(input_x[6], 5);
        idvd_poly_feat[3305] = pow(input_x[2], 1) * pow(input_x[5], 6);
        idvd_poly_feat[3306] = pow(input_x[2], 1) * pow(input_x[5], 5) * pow(input_x[6], 1);
        idvd_poly_feat[3307] = pow(input_x[2], 1) * pow(input_x[5], 4) * pow(input_x[6], 2);
        idvd_poly_feat[3308] = pow(input_x[2], 1) * pow(input_x[5], 3) * pow(input_x[6], 3);
        idvd_poly_feat[3309] = pow(input_x[2], 1) * pow(input_x[5], 2) * pow(input_x[6], 4);
        idvd_poly_feat[3310] = pow(input_x[2], 1) * pow(input_x[5], 1) * pow(input_x[6], 5);
        idvd_poly_feat[3311] = pow(input_x[2], 1) * pow(input_x[6], 6);
        idvd_poly_feat[3312] = pow(input_x[3], 7);
        idvd_poly_feat[3313] = pow(input_x[3], 6) * pow(input_x[4], 1);
        idvd_poly_feat[3314] = pow(input_x[3], 6) * pow(input_x[5], 1);
        idvd_poly_feat[3315] = pow(input_x[3], 6) * pow(input_x[6], 1);
        idvd_poly_feat[3316] = pow(input_x[3], 5) * pow(input_x[4], 2);
        idvd_poly_feat[3317] = pow(input_x[3], 5) * pow(input_x[4], 1) * pow(input_x[5], 1);
        idvd_poly_feat[3318] = pow(input_x[3], 5) * pow(input_x[4], 1) * pow(input_x[6], 1);
        idvd_poly_feat[3319] = pow(input_x[3], 5) * pow(input_x[5], 2);
        idvd_poly_feat[3320] = pow(input_x[3], 5) * pow(input_x[5], 1) * pow(input_x[6], 1);
        idvd_poly_feat[3321] = pow(input_x[3], 5) * pow(input_x[6], 2);
        idvd_poly_feat[3322] = pow(input_x[3], 4) * pow(input_x[4], 3);
        idvd_poly_feat[3323] = pow(input_x[3], 4) * pow(input_x[4], 2) * pow(input_x[5], 1);
        idvd_poly_feat[3324] = pow(input_x[3], 4) * pow(input_x[4], 2) * pow(input_x[6], 1);
        idvd_poly_feat[3325] = pow(input_x[3], 4) * pow(input_x[4], 1) * pow(input_x[5], 2);
        idvd_poly_feat[3326] = pow(input_x[3], 4) * pow(input_x[4], 1) * pow(input_x[5], 1) * pow(input_x[6], 1);
        idvd_poly_feat[3327] = pow(input_x[3], 4) * pow(input_x[4], 1) * pow(input_x[6], 2);
        idvd_poly_feat[3328] = pow(input_x[3], 4) * pow(input_x[5], 3);
        idvd_poly_feat[3329] = pow(input_x[3], 4) * pow(input_x[5], 2) * pow(input_x[6], 1);
        idvd_poly_feat[3330] = pow(input_x[3], 4) * pow(input_x[5], 1) * pow(input_x[6], 2);
        idvd_poly_feat[3331] = pow(input_x[3], 4) * pow(input_x[6], 3);
        idvd_poly_feat[3332] = pow(input_x[3], 3) * pow(input_x[4], 4);
        idvd_poly_feat[3333] = pow(input_x[3], 3) * pow(input_x[4], 3) * pow(input_x[5], 1);
        idvd_poly_feat[3334] = pow(input_x[3], 3) * pow(input_x[4], 3) * pow(input_x[6], 1);
        idvd_poly_feat[3335] = pow(input_x[3], 3) * pow(input_x[4], 2) * pow(input_x[5], 2);
        idvd_poly_feat[3336] = pow(input_x[3], 3) * pow(input_x[4], 2) * pow(input_x[5], 1) * pow(input_x[6], 1);
        idvd_poly_feat[3337] = pow(input_x[3], 3) * pow(input_x[4], 2) * pow(input_x[6], 2);
        idvd_poly_feat[3338] = pow(input_x[3], 3) * pow(input_x[4], 1) * pow(input_x[5], 3);
        idvd_poly_feat[3339] = pow(input_x[3], 3) * pow(input_x[4], 1) * pow(input_x[5], 2) * pow(input_x[6], 1);
        idvd_poly_feat[3340] = pow(input_x[3], 3) * pow(input_x[4], 1) * pow(input_x[5], 1) * pow(input_x[6], 2);
        idvd_poly_feat[3341] = pow(input_x[3], 3) * pow(input_x[4], 1) * pow(input_x[6], 3);
        idvd_poly_feat[3342] = pow(input_x[3], 3) * pow(input_x[5], 4);
        idvd_poly_feat[3343] = pow(input_x[3], 3) * pow(input_x[5], 3) * pow(input_x[6], 1);
        idvd_poly_feat[3344] = pow(input_x[3], 3) * pow(input_x[5], 2) * pow(input_x[6], 2);
        idvd_poly_feat[3345] = pow(input_x[3], 3) * pow(input_x[5], 1) * pow(input_x[6], 3);
        idvd_poly_feat[3346] = pow(input_x[3], 3) * pow(input_x[6], 4);
        idvd_poly_feat[3347] = pow(input_x[3], 2) * pow(input_x[4], 5);
        idvd_poly_feat[3348] = pow(input_x[3], 2) * pow(input_x[4], 4) * pow(input_x[5], 1);
        idvd_poly_feat[3349] = pow(input_x[3], 2) * pow(input_x[4], 4) * pow(input_x[6], 1);
        idvd_poly_feat[3350] = pow(input_x[3], 2) * pow(input_x[4], 3) * pow(input_x[5], 2);
        idvd_poly_feat[3351] = pow(input_x[3], 2) * pow(input_x[4], 3) * pow(input_x[5], 1) * pow(input_x[6], 1);
        idvd_poly_feat[3352] = pow(input_x[3], 2) * pow(input_x[4], 3) * pow(input_x[6], 2);
        idvd_poly_feat[3353] = pow(input_x[3], 2) * pow(input_x[4], 2) * pow(input_x[5], 3);
        idvd_poly_feat[3354] = pow(input_x[3], 2) * pow(input_x[4], 2) * pow(input_x[5], 2) * pow(input_x[6], 1);
        idvd_poly_feat[3355] = pow(input_x[3], 2) * pow(input_x[4], 2) * pow(input_x[5], 1) * pow(input_x[6], 2);
        idvd_poly_feat[3356] = pow(input_x[3], 2) * pow(input_x[4], 2) * pow(input_x[6], 3);
        idvd_poly_feat[3357] = pow(input_x[3], 2) * pow(input_x[4], 1) * pow(input_x[5], 4);
        idvd_poly_feat[3358] = pow(input_x[3], 2) * pow(input_x[4], 1) * pow(input_x[5], 3) * pow(input_x[6], 1);
        idvd_poly_feat[3359] = pow(input_x[3], 2) * pow(input_x[4], 1) * pow(input_x[5], 2) * pow(input_x[6], 2);
        idvd_poly_feat[3360] = pow(input_x[3], 2) * pow(input_x[4], 1) * pow(input_x[5], 1) * pow(input_x[6], 3);
        idvd_poly_feat[3361] = pow(input_x[3], 2) * pow(input_x[4], 1) * pow(input_x[6], 4);
        idvd_poly_feat[3362] = pow(input_x[3], 2) * pow(input_x[5], 5);
        idvd_poly_feat[3363] = pow(input_x[3], 2) * pow(input_x[5], 4) * pow(input_x[6], 1);
        idvd_poly_feat[3364] = pow(input_x[3], 2) * pow(input_x[5], 3) * pow(input_x[6], 2);
        idvd_poly_feat[3365] = pow(input_x[3], 2) * pow(input_x[5], 2) * pow(input_x[6], 3);
        idvd_poly_feat[3366] = pow(input_x[3], 2) * pow(input_x[5], 1) * pow(input_x[6], 4);
        idvd_poly_feat[3367] = pow(input_x[3], 2) * pow(input_x[6], 5);
        idvd_poly_feat[3368] = pow(input_x[3], 1) * pow(input_x[4], 6);
        idvd_poly_feat[3369] = pow(input_x[3], 1) * pow(input_x[4], 5) * pow(input_x[5], 1);
        idvd_poly_feat[3370] = pow(input_x[3], 1) * pow(input_x[4], 5) * pow(input_x[6], 1);
        idvd_poly_feat[3371] = pow(input_x[3], 1) * pow(input_x[4], 4) * pow(input_x[5], 2);
        idvd_poly_feat[3372] = pow(input_x[3], 1) * pow(input_x[4], 4) * pow(input_x[5], 1) * pow(input_x[6], 1);
        idvd_poly_feat[3373] = pow(input_x[3], 1) * pow(input_x[4], 4) * pow(input_x[6], 2);
        idvd_poly_feat[3374] = pow(input_x[3], 1) * pow(input_x[4], 3) * pow(input_x[5], 3);
        idvd_poly_feat[3375] = pow(input_x[3], 1) * pow(input_x[4], 3) * pow(input_x[5], 2) * pow(input_x[6], 1);
        idvd_poly_feat[3376] = pow(input_x[3], 1) * pow(input_x[4], 3) * pow(input_x[5], 1) * pow(input_x[6], 2);
        idvd_poly_feat[3377] = pow(input_x[3], 1) * pow(input_x[4], 3) * pow(input_x[6], 3);
        idvd_poly_feat[3378] = pow(input_x[3], 1) * pow(input_x[4], 2) * pow(input_x[5], 4);
        idvd_poly_feat[3379] = pow(input_x[3], 1) * pow(input_x[4], 2) * pow(input_x[5], 3) * pow(input_x[6], 1);
        idvd_poly_feat[3380] = pow(input_x[3], 1) * pow(input_x[4], 2) * pow(input_x[5], 2) * pow(input_x[6], 2);
        idvd_poly_feat[3381] = pow(input_x[3], 1) * pow(input_x[4], 2) * pow(input_x[5], 1) * pow(input_x[6], 3);
        idvd_poly_feat[3382] = pow(input_x[3], 1) * pow(input_x[4], 2) * pow(input_x[6], 4);
        idvd_poly_feat[3383] = pow(input_x[3], 1) * pow(input_x[4], 1) * pow(input_x[5], 5);
        idvd_poly_feat[3384] = pow(input_x[3], 1) * pow(input_x[4], 1) * pow(input_x[5], 4) * pow(input_x[6], 1);
        idvd_poly_feat[3385] = pow(input_x[3], 1) * pow(input_x[4], 1) * pow(input_x[5], 3) * pow(input_x[6], 2);
        idvd_poly_feat[3386] = pow(input_x[3], 1) * pow(input_x[4], 1) * pow(input_x[5], 2) * pow(input_x[6], 3);
        idvd_poly_feat[3387] = pow(input_x[3], 1) * pow(input_x[4], 1) * pow(input_x[5], 1) * pow(input_x[6], 4);
        idvd_poly_feat[3388] = pow(input_x[3], 1) * pow(input_x[4], 1) * pow(input_x[6], 5);
        idvd_poly_feat[3389] = pow(input_x[3], 1) * pow(input_x[5], 6);
        idvd_poly_feat[3390] = pow(input_x[3], 1) * pow(input_x[5], 5) * pow(input_x[6], 1);
        idvd_poly_feat[3391] = pow(input_x[3], 1) * pow(input_x[5], 4) * pow(input_x[6], 2);
        idvd_poly_feat[3392] = pow(input_x[3], 1) * pow(input_x[5], 3) * pow(input_x[6], 3);
        idvd_poly_feat[3393] = pow(input_x[3], 1) * pow(input_x[5], 2) * pow(input_x[6], 4);
        idvd_poly_feat[3394] = pow(input_x[3], 1) * pow(input_x[5], 1) * pow(input_x[6], 5);
        idvd_poly_feat[3395] = pow(input_x[3], 1) * pow(input_x[6], 6);
        idvd_poly_feat[3396] = pow(input_x[4], 7);
        idvd_poly_feat[3397] = pow(input_x[4], 6) * pow(input_x[5], 1);
        idvd_poly_feat[3398] = pow(input_x[4], 6) * pow(input_x[6], 1);
        idvd_poly_feat[3399] = pow(input_x[4], 5) * pow(input_x[5], 2);
        idvd_poly_feat[3400] = pow(input_x[4], 5) * pow(input_x[5], 1) * pow(input_x[6], 1);
        idvd_poly_feat[3401] = pow(input_x[4], 5) * pow(input_x[6], 2);
        idvd_poly_feat[3402] = pow(input_x[4], 4) * pow(input_x[5], 3);
        idvd_poly_feat[3403] = pow(input_x[4], 4) * pow(input_x[5], 2) * pow(input_x[6], 1);
        idvd_poly_feat[3404] = pow(input_x[4], 4) * pow(input_x[5], 1) * pow(input_x[6], 2);
        idvd_poly_feat[3405] = pow(input_x[4], 4) * pow(input_x[6], 3);
        idvd_poly_feat[3406] = pow(input_x[4], 3) * pow(input_x[5], 4);
        idvd_poly_feat[3407] = pow(input_x[4], 3) * pow(input_x[5], 3) * pow(input_x[6], 1);
        idvd_poly_feat[3408] = pow(input_x[4], 3) * pow(input_x[5], 2) * pow(input_x[6], 2);
        idvd_poly_feat[3409] = pow(input_x[4], 3) * pow(input_x[5], 1) * pow(input_x[6], 3);
        idvd_poly_feat[3410] = pow(input_x[4], 3) * pow(input_x[6], 4);
        idvd_poly_feat[3411] = pow(input_x[4], 2) * pow(input_x[5], 5);
        idvd_poly_feat[3412] = pow(input_x[4], 2) * pow(input_x[5], 4) * pow(input_x[6], 1);
        idvd_poly_feat[3413] = pow(input_x[4], 2) * pow(input_x[5], 3) * pow(input_x[6], 2);
        idvd_poly_feat[3414] = pow(input_x[4], 2) * pow(input_x[5], 2) * pow(input_x[6], 3);
        idvd_poly_feat[3415] = pow(input_x[4], 2) * pow(input_x[5], 1) * pow(input_x[6], 4);
        idvd_poly_feat[3416] = pow(input_x[4], 2) * pow(input_x[6], 5);
        idvd_poly_feat[3417] = pow(input_x[4], 1) * pow(input_x[5], 6);
        idvd_poly_feat[3418] = pow(input_x[4], 1) * pow(input_x[5], 5) * pow(input_x[6], 1);
        idvd_poly_feat[3419] = pow(input_x[4], 1) * pow(input_x[5], 4) * pow(input_x[6], 2);
        idvd_poly_feat[3420] = pow(input_x[4], 1) * pow(input_x[5], 3) * pow(input_x[6], 3);
        idvd_poly_feat[3421] = pow(input_x[4], 1) * pow(input_x[5], 2) * pow(input_x[6], 4);
        idvd_poly_feat[3422] = pow(input_x[4], 1) * pow(input_x[5], 1) * pow(input_x[6], 5);
        idvd_poly_feat[3423] = pow(input_x[4], 1) * pow(input_x[6], 6);
        idvd_poly_feat[3424] = pow(input_x[5], 7);
        idvd_poly_feat[3425] = pow(input_x[5], 6) * pow(input_x[6], 1);
        idvd_poly_feat[3426] = pow(input_x[5], 5) * pow(input_x[6], 2);
        idvd_poly_feat[3427] = pow(input_x[5], 4) * pow(input_x[6], 3);
        idvd_poly_feat[3428] = pow(input_x[5], 3) * pow(input_x[6], 4);
        idvd_poly_feat[3429] = pow(input_x[5], 2) * pow(input_x[6], 5);
        idvd_poly_feat[3430] = pow(input_x[5], 1) * pow(input_x[6], 6);
        idvd_poly_feat[3431] = pow(input_x[6], 7);
        idvd_poly_feat[3432] = pow(input_x[0], 8);
        idvd_poly_feat[3433] = pow(input_x[0], 7) * pow(input_x[1], 1);
        idvd_poly_feat[3434] = pow(input_x[0], 7) * pow(input_x[2], 1);
        idvd_poly_feat[3435] = pow(input_x[0], 7) * pow(input_x[3], 1);
        idvd_poly_feat[3436] = pow(input_x[0], 7) * pow(input_x[4], 1);
        idvd_poly_feat[3437] = pow(input_x[0], 7) * pow(input_x[5], 1);
        idvd_poly_feat[3438] = pow(input_x[0], 7) * pow(input_x[6], 1);
        idvd_poly_feat[3439] = pow(input_x[0], 6) * pow(input_x[1], 2);
        idvd_poly_feat[3440] = pow(input_x[0], 6) * pow(input_x[1], 1) * pow(input_x[2], 1);
        idvd_poly_feat[3441] = pow(input_x[0], 6) * pow(input_x[1], 1) * pow(input_x[3], 1);
        idvd_poly_feat[3442] = pow(input_x[0], 6) * pow(input_x[1], 1) * pow(input_x[4], 1);
        idvd_poly_feat[3443] = pow(input_x[0], 6) * pow(input_x[1], 1) * pow(input_x[5], 1);
        idvd_poly_feat[3444] = pow(input_x[0], 6) * pow(input_x[1], 1) * pow(input_x[6], 1);
        idvd_poly_feat[3445] = pow(input_x[0], 6) * pow(input_x[2], 2);
        idvd_poly_feat[3446] = pow(input_x[0], 6) * pow(input_x[2], 1) * pow(input_x[3], 1);
        idvd_poly_feat[3447] = pow(input_x[0], 6) * pow(input_x[2], 1) * pow(input_x[4], 1);
        idvd_poly_feat[3448] = pow(input_x[0], 6) * pow(input_x[2], 1) * pow(input_x[5], 1);
        idvd_poly_feat[3449] = pow(input_x[0], 6) * pow(input_x[2], 1) * pow(input_x[6], 1);
        idvd_poly_feat[3450] = pow(input_x[0], 6) * pow(input_x[3], 2);
        idvd_poly_feat[3451] = pow(input_x[0], 6) * pow(input_x[3], 1) * pow(input_x[4], 1);
        idvd_poly_feat[3452] = pow(input_x[0], 6) * pow(input_x[3], 1) * pow(input_x[5], 1);
        idvd_poly_feat[3453] = pow(input_x[0], 6) * pow(input_x[3], 1) * pow(input_x[6], 1);
        idvd_poly_feat[3454] = pow(input_x[0], 6) * pow(input_x[4], 2);
        idvd_poly_feat[3455] = pow(input_x[0], 6) * pow(input_x[4], 1) * pow(input_x[5], 1);
        idvd_poly_feat[3456] = pow(input_x[0], 6) * pow(input_x[4], 1) * pow(input_x[6], 1);
        idvd_poly_feat[3457] = pow(input_x[0], 6) * pow(input_x[5], 2);
        idvd_poly_feat[3458] = pow(input_x[0], 6) * pow(input_x[5], 1) * pow(input_x[6], 1);
        idvd_poly_feat[3459] = pow(input_x[0], 6) * pow(input_x[6], 2);
        idvd_poly_feat[3460] = pow(input_x[0], 5) * pow(input_x[1], 3);
        idvd_poly_feat[3461] = pow(input_x[0], 5) * pow(input_x[1], 2) * pow(input_x[2], 1);
        idvd_poly_feat[3462] = pow(input_x[0], 5) * pow(input_x[1], 2) * pow(input_x[3], 1);
        idvd_poly_feat[3463] = pow(input_x[0], 5) * pow(input_x[1], 2) * pow(input_x[4], 1);
        idvd_poly_feat[3464] = pow(input_x[0], 5) * pow(input_x[1], 2) * pow(input_x[5], 1);
        idvd_poly_feat[3465] = pow(input_x[0], 5) * pow(input_x[1], 2) * pow(input_x[6], 1);
        idvd_poly_feat[3466] = pow(input_x[0], 5) * pow(input_x[1], 1) * pow(input_x[2], 2);
        idvd_poly_feat[3467] = pow(input_x[0], 5) * pow(input_x[1], 1) * pow(input_x[2], 1) * pow(input_x[3], 1);
        idvd_poly_feat[3468] = pow(input_x[0], 5) * pow(input_x[1], 1) * pow(input_x[2], 1) * pow(input_x[4], 1);
        idvd_poly_feat[3469] = pow(input_x[0], 5) * pow(input_x[1], 1) * pow(input_x[2], 1) * pow(input_x[5], 1);
        idvd_poly_feat[3470] = pow(input_x[0], 5) * pow(input_x[1], 1) * pow(input_x[2], 1) * pow(input_x[6], 1);
        idvd_poly_feat[3471] = pow(input_x[0], 5) * pow(input_x[1], 1) * pow(input_x[3], 2);
        idvd_poly_feat[3472] = pow(input_x[0], 5) * pow(input_x[1], 1) * pow(input_x[3], 1) * pow(input_x[4], 1);
        idvd_poly_feat[3473] = pow(input_x[0], 5) * pow(input_x[1], 1) * pow(input_x[3], 1) * pow(input_x[5], 1);
        idvd_poly_feat[3474] = pow(input_x[0], 5) * pow(input_x[1], 1) * pow(input_x[3], 1) * pow(input_x[6], 1);
        idvd_poly_feat[3475] = pow(input_x[0], 5) * pow(input_x[1], 1) * pow(input_x[4], 2);
        idvd_poly_feat[3476] = pow(input_x[0], 5) * pow(input_x[1], 1) * pow(input_x[4], 1) * pow(input_x[5], 1);
        idvd_poly_feat[3477] = pow(input_x[0], 5) * pow(input_x[1], 1) * pow(input_x[4], 1) * pow(input_x[6], 1);
        idvd_poly_feat[3478] = pow(input_x[0], 5) * pow(input_x[1], 1) * pow(input_x[5], 2);
        idvd_poly_feat[3479] = pow(input_x[0], 5) * pow(input_x[1], 1) * pow(input_x[5], 1) * pow(input_x[6], 1);
        idvd_poly_feat[3480] = pow(input_x[0], 5) * pow(input_x[1], 1) * pow(input_x[6], 2);
        idvd_poly_feat[3481] = pow(input_x[0], 5) * pow(input_x[2], 3);
        idvd_poly_feat[3482] = pow(input_x[0], 5) * pow(input_x[2], 2) * pow(input_x[3], 1);
        idvd_poly_feat[3483] = pow(input_x[0], 5) * pow(input_x[2], 2) * pow(input_x[4], 1);
        idvd_poly_feat[3484] = pow(input_x[0], 5) * pow(input_x[2], 2) * pow(input_x[5], 1);
        idvd_poly_feat[3485] = pow(input_x[0], 5) * pow(input_x[2], 2) * pow(input_x[6], 1);
        idvd_poly_feat[3486] = pow(input_x[0], 5) * pow(input_x[2], 1) * pow(input_x[3], 2);
        idvd_poly_feat[3487] = pow(input_x[0], 5) * pow(input_x[2], 1) * pow(input_x[3], 1) * pow(input_x[4], 1);
        idvd_poly_feat[3488] = pow(input_x[0], 5) * pow(input_x[2], 1) * pow(input_x[3], 1) * pow(input_x[5], 1);
        idvd_poly_feat[3489] = pow(input_x[0], 5) * pow(input_x[2], 1) * pow(input_x[3], 1) * pow(input_x[6], 1);
        idvd_poly_feat[3490] = pow(input_x[0], 5) * pow(input_x[2], 1) * pow(input_x[4], 2);
        idvd_poly_feat[3491] = pow(input_x[0], 5) * pow(input_x[2], 1) * pow(input_x[4], 1) * pow(input_x[5], 1);
        idvd_poly_feat[3492] = pow(input_x[0], 5) * pow(input_x[2], 1) * pow(input_x[4], 1) * pow(input_x[6], 1);
        idvd_poly_feat[3493] = pow(input_x[0], 5) * pow(input_x[2], 1) * pow(input_x[5], 2);
        idvd_poly_feat[3494] = pow(input_x[0], 5) * pow(input_x[2], 1) * pow(input_x[5], 1) * pow(input_x[6], 1);
        idvd_poly_feat[3495] = pow(input_x[0], 5) * pow(input_x[2], 1) * pow(input_x[6], 2);
        idvd_poly_feat[3496] = pow(input_x[0], 5) * pow(input_x[3], 3);
        idvd_poly_feat[3497] = pow(input_x[0], 5) * pow(input_x[3], 2) * pow(input_x[4], 1);
        idvd_poly_feat[3498] = pow(input_x[0], 5) * pow(input_x[3], 2) * pow(input_x[5], 1);
        idvd_poly_feat[3499] = pow(input_x[0], 5) * pow(input_x[3], 2) * pow(input_x[6], 1);
        idvd_poly_feat[3500] = pow(input_x[0], 5) * pow(input_x[3], 1) * pow(input_x[4], 2);
        idvd_poly_feat[3501] = pow(input_x[0], 5) * pow(input_x[3], 1) * pow(input_x[4], 1) * pow(input_x[5], 1);
        idvd_poly_feat[3502] = pow(input_x[0], 5) * pow(input_x[3], 1) * pow(input_x[4], 1) * pow(input_x[6], 1);
        idvd_poly_feat[3503] = pow(input_x[0], 5) * pow(input_x[3], 1) * pow(input_x[5], 2);
        idvd_poly_feat[3504] = pow(input_x[0], 5) * pow(input_x[3], 1) * pow(input_x[5], 1) * pow(input_x[6], 1);
        idvd_poly_feat[3505] = pow(input_x[0], 5) * pow(input_x[3], 1) * pow(input_x[6], 2);
        idvd_poly_feat[3506] = pow(input_x[0], 5) * pow(input_x[4], 3);
        idvd_poly_feat[3507] = pow(input_x[0], 5) * pow(input_x[4], 2) * pow(input_x[5], 1);
        idvd_poly_feat[3508] = pow(input_x[0], 5) * pow(input_x[4], 2) * pow(input_x[6], 1);
        idvd_poly_feat[3509] = pow(input_x[0], 5) * pow(input_x[4], 1) * pow(input_x[5], 2);
        idvd_poly_feat[3510] = pow(input_x[0], 5) * pow(input_x[4], 1) * pow(input_x[5], 1) * pow(input_x[6], 1);
        idvd_poly_feat[3511] = pow(input_x[0], 5) * pow(input_x[4], 1) * pow(input_x[6], 2);
        idvd_poly_feat[3512] = pow(input_x[0], 5) * pow(input_x[5], 3);
        idvd_poly_feat[3513] = pow(input_x[0], 5) * pow(input_x[5], 2) * pow(input_x[6], 1);
        idvd_poly_feat[3514] = pow(input_x[0], 5) * pow(input_x[5], 1) * pow(input_x[6], 2);
        idvd_poly_feat[3515] = pow(input_x[0], 5) * pow(input_x[6], 3);
        idvd_poly_feat[3516] = pow(input_x[0], 4) * pow(input_x[1], 4);
        idvd_poly_feat[3517] = pow(input_x[0], 4) * pow(input_x[1], 3) * pow(input_x[2], 1);
        idvd_poly_feat[3518] = pow(input_x[0], 4) * pow(input_x[1], 3) * pow(input_x[3], 1);
        idvd_poly_feat[3519] = pow(input_x[0], 4) * pow(input_x[1], 3) * pow(input_x[4], 1);
        idvd_poly_feat[3520] = pow(input_x[0], 4) * pow(input_x[1], 3) * pow(input_x[5], 1);
        idvd_poly_feat[3521] = pow(input_x[0], 4) * pow(input_x[1], 3) * pow(input_x[6], 1);
        idvd_poly_feat[3522] = pow(input_x[0], 4) * pow(input_x[1], 2) * pow(input_x[2], 2);
        idvd_poly_feat[3523] = pow(input_x[0], 4) * pow(input_x[1], 2) * pow(input_x[2], 1) * pow(input_x[3], 1);
        idvd_poly_feat[3524] = pow(input_x[0], 4) * pow(input_x[1], 2) * pow(input_x[2], 1) * pow(input_x[4], 1);
        idvd_poly_feat[3525] = pow(input_x[0], 4) * pow(input_x[1], 2) * pow(input_x[2], 1) * pow(input_x[5], 1);
        idvd_poly_feat[3526] = pow(input_x[0], 4) * pow(input_x[1], 2) * pow(input_x[2], 1) * pow(input_x[6], 1);
        idvd_poly_feat[3527] = pow(input_x[0], 4) * pow(input_x[1], 2) * pow(input_x[3], 2);
        idvd_poly_feat[3528] = pow(input_x[0], 4) * pow(input_x[1], 2) * pow(input_x[3], 1) * pow(input_x[4], 1);
        idvd_poly_feat[3529] = pow(input_x[0], 4) * pow(input_x[1], 2) * pow(input_x[3], 1) * pow(input_x[5], 1);
        idvd_poly_feat[3530] = pow(input_x[0], 4) * pow(input_x[1], 2) * pow(input_x[3], 1) * pow(input_x[6], 1);
        idvd_poly_feat[3531] = pow(input_x[0], 4) * pow(input_x[1], 2) * pow(input_x[4], 2);
        idvd_poly_feat[3532] = pow(input_x[0], 4) * pow(input_x[1], 2) * pow(input_x[4], 1) * pow(input_x[5], 1);
        idvd_poly_feat[3533] = pow(input_x[0], 4) * pow(input_x[1], 2) * pow(input_x[4], 1) * pow(input_x[6], 1);
        idvd_poly_feat[3534] = pow(input_x[0], 4) * pow(input_x[1], 2) * pow(input_x[5], 2);
        idvd_poly_feat[3535] = pow(input_x[0], 4) * pow(input_x[1], 2) * pow(input_x[5], 1) * pow(input_x[6], 1);
        idvd_poly_feat[3536] = pow(input_x[0], 4) * pow(input_x[1], 2) * pow(input_x[6], 2);
        idvd_poly_feat[3537] = pow(input_x[0], 4) * pow(input_x[1], 1) * pow(input_x[2], 3);
        idvd_poly_feat[3538] = pow(input_x[0], 4) * pow(input_x[1], 1) * pow(input_x[2], 2) * pow(input_x[3], 1);
        idvd_poly_feat[3539] = pow(input_x[0], 4) * pow(input_x[1], 1) * pow(input_x[2], 2) * pow(input_x[4], 1);
        idvd_poly_feat[3540] = pow(input_x[0], 4) * pow(input_x[1], 1) * pow(input_x[2], 2) * pow(input_x[5], 1);
        idvd_poly_feat[3541] = pow(input_x[0], 4) * pow(input_x[1], 1) * pow(input_x[2], 2) * pow(input_x[6], 1);
        idvd_poly_feat[3542] = pow(input_x[0], 4) * pow(input_x[1], 1) * pow(input_x[2], 1) * pow(input_x[3], 2);
        idvd_poly_feat[3543] = pow(input_x[0], 4) * pow(input_x[1], 1) * pow(input_x[2], 1) * pow(input_x[3], 1) * pow(input_x[4], 1);
        idvd_poly_feat[3544] = pow(input_x[0], 4) * pow(input_x[1], 1) * pow(input_x[2], 1) * pow(input_x[3], 1) * pow(input_x[5], 1);
        idvd_poly_feat[3545] = pow(input_x[0], 4) * pow(input_x[1], 1) * pow(input_x[2], 1) * pow(input_x[3], 1) * pow(input_x[6], 1);
        idvd_poly_feat[3546] = pow(input_x[0], 4) * pow(input_x[1], 1) * pow(input_x[2], 1) * pow(input_x[4], 2);
        idvd_poly_feat[3547] = pow(input_x[0], 4) * pow(input_x[1], 1) * pow(input_x[2], 1) * pow(input_x[4], 1) * pow(input_x[5], 1);
        idvd_poly_feat[3548] = pow(input_x[0], 4) * pow(input_x[1], 1) * pow(input_x[2], 1) * pow(input_x[4], 1) * pow(input_x[6], 1);
        idvd_poly_feat[3549] = pow(input_x[0], 4) * pow(input_x[1], 1) * pow(input_x[2], 1) * pow(input_x[5], 2);
        idvd_poly_feat[3550] = pow(input_x[0], 4) * pow(input_x[1], 1) * pow(input_x[2], 1) * pow(input_x[5], 1) * pow(input_x[6], 1);
        idvd_poly_feat[3551] = pow(input_x[0], 4) * pow(input_x[1], 1) * pow(input_x[2], 1) * pow(input_x[6], 2);
        idvd_poly_feat[3552] = pow(input_x[0], 4) * pow(input_x[1], 1) * pow(input_x[3], 3);
        idvd_poly_feat[3553] = pow(input_x[0], 4) * pow(input_x[1], 1) * pow(input_x[3], 2) * pow(input_x[4], 1);
        idvd_poly_feat[3554] = pow(input_x[0], 4) * pow(input_x[1], 1) * pow(input_x[3], 2) * pow(input_x[5], 1);
        idvd_poly_feat[3555] = pow(input_x[0], 4) * pow(input_x[1], 1) * pow(input_x[3], 2) * pow(input_x[6], 1);
        idvd_poly_feat[3556] = pow(input_x[0], 4) * pow(input_x[1], 1) * pow(input_x[3], 1) * pow(input_x[4], 2);
        idvd_poly_feat[3557] = pow(input_x[0], 4) * pow(input_x[1], 1) * pow(input_x[3], 1) * pow(input_x[4], 1) * pow(input_x[5], 1);
        idvd_poly_feat[3558] = pow(input_x[0], 4) * pow(input_x[1], 1) * pow(input_x[3], 1) * pow(input_x[4], 1) * pow(input_x[6], 1);
        idvd_poly_feat[3559] = pow(input_x[0], 4) * pow(input_x[1], 1) * pow(input_x[3], 1) * pow(input_x[5], 2);
        idvd_poly_feat[3560] = pow(input_x[0], 4) * pow(input_x[1], 1) * pow(input_x[3], 1) * pow(input_x[5], 1) * pow(input_x[6], 1);
        idvd_poly_feat[3561] = pow(input_x[0], 4) * pow(input_x[1], 1) * pow(input_x[3], 1) * pow(input_x[6], 2);
        idvd_poly_feat[3562] = pow(input_x[0], 4) * pow(input_x[1], 1) * pow(input_x[4], 3);
        idvd_poly_feat[3563] = pow(input_x[0], 4) * pow(input_x[1], 1) * pow(input_x[4], 2) * pow(input_x[5], 1);
        idvd_poly_feat[3564] = pow(input_x[0], 4) * pow(input_x[1], 1) * pow(input_x[4], 2) * pow(input_x[6], 1);
        idvd_poly_feat[3565] = pow(input_x[0], 4) * pow(input_x[1], 1) * pow(input_x[4], 1) * pow(input_x[5], 2);
        idvd_poly_feat[3566] = pow(input_x[0], 4) * pow(input_x[1], 1) * pow(input_x[4], 1) * pow(input_x[5], 1) * pow(input_x[6], 1);
        idvd_poly_feat[3567] = pow(input_x[0], 4) * pow(input_x[1], 1) * pow(input_x[4], 1) * pow(input_x[6], 2);
        idvd_poly_feat[3568] = pow(input_x[0], 4) * pow(input_x[1], 1) * pow(input_x[5], 3);
        idvd_poly_feat[3569] = pow(input_x[0], 4) * pow(input_x[1], 1) * pow(input_x[5], 2) * pow(input_x[6], 1);
        idvd_poly_feat[3570] = pow(input_x[0], 4) * pow(input_x[1], 1) * pow(input_x[5], 1) * pow(input_x[6], 2);
        idvd_poly_feat[3571] = pow(input_x[0], 4) * pow(input_x[1], 1) * pow(input_x[6], 3);
        idvd_poly_feat[3572] = pow(input_x[0], 4) * pow(input_x[2], 4);
        idvd_poly_feat[3573] = pow(input_x[0], 4) * pow(input_x[2], 3) * pow(input_x[3], 1);
        idvd_poly_feat[3574] = pow(input_x[0], 4) * pow(input_x[2], 3) * pow(input_x[4], 1);
        idvd_poly_feat[3575] = pow(input_x[0], 4) * pow(input_x[2], 3) * pow(input_x[5], 1);
        idvd_poly_feat[3576] = pow(input_x[0], 4) * pow(input_x[2], 3) * pow(input_x[6], 1);
        idvd_poly_feat[3577] = pow(input_x[0], 4) * pow(input_x[2], 2) * pow(input_x[3], 2);
        idvd_poly_feat[3578] = pow(input_x[0], 4) * pow(input_x[2], 2) * pow(input_x[3], 1) * pow(input_x[4], 1);
        idvd_poly_feat[3579] = pow(input_x[0], 4) * pow(input_x[2], 2) * pow(input_x[3], 1) * pow(input_x[5], 1);
        idvd_poly_feat[3580] = pow(input_x[0], 4) * pow(input_x[2], 2) * pow(input_x[3], 1) * pow(input_x[6], 1);
        idvd_poly_feat[3581] = pow(input_x[0], 4) * pow(input_x[2], 2) * pow(input_x[4], 2);
        idvd_poly_feat[3582] = pow(input_x[0], 4) * pow(input_x[2], 2) * pow(input_x[4], 1) * pow(input_x[5], 1);
        idvd_poly_feat[3583] = pow(input_x[0], 4) * pow(input_x[2], 2) * pow(input_x[4], 1) * pow(input_x[6], 1);
        idvd_poly_feat[3584] = pow(input_x[0], 4) * pow(input_x[2], 2) * pow(input_x[5], 2);
        idvd_poly_feat[3585] = pow(input_x[0], 4) * pow(input_x[2], 2) * pow(input_x[5], 1) * pow(input_x[6], 1);
        idvd_poly_feat[3586] = pow(input_x[0], 4) * pow(input_x[2], 2) * pow(input_x[6], 2);
        idvd_poly_feat[3587] = pow(input_x[0], 4) * pow(input_x[2], 1) * pow(input_x[3], 3);
        idvd_poly_feat[3588] = pow(input_x[0], 4) * pow(input_x[2], 1) * pow(input_x[3], 2) * pow(input_x[4], 1);
        idvd_poly_feat[3589] = pow(input_x[0], 4) * pow(input_x[2], 1) * pow(input_x[3], 2) * pow(input_x[5], 1);
        idvd_poly_feat[3590] = pow(input_x[0], 4) * pow(input_x[2], 1) * pow(input_x[3], 2) * pow(input_x[6], 1);
        idvd_poly_feat[3591] = pow(input_x[0], 4) * pow(input_x[2], 1) * pow(input_x[3], 1) * pow(input_x[4], 2);
        idvd_poly_feat[3592] = pow(input_x[0], 4) * pow(input_x[2], 1) * pow(input_x[3], 1) * pow(input_x[4], 1) * pow(input_x[5], 1);
        idvd_poly_feat[3593] = pow(input_x[0], 4) * pow(input_x[2], 1) * pow(input_x[3], 1) * pow(input_x[4], 1) * pow(input_x[6], 1);
        idvd_poly_feat[3594] = pow(input_x[0], 4) * pow(input_x[2], 1) * pow(input_x[3], 1) * pow(input_x[5], 2);
        idvd_poly_feat[3595] = pow(input_x[0], 4) * pow(input_x[2], 1) * pow(input_x[3], 1) * pow(input_x[5], 1) * pow(input_x[6], 1);
        idvd_poly_feat[3596] = pow(input_x[0], 4) * pow(input_x[2], 1) * pow(input_x[3], 1) * pow(input_x[6], 2);
        idvd_poly_feat[3597] = pow(input_x[0], 4) * pow(input_x[2], 1) * pow(input_x[4], 3);
        idvd_poly_feat[3598] = pow(input_x[0], 4) * pow(input_x[2], 1) * pow(input_x[4], 2) * pow(input_x[5], 1);
        idvd_poly_feat[3599] = pow(input_x[0], 4) * pow(input_x[2], 1) * pow(input_x[4], 2) * pow(input_x[6], 1);
        idvd_poly_feat[3600] = pow(input_x[0], 4) * pow(input_x[2], 1) * pow(input_x[4], 1) * pow(input_x[5], 2);
        idvd_poly_feat[3601] = pow(input_x[0], 4) * pow(input_x[2], 1) * pow(input_x[4], 1) * pow(input_x[5], 1) * pow(input_x[6], 1);
        idvd_poly_feat[3602] = pow(input_x[0], 4) * pow(input_x[2], 1) * pow(input_x[4], 1) * pow(input_x[6], 2);
        idvd_poly_feat[3603] = pow(input_x[0], 4) * pow(input_x[2], 1) * pow(input_x[5], 3);
        idvd_poly_feat[3604] = pow(input_x[0], 4) * pow(input_x[2], 1) * pow(input_x[5], 2) * pow(input_x[6], 1);
        idvd_poly_feat[3605] = pow(input_x[0], 4) * pow(input_x[2], 1) * pow(input_x[5], 1) * pow(input_x[6], 2);
        idvd_poly_feat[3606] = pow(input_x[0], 4) * pow(input_x[2], 1) * pow(input_x[6], 3);
        idvd_poly_feat[3607] = pow(input_x[0], 4) * pow(input_x[3], 4);
        idvd_poly_feat[3608] = pow(input_x[0], 4) * pow(input_x[3], 3) * pow(input_x[4], 1);
        idvd_poly_feat[3609] = pow(input_x[0], 4) * pow(input_x[3], 3) * pow(input_x[5], 1);
        idvd_poly_feat[3610] = pow(input_x[0], 4) * pow(input_x[3], 3) * pow(input_x[6], 1);
        idvd_poly_feat[3611] = pow(input_x[0], 4) * pow(input_x[3], 2) * pow(input_x[4], 2);
        idvd_poly_feat[3612] = pow(input_x[0], 4) * pow(input_x[3], 2) * pow(input_x[4], 1) * pow(input_x[5], 1);
        idvd_poly_feat[3613] = pow(input_x[0], 4) * pow(input_x[3], 2) * pow(input_x[4], 1) * pow(input_x[6], 1);
        idvd_poly_feat[3614] = pow(input_x[0], 4) * pow(input_x[3], 2) * pow(input_x[5], 2);
        idvd_poly_feat[3615] = pow(input_x[0], 4) * pow(input_x[3], 2) * pow(input_x[5], 1) * pow(input_x[6], 1);
        idvd_poly_feat[3616] = pow(input_x[0], 4) * pow(input_x[3], 2) * pow(input_x[6], 2);
        idvd_poly_feat[3617] = pow(input_x[0], 4) * pow(input_x[3], 1) * pow(input_x[4], 3);
        idvd_poly_feat[3618] = pow(input_x[0], 4) * pow(input_x[3], 1) * pow(input_x[4], 2) * pow(input_x[5], 1);
        idvd_poly_feat[3619] = pow(input_x[0], 4) * pow(input_x[3], 1) * pow(input_x[4], 2) * pow(input_x[6], 1);
        idvd_poly_feat[3620] = pow(input_x[0], 4) * pow(input_x[3], 1) * pow(input_x[4], 1) * pow(input_x[5], 2);
        idvd_poly_feat[3621] = pow(input_x[0], 4) * pow(input_x[3], 1) * pow(input_x[4], 1) * pow(input_x[5], 1) * pow(input_x[6], 1);
        idvd_poly_feat[3622] = pow(input_x[0], 4) * pow(input_x[3], 1) * pow(input_x[4], 1) * pow(input_x[6], 2);
        idvd_poly_feat[3623] = pow(input_x[0], 4) * pow(input_x[3], 1) * pow(input_x[5], 3);
        idvd_poly_feat[3624] = pow(input_x[0], 4) * pow(input_x[3], 1) * pow(input_x[5], 2) * pow(input_x[6], 1);
        idvd_poly_feat[3625] = pow(input_x[0], 4) * pow(input_x[3], 1) * pow(input_x[5], 1) * pow(input_x[6], 2);
        idvd_poly_feat[3626] = pow(input_x[0], 4) * pow(input_x[3], 1) * pow(input_x[6], 3);
        idvd_poly_feat[3627] = pow(input_x[0], 4) * pow(input_x[4], 4);
        idvd_poly_feat[3628] = pow(input_x[0], 4) * pow(input_x[4], 3) * pow(input_x[5], 1);
        idvd_poly_feat[3629] = pow(input_x[0], 4) * pow(input_x[4], 3) * pow(input_x[6], 1);
        idvd_poly_feat[3630] = pow(input_x[0], 4) * pow(input_x[4], 2) * pow(input_x[5], 2);
        idvd_poly_feat[3631] = pow(input_x[0], 4) * pow(input_x[4], 2) * pow(input_x[5], 1) * pow(input_x[6], 1);
        idvd_poly_feat[3632] = pow(input_x[0], 4) * pow(input_x[4], 2) * pow(input_x[6], 2);
        idvd_poly_feat[3633] = pow(input_x[0], 4) * pow(input_x[4], 1) * pow(input_x[5], 3);
        idvd_poly_feat[3634] = pow(input_x[0], 4) * pow(input_x[4], 1) * pow(input_x[5], 2) * pow(input_x[6], 1);
        idvd_poly_feat[3635] = pow(input_x[0], 4) * pow(input_x[4], 1) * pow(input_x[5], 1) * pow(input_x[6], 2);
        idvd_poly_feat[3636] = pow(input_x[0], 4) * pow(input_x[4], 1) * pow(input_x[6], 3);
        idvd_poly_feat[3637] = pow(input_x[0], 4) * pow(input_x[5], 4);
        idvd_poly_feat[3638] = pow(input_x[0], 4) * pow(input_x[5], 3) * pow(input_x[6], 1);
        idvd_poly_feat[3639] = pow(input_x[0], 4) * pow(input_x[5], 2) * pow(input_x[6], 2);
        idvd_poly_feat[3640] = pow(input_x[0], 4) * pow(input_x[5], 1) * pow(input_x[6], 3);
        idvd_poly_feat[3641] = pow(input_x[0], 4) * pow(input_x[6], 4);
        idvd_poly_feat[3642] = pow(input_x[0], 3) * pow(input_x[1], 5);
        idvd_poly_feat[3643] = pow(input_x[0], 3) * pow(input_x[1], 4) * pow(input_x[2], 1);
        idvd_poly_feat[3644] = pow(input_x[0], 3) * pow(input_x[1], 4) * pow(input_x[3], 1);
        idvd_poly_feat[3645] = pow(input_x[0], 3) * pow(input_x[1], 4) * pow(input_x[4], 1);
        idvd_poly_feat[3646] = pow(input_x[0], 3) * pow(input_x[1], 4) * pow(input_x[5], 1);
        idvd_poly_feat[3647] = pow(input_x[0], 3) * pow(input_x[1], 4) * pow(input_x[6], 1);
        idvd_poly_feat[3648] = pow(input_x[0], 3) * pow(input_x[1], 3) * pow(input_x[2], 2);
        idvd_poly_feat[3649] = pow(input_x[0], 3) * pow(input_x[1], 3) * pow(input_x[2], 1) * pow(input_x[3], 1);
        idvd_poly_feat[3650] = pow(input_x[0], 3) * pow(input_x[1], 3) * pow(input_x[2], 1) * pow(input_x[4], 1);
        idvd_poly_feat[3651] = pow(input_x[0], 3) * pow(input_x[1], 3) * pow(input_x[2], 1) * pow(input_x[5], 1);
        idvd_poly_feat[3652] = pow(input_x[0], 3) * pow(input_x[1], 3) * pow(input_x[2], 1) * pow(input_x[6], 1);
        idvd_poly_feat[3653] = pow(input_x[0], 3) * pow(input_x[1], 3) * pow(input_x[3], 2);
        idvd_poly_feat[3654] = pow(input_x[0], 3) * pow(input_x[1], 3) * pow(input_x[3], 1) * pow(input_x[4], 1);
        idvd_poly_feat[3655] = pow(input_x[0], 3) * pow(input_x[1], 3) * pow(input_x[3], 1) * pow(input_x[5], 1);
        idvd_poly_feat[3656] = pow(input_x[0], 3) * pow(input_x[1], 3) * pow(input_x[3], 1) * pow(input_x[6], 1);
        idvd_poly_feat[3657] = pow(input_x[0], 3) * pow(input_x[1], 3) * pow(input_x[4], 2);
        idvd_poly_feat[3658] = pow(input_x[0], 3) * pow(input_x[1], 3) * pow(input_x[4], 1) * pow(input_x[5], 1);
        idvd_poly_feat[3659] = pow(input_x[0], 3) * pow(input_x[1], 3) * pow(input_x[4], 1) * pow(input_x[6], 1);
        idvd_poly_feat[3660] = pow(input_x[0], 3) * pow(input_x[1], 3) * pow(input_x[5], 2);
        idvd_poly_feat[3661] = pow(input_x[0], 3) * pow(input_x[1], 3) * pow(input_x[5], 1) * pow(input_x[6], 1);
        idvd_poly_feat[3662] = pow(input_x[0], 3) * pow(input_x[1], 3) * pow(input_x[6], 2);
        idvd_poly_feat[3663] = pow(input_x[0], 3) * pow(input_x[1], 2) * pow(input_x[2], 3);
        idvd_poly_feat[3664] = pow(input_x[0], 3) * pow(input_x[1], 2) * pow(input_x[2], 2) * pow(input_x[3], 1);
        idvd_poly_feat[3665] = pow(input_x[0], 3) * pow(input_x[1], 2) * pow(input_x[2], 2) * pow(input_x[4], 1);
        idvd_poly_feat[3666] = pow(input_x[0], 3) * pow(input_x[1], 2) * pow(input_x[2], 2) * pow(input_x[5], 1);
        idvd_poly_feat[3667] = pow(input_x[0], 3) * pow(input_x[1], 2) * pow(input_x[2], 2) * pow(input_x[6], 1);
        idvd_poly_feat[3668] = pow(input_x[0], 3) * pow(input_x[1], 2) * pow(input_x[2], 1) * pow(input_x[3], 2);
        idvd_poly_feat[3669] = pow(input_x[0], 3) * pow(input_x[1], 2) * pow(input_x[2], 1) * pow(input_x[3], 1) * pow(input_x[4], 1);
        idvd_poly_feat[3670] = pow(input_x[0], 3) * pow(input_x[1], 2) * pow(input_x[2], 1) * pow(input_x[3], 1) * pow(input_x[5], 1);
        idvd_poly_feat[3671] = pow(input_x[0], 3) * pow(input_x[1], 2) * pow(input_x[2], 1) * pow(input_x[3], 1) * pow(input_x[6], 1);
        idvd_poly_feat[3672] = pow(input_x[0], 3) * pow(input_x[1], 2) * pow(input_x[2], 1) * pow(input_x[4], 2);
        idvd_poly_feat[3673] = pow(input_x[0], 3) * pow(input_x[1], 2) * pow(input_x[2], 1) * pow(input_x[4], 1) * pow(input_x[5], 1);
        idvd_poly_feat[3674] = pow(input_x[0], 3) * pow(input_x[1], 2) * pow(input_x[2], 1) * pow(input_x[4], 1) * pow(input_x[6], 1);
        idvd_poly_feat[3675] = pow(input_x[0], 3) * pow(input_x[1], 2) * pow(input_x[2], 1) * pow(input_x[5], 2);
        idvd_poly_feat[3676] = pow(input_x[0], 3) * pow(input_x[1], 2) * pow(input_x[2], 1) * pow(input_x[5], 1) * pow(input_x[6], 1);
        idvd_poly_feat[3677] = pow(input_x[0], 3) * pow(input_x[1], 2) * pow(input_x[2], 1) * pow(input_x[6], 2);
        idvd_poly_feat[3678] = pow(input_x[0], 3) * pow(input_x[1], 2) * pow(input_x[3], 3);
        idvd_poly_feat[3679] = pow(input_x[0], 3) * pow(input_x[1], 2) * pow(input_x[3], 2) * pow(input_x[4], 1);
        idvd_poly_feat[3680] = pow(input_x[0], 3) * pow(input_x[1], 2) * pow(input_x[3], 2) * pow(input_x[5], 1);
        idvd_poly_feat[3681] = pow(input_x[0], 3) * pow(input_x[1], 2) * pow(input_x[3], 2) * pow(input_x[6], 1);
        idvd_poly_feat[3682] = pow(input_x[0], 3) * pow(input_x[1], 2) * pow(input_x[3], 1) * pow(input_x[4], 2);
        idvd_poly_feat[3683] = pow(input_x[0], 3) * pow(input_x[1], 2) * pow(input_x[3], 1) * pow(input_x[4], 1) * pow(input_x[5], 1);
        idvd_poly_feat[3684] = pow(input_x[0], 3) * pow(input_x[1], 2) * pow(input_x[3], 1) * pow(input_x[4], 1) * pow(input_x[6], 1);
        idvd_poly_feat[3685] = pow(input_x[0], 3) * pow(input_x[1], 2) * pow(input_x[3], 1) * pow(input_x[5], 2);
        idvd_poly_feat[3686] = pow(input_x[0], 3) * pow(input_x[1], 2) * pow(input_x[3], 1) * pow(input_x[5], 1) * pow(input_x[6], 1);
        idvd_poly_feat[3687] = pow(input_x[0], 3) * pow(input_x[1], 2) * pow(input_x[3], 1) * pow(input_x[6], 2);
        idvd_poly_feat[3688] = pow(input_x[0], 3) * pow(input_x[1], 2) * pow(input_x[4], 3);
        idvd_poly_feat[3689] = pow(input_x[0], 3) * pow(input_x[1], 2) * pow(input_x[4], 2) * pow(input_x[5], 1);
        idvd_poly_feat[3690] = pow(input_x[0], 3) * pow(input_x[1], 2) * pow(input_x[4], 2) * pow(input_x[6], 1);
        idvd_poly_feat[3691] = pow(input_x[0], 3) * pow(input_x[1], 2) * pow(input_x[4], 1) * pow(input_x[5], 2);
        idvd_poly_feat[3692] = pow(input_x[0], 3) * pow(input_x[1], 2) * pow(input_x[4], 1) * pow(input_x[5], 1) * pow(input_x[6], 1);
        idvd_poly_feat[3693] = pow(input_x[0], 3) * pow(input_x[1], 2) * pow(input_x[4], 1) * pow(input_x[6], 2);
        idvd_poly_feat[3694] = pow(input_x[0], 3) * pow(input_x[1], 2) * pow(input_x[5], 3);
        idvd_poly_feat[3695] = pow(input_x[0], 3) * pow(input_x[1], 2) * pow(input_x[5], 2) * pow(input_x[6], 1);
        idvd_poly_feat[3696] = pow(input_x[0], 3) * pow(input_x[1], 2) * pow(input_x[5], 1) * pow(input_x[6], 2);
        idvd_poly_feat[3697] = pow(input_x[0], 3) * pow(input_x[1], 2) * pow(input_x[6], 3);
        idvd_poly_feat[3698] = pow(input_x[0], 3) * pow(input_x[1], 1) * pow(input_x[2], 4);
        idvd_poly_feat[3699] = pow(input_x[0], 3) * pow(input_x[1], 1) * pow(input_x[2], 3) * pow(input_x[3], 1);
        idvd_poly_feat[3700] = pow(input_x[0], 3) * pow(input_x[1], 1) * pow(input_x[2], 3) * pow(input_x[4], 1);
        idvd_poly_feat[3701] = pow(input_x[0], 3) * pow(input_x[1], 1) * pow(input_x[2], 3) * pow(input_x[5], 1);
        idvd_poly_feat[3702] = pow(input_x[0], 3) * pow(input_x[1], 1) * pow(input_x[2], 3) * pow(input_x[6], 1);
        idvd_poly_feat[3703] = pow(input_x[0], 3) * pow(input_x[1], 1) * pow(input_x[2], 2) * pow(input_x[3], 2);
        idvd_poly_feat[3704] = pow(input_x[0], 3) * pow(input_x[1], 1) * pow(input_x[2], 2) * pow(input_x[3], 1) * pow(input_x[4], 1);
        idvd_poly_feat[3705] = pow(input_x[0], 3) * pow(input_x[1], 1) * pow(input_x[2], 2) * pow(input_x[3], 1) * pow(input_x[5], 1);
        idvd_poly_feat[3706] = pow(input_x[0], 3) * pow(input_x[1], 1) * pow(input_x[2], 2) * pow(input_x[3], 1) * pow(input_x[6], 1);
        idvd_poly_feat[3707] = pow(input_x[0], 3) * pow(input_x[1], 1) * pow(input_x[2], 2) * pow(input_x[4], 2);
        idvd_poly_feat[3708] = pow(input_x[0], 3) * pow(input_x[1], 1) * pow(input_x[2], 2) * pow(input_x[4], 1) * pow(input_x[5], 1);
        idvd_poly_feat[3709] = pow(input_x[0], 3) * pow(input_x[1], 1) * pow(input_x[2], 2) * pow(input_x[4], 1) * pow(input_x[6], 1);
        idvd_poly_feat[3710] = pow(input_x[0], 3) * pow(input_x[1], 1) * pow(input_x[2], 2) * pow(input_x[5], 2);
        idvd_poly_feat[3711] = pow(input_x[0], 3) * pow(input_x[1], 1) * pow(input_x[2], 2) * pow(input_x[5], 1) * pow(input_x[6], 1);
        idvd_poly_feat[3712] = pow(input_x[0], 3) * pow(input_x[1], 1) * pow(input_x[2], 2) * pow(input_x[6], 2);
        idvd_poly_feat[3713] = pow(input_x[0], 3) * pow(input_x[1], 1) * pow(input_x[2], 1) * pow(input_x[3], 3);
        idvd_poly_feat[3714] = pow(input_x[0], 3) * pow(input_x[1], 1) * pow(input_x[2], 1) * pow(input_x[3], 2) * pow(input_x[4], 1);
        idvd_poly_feat[3715] = pow(input_x[0], 3) * pow(input_x[1], 1) * pow(input_x[2], 1) * pow(input_x[3], 2) * pow(input_x[5], 1);
        idvd_poly_feat[3716] = pow(input_x[0], 3) * pow(input_x[1], 1) * pow(input_x[2], 1) * pow(input_x[3], 2) * pow(input_x[6], 1);
        idvd_poly_feat[3717] = pow(input_x[0], 3) * pow(input_x[1], 1) * pow(input_x[2], 1) * pow(input_x[3], 1) * pow(input_x[4], 2);
        idvd_poly_feat[3718] = pow(input_x[0], 3) * pow(input_x[1], 1) * pow(input_x[2], 1) * pow(input_x[3], 1) * pow(input_x[4], 1) * pow(input_x[5], 1);
        idvd_poly_feat[3719] = pow(input_x[0], 3) * pow(input_x[1], 1) * pow(input_x[2], 1) * pow(input_x[3], 1) * pow(input_x[4], 1) * pow(input_x[6], 1);
        idvd_poly_feat[3720] = pow(input_x[0], 3) * pow(input_x[1], 1) * pow(input_x[2], 1) * pow(input_x[3], 1) * pow(input_x[5], 2);
        idvd_poly_feat[3721] = pow(input_x[0], 3) * pow(input_x[1], 1) * pow(input_x[2], 1) * pow(input_x[3], 1) * pow(input_x[5], 1) * pow(input_x[6], 1);
        idvd_poly_feat[3722] = pow(input_x[0], 3) * pow(input_x[1], 1) * pow(input_x[2], 1) * pow(input_x[3], 1) * pow(input_x[6], 2);
        idvd_poly_feat[3723] = pow(input_x[0], 3) * pow(input_x[1], 1) * pow(input_x[2], 1) * pow(input_x[4], 3);
        idvd_poly_feat[3724] = pow(input_x[0], 3) * pow(input_x[1], 1) * pow(input_x[2], 1) * pow(input_x[4], 2) * pow(input_x[5], 1);
        idvd_poly_feat[3725] = pow(input_x[0], 3) * pow(input_x[1], 1) * pow(input_x[2], 1) * pow(input_x[4], 2) * pow(input_x[6], 1);
        idvd_poly_feat[3726] = pow(input_x[0], 3) * pow(input_x[1], 1) * pow(input_x[2], 1) * pow(input_x[4], 1) * pow(input_x[5], 2);
        idvd_poly_feat[3727] = pow(input_x[0], 3) * pow(input_x[1], 1) * pow(input_x[2], 1) * pow(input_x[4], 1) * pow(input_x[5], 1) * pow(input_x[6], 1);
        idvd_poly_feat[3728] = pow(input_x[0], 3) * pow(input_x[1], 1) * pow(input_x[2], 1) * pow(input_x[4], 1) * pow(input_x[6], 2);
        idvd_poly_feat[3729] = pow(input_x[0], 3) * pow(input_x[1], 1) * pow(input_x[2], 1) * pow(input_x[5], 3);
        idvd_poly_feat[3730] = pow(input_x[0], 3) * pow(input_x[1], 1) * pow(input_x[2], 1) * pow(input_x[5], 2) * pow(input_x[6], 1);
        idvd_poly_feat[3731] = pow(input_x[0], 3) * pow(input_x[1], 1) * pow(input_x[2], 1) * pow(input_x[5], 1) * pow(input_x[6], 2);
        idvd_poly_feat[3732] = pow(input_x[0], 3) * pow(input_x[1], 1) * pow(input_x[2], 1) * pow(input_x[6], 3);
        idvd_poly_feat[3733] = pow(input_x[0], 3) * pow(input_x[1], 1) * pow(input_x[3], 4);
        idvd_poly_feat[3734] = pow(input_x[0], 3) * pow(input_x[1], 1) * pow(input_x[3], 3) * pow(input_x[4], 1);
        idvd_poly_feat[3735] = pow(input_x[0], 3) * pow(input_x[1], 1) * pow(input_x[3], 3) * pow(input_x[5], 1);
        idvd_poly_feat[3736] = pow(input_x[0], 3) * pow(input_x[1], 1) * pow(input_x[3], 3) * pow(input_x[6], 1);
        idvd_poly_feat[3737] = pow(input_x[0], 3) * pow(input_x[1], 1) * pow(input_x[3], 2) * pow(input_x[4], 2);
        idvd_poly_feat[3738] = pow(input_x[0], 3) * pow(input_x[1], 1) * pow(input_x[3], 2) * pow(input_x[4], 1) * pow(input_x[5], 1);
        idvd_poly_feat[3739] = pow(input_x[0], 3) * pow(input_x[1], 1) * pow(input_x[3], 2) * pow(input_x[4], 1) * pow(input_x[6], 1);
        idvd_poly_feat[3740] = pow(input_x[0], 3) * pow(input_x[1], 1) * pow(input_x[3], 2) * pow(input_x[5], 2);
        idvd_poly_feat[3741] = pow(input_x[0], 3) * pow(input_x[1], 1) * pow(input_x[3], 2) * pow(input_x[5], 1) * pow(input_x[6], 1);
        idvd_poly_feat[3742] = pow(input_x[0], 3) * pow(input_x[1], 1) * pow(input_x[3], 2) * pow(input_x[6], 2);
        idvd_poly_feat[3743] = pow(input_x[0], 3) * pow(input_x[1], 1) * pow(input_x[3], 1) * pow(input_x[4], 3);
        idvd_poly_feat[3744] = pow(input_x[0], 3) * pow(input_x[1], 1) * pow(input_x[3], 1) * pow(input_x[4], 2) * pow(input_x[5], 1);
        idvd_poly_feat[3745] = pow(input_x[0], 3) * pow(input_x[1], 1) * pow(input_x[3], 1) * pow(input_x[4], 2) * pow(input_x[6], 1);
        idvd_poly_feat[3746] = pow(input_x[0], 3) * pow(input_x[1], 1) * pow(input_x[3], 1) * pow(input_x[4], 1) * pow(input_x[5], 2);
        idvd_poly_feat[3747] = pow(input_x[0], 3) * pow(input_x[1], 1) * pow(input_x[3], 1) * pow(input_x[4], 1) * pow(input_x[5], 1) * pow(input_x[6], 1);
        idvd_poly_feat[3748] = pow(input_x[0], 3) * pow(input_x[1], 1) * pow(input_x[3], 1) * pow(input_x[4], 1) * pow(input_x[6], 2);
        idvd_poly_feat[3749] = pow(input_x[0], 3) * pow(input_x[1], 1) * pow(input_x[3], 1) * pow(input_x[5], 3);
        idvd_poly_feat[3750] = pow(input_x[0], 3) * pow(input_x[1], 1) * pow(input_x[3], 1) * pow(input_x[5], 2) * pow(input_x[6], 1);
        idvd_poly_feat[3751] = pow(input_x[0], 3) * pow(input_x[1], 1) * pow(input_x[3], 1) * pow(input_x[5], 1) * pow(input_x[6], 2);
        idvd_poly_feat[3752] = pow(input_x[0], 3) * pow(input_x[1], 1) * pow(input_x[3], 1) * pow(input_x[6], 3);
        idvd_poly_feat[3753] = pow(input_x[0], 3) * pow(input_x[1], 1) * pow(input_x[4], 4);
        idvd_poly_feat[3754] = pow(input_x[0], 3) * pow(input_x[1], 1) * pow(input_x[4], 3) * pow(input_x[5], 1);
        idvd_poly_feat[3755] = pow(input_x[0], 3) * pow(input_x[1], 1) * pow(input_x[4], 3) * pow(input_x[6], 1);
        idvd_poly_feat[3756] = pow(input_x[0], 3) * pow(input_x[1], 1) * pow(input_x[4], 2) * pow(input_x[5], 2);
        idvd_poly_feat[3757] = pow(input_x[0], 3) * pow(input_x[1], 1) * pow(input_x[4], 2) * pow(input_x[5], 1) * pow(input_x[6], 1);
        idvd_poly_feat[3758] = pow(input_x[0], 3) * pow(input_x[1], 1) * pow(input_x[4], 2) * pow(input_x[6], 2);
        idvd_poly_feat[3759] = pow(input_x[0], 3) * pow(input_x[1], 1) * pow(input_x[4], 1) * pow(input_x[5], 3);
        idvd_poly_feat[3760] = pow(input_x[0], 3) * pow(input_x[1], 1) * pow(input_x[4], 1) * pow(input_x[5], 2) * pow(input_x[6], 1);
        idvd_poly_feat[3761] = pow(input_x[0], 3) * pow(input_x[1], 1) * pow(input_x[4], 1) * pow(input_x[5], 1) * pow(input_x[6], 2);
        idvd_poly_feat[3762] = pow(input_x[0], 3) * pow(input_x[1], 1) * pow(input_x[4], 1) * pow(input_x[6], 3);
        idvd_poly_feat[3763] = pow(input_x[0], 3) * pow(input_x[1], 1) * pow(input_x[5], 4);
        idvd_poly_feat[3764] = pow(input_x[0], 3) * pow(input_x[1], 1) * pow(input_x[5], 3) * pow(input_x[6], 1);
        idvd_poly_feat[3765] = pow(input_x[0], 3) * pow(input_x[1], 1) * pow(input_x[5], 2) * pow(input_x[6], 2);
        idvd_poly_feat[3766] = pow(input_x[0], 3) * pow(input_x[1], 1) * pow(input_x[5], 1) * pow(input_x[6], 3);
        idvd_poly_feat[3767] = pow(input_x[0], 3) * pow(input_x[1], 1) * pow(input_x[6], 4);
        idvd_poly_feat[3768] = pow(input_x[0], 3) * pow(input_x[2], 5);
        idvd_poly_feat[3769] = pow(input_x[0], 3) * pow(input_x[2], 4) * pow(input_x[3], 1);
        idvd_poly_feat[3770] = pow(input_x[0], 3) * pow(input_x[2], 4) * pow(input_x[4], 1);
        idvd_poly_feat[3771] = pow(input_x[0], 3) * pow(input_x[2], 4) * pow(input_x[5], 1);
        idvd_poly_feat[3772] = pow(input_x[0], 3) * pow(input_x[2], 4) * pow(input_x[6], 1);
        idvd_poly_feat[3773] = pow(input_x[0], 3) * pow(input_x[2], 3) * pow(input_x[3], 2);
        idvd_poly_feat[3774] = pow(input_x[0], 3) * pow(input_x[2], 3) * pow(input_x[3], 1) * pow(input_x[4], 1);
        idvd_poly_feat[3775] = pow(input_x[0], 3) * pow(input_x[2], 3) * pow(input_x[3], 1) * pow(input_x[5], 1);
        idvd_poly_feat[3776] = pow(input_x[0], 3) * pow(input_x[2], 3) * pow(input_x[3], 1) * pow(input_x[6], 1);
        idvd_poly_feat[3777] = pow(input_x[0], 3) * pow(input_x[2], 3) * pow(input_x[4], 2);
        idvd_poly_feat[3778] = pow(input_x[0], 3) * pow(input_x[2], 3) * pow(input_x[4], 1) * pow(input_x[5], 1);
        idvd_poly_feat[3779] = pow(input_x[0], 3) * pow(input_x[2], 3) * pow(input_x[4], 1) * pow(input_x[6], 1);
        idvd_poly_feat[3780] = pow(input_x[0], 3) * pow(input_x[2], 3) * pow(input_x[5], 2);
        idvd_poly_feat[3781] = pow(input_x[0], 3) * pow(input_x[2], 3) * pow(input_x[5], 1) * pow(input_x[6], 1);
        idvd_poly_feat[3782] = pow(input_x[0], 3) * pow(input_x[2], 3) * pow(input_x[6], 2);
        idvd_poly_feat[3783] = pow(input_x[0], 3) * pow(input_x[2], 2) * pow(input_x[3], 3);
        idvd_poly_feat[3784] = pow(input_x[0], 3) * pow(input_x[2], 2) * pow(input_x[3], 2) * pow(input_x[4], 1);
        idvd_poly_feat[3785] = pow(input_x[0], 3) * pow(input_x[2], 2) * pow(input_x[3], 2) * pow(input_x[5], 1);
        idvd_poly_feat[3786] = pow(input_x[0], 3) * pow(input_x[2], 2) * pow(input_x[3], 2) * pow(input_x[6], 1);
        idvd_poly_feat[3787] = pow(input_x[0], 3) * pow(input_x[2], 2) * pow(input_x[3], 1) * pow(input_x[4], 2);
        idvd_poly_feat[3788] = pow(input_x[0], 3) * pow(input_x[2], 2) * pow(input_x[3], 1) * pow(input_x[4], 1) * pow(input_x[5], 1);
        idvd_poly_feat[3789] = pow(input_x[0], 3) * pow(input_x[2], 2) * pow(input_x[3], 1) * pow(input_x[4], 1) * pow(input_x[6], 1);
        idvd_poly_feat[3790] = pow(input_x[0], 3) * pow(input_x[2], 2) * pow(input_x[3], 1) * pow(input_x[5], 2);
        idvd_poly_feat[3791] = pow(input_x[0], 3) * pow(input_x[2], 2) * pow(input_x[3], 1) * pow(input_x[5], 1) * pow(input_x[6], 1);
        idvd_poly_feat[3792] = pow(input_x[0], 3) * pow(input_x[2], 2) * pow(input_x[3], 1) * pow(input_x[6], 2);
        idvd_poly_feat[3793] = pow(input_x[0], 3) * pow(input_x[2], 2) * pow(input_x[4], 3);
        idvd_poly_feat[3794] = pow(input_x[0], 3) * pow(input_x[2], 2) * pow(input_x[4], 2) * pow(input_x[5], 1);
        idvd_poly_feat[3795] = pow(input_x[0], 3) * pow(input_x[2], 2) * pow(input_x[4], 2) * pow(input_x[6], 1);
        idvd_poly_feat[3796] = pow(input_x[0], 3) * pow(input_x[2], 2) * pow(input_x[4], 1) * pow(input_x[5], 2);
        idvd_poly_feat[3797] = pow(input_x[0], 3) * pow(input_x[2], 2) * pow(input_x[4], 1) * pow(input_x[5], 1) * pow(input_x[6], 1);
        idvd_poly_feat[3798] = pow(input_x[0], 3) * pow(input_x[2], 2) * pow(input_x[4], 1) * pow(input_x[6], 2);
        idvd_poly_feat[3799] = pow(input_x[0], 3) * pow(input_x[2], 2) * pow(input_x[5], 3);
        idvd_poly_feat[3800] = pow(input_x[0], 3) * pow(input_x[2], 2) * pow(input_x[5], 2) * pow(input_x[6], 1);
        idvd_poly_feat[3801] = pow(input_x[0], 3) * pow(input_x[2], 2) * pow(input_x[5], 1) * pow(input_x[6], 2);
        idvd_poly_feat[3802] = pow(input_x[0], 3) * pow(input_x[2], 2) * pow(input_x[6], 3);
        idvd_poly_feat[3803] = pow(input_x[0], 3) * pow(input_x[2], 1) * pow(input_x[3], 4);
        idvd_poly_feat[3804] = pow(input_x[0], 3) * pow(input_x[2], 1) * pow(input_x[3], 3) * pow(input_x[4], 1);
        idvd_poly_feat[3805] = pow(input_x[0], 3) * pow(input_x[2], 1) * pow(input_x[3], 3) * pow(input_x[5], 1);
        idvd_poly_feat[3806] = pow(input_x[0], 3) * pow(input_x[2], 1) * pow(input_x[3], 3) * pow(input_x[6], 1);
        idvd_poly_feat[3807] = pow(input_x[0], 3) * pow(input_x[2], 1) * pow(input_x[3], 2) * pow(input_x[4], 2);
        idvd_poly_feat[3808] = pow(input_x[0], 3) * pow(input_x[2], 1) * pow(input_x[3], 2) * pow(input_x[4], 1) * pow(input_x[5], 1);
        idvd_poly_feat[3809] = pow(input_x[0], 3) * pow(input_x[2], 1) * pow(input_x[3], 2) * pow(input_x[4], 1) * pow(input_x[6], 1);
        idvd_poly_feat[3810] = pow(input_x[0], 3) * pow(input_x[2], 1) * pow(input_x[3], 2) * pow(input_x[5], 2);
        idvd_poly_feat[3811] = pow(input_x[0], 3) * pow(input_x[2], 1) * pow(input_x[3], 2) * pow(input_x[5], 1) * pow(input_x[6], 1);
        idvd_poly_feat[3812] = pow(input_x[0], 3) * pow(input_x[2], 1) * pow(input_x[3], 2) * pow(input_x[6], 2);
        idvd_poly_feat[3813] = pow(input_x[0], 3) * pow(input_x[2], 1) * pow(input_x[3], 1) * pow(input_x[4], 3);
        idvd_poly_feat[3814] = pow(input_x[0], 3) * pow(input_x[2], 1) * pow(input_x[3], 1) * pow(input_x[4], 2) * pow(input_x[5], 1);
        idvd_poly_feat[3815] = pow(input_x[0], 3) * pow(input_x[2], 1) * pow(input_x[3], 1) * pow(input_x[4], 2) * pow(input_x[6], 1);
        idvd_poly_feat[3816] = pow(input_x[0], 3) * pow(input_x[2], 1) * pow(input_x[3], 1) * pow(input_x[4], 1) * pow(input_x[5], 2);
        idvd_poly_feat[3817] = pow(input_x[0], 3) * pow(input_x[2], 1) * pow(input_x[3], 1) * pow(input_x[4], 1) * pow(input_x[5], 1) * pow(input_x[6], 1);
        idvd_poly_feat[3818] = pow(input_x[0], 3) * pow(input_x[2], 1) * pow(input_x[3], 1) * pow(input_x[4], 1) * pow(input_x[6], 2);
        idvd_poly_feat[3819] = pow(input_x[0], 3) * pow(input_x[2], 1) * pow(input_x[3], 1) * pow(input_x[5], 3);
        idvd_poly_feat[3820] = pow(input_x[0], 3) * pow(input_x[2], 1) * pow(input_x[3], 1) * pow(input_x[5], 2) * pow(input_x[6], 1);
        idvd_poly_feat[3821] = pow(input_x[0], 3) * pow(input_x[2], 1) * pow(input_x[3], 1) * pow(input_x[5], 1) * pow(input_x[6], 2);
        idvd_poly_feat[3822] = pow(input_x[0], 3) * pow(input_x[2], 1) * pow(input_x[3], 1) * pow(input_x[6], 3);
        idvd_poly_feat[3823] = pow(input_x[0], 3) * pow(input_x[2], 1) * pow(input_x[4], 4);
        idvd_poly_feat[3824] = pow(input_x[0], 3) * pow(input_x[2], 1) * pow(input_x[4], 3) * pow(input_x[5], 1);
        idvd_poly_feat[3825] = pow(input_x[0], 3) * pow(input_x[2], 1) * pow(input_x[4], 3) * pow(input_x[6], 1);
        idvd_poly_feat[3826] = pow(input_x[0], 3) * pow(input_x[2], 1) * pow(input_x[4], 2) * pow(input_x[5], 2);
        idvd_poly_feat[3827] = pow(input_x[0], 3) * pow(input_x[2], 1) * pow(input_x[4], 2) * pow(input_x[5], 1) * pow(input_x[6], 1);
        idvd_poly_feat[3828] = pow(input_x[0], 3) * pow(input_x[2], 1) * pow(input_x[4], 2) * pow(input_x[6], 2);
        idvd_poly_feat[3829] = pow(input_x[0], 3) * pow(input_x[2], 1) * pow(input_x[4], 1) * pow(input_x[5], 3);
        idvd_poly_feat[3830] = pow(input_x[0], 3) * pow(input_x[2], 1) * pow(input_x[4], 1) * pow(input_x[5], 2) * pow(input_x[6], 1);
        idvd_poly_feat[3831] = pow(input_x[0], 3) * pow(input_x[2], 1) * pow(input_x[4], 1) * pow(input_x[5], 1) * pow(input_x[6], 2);
        idvd_poly_feat[3832] = pow(input_x[0], 3) * pow(input_x[2], 1) * pow(input_x[4], 1) * pow(input_x[6], 3);
        idvd_poly_feat[3833] = pow(input_x[0], 3) * pow(input_x[2], 1) * pow(input_x[5], 4);
        idvd_poly_feat[3834] = pow(input_x[0], 3) * pow(input_x[2], 1) * pow(input_x[5], 3) * pow(input_x[6], 1);
        idvd_poly_feat[3835] = pow(input_x[0], 3) * pow(input_x[2], 1) * pow(input_x[5], 2) * pow(input_x[6], 2);
        idvd_poly_feat[3836] = pow(input_x[0], 3) * pow(input_x[2], 1) * pow(input_x[5], 1) * pow(input_x[6], 3);
        idvd_poly_feat[3837] = pow(input_x[0], 3) * pow(input_x[2], 1) * pow(input_x[6], 4);
        idvd_poly_feat[3838] = pow(input_x[0], 3) * pow(input_x[3], 5);
        idvd_poly_feat[3839] = pow(input_x[0], 3) * pow(input_x[3], 4) * pow(input_x[4], 1);
        idvd_poly_feat[3840] = pow(input_x[0], 3) * pow(input_x[3], 4) * pow(input_x[5], 1);
        idvd_poly_feat[3841] = pow(input_x[0], 3) * pow(input_x[3], 4) * pow(input_x[6], 1);
        idvd_poly_feat[3842] = pow(input_x[0], 3) * pow(input_x[3], 3) * pow(input_x[4], 2);
        idvd_poly_feat[3843] = pow(input_x[0], 3) * pow(input_x[3], 3) * pow(input_x[4], 1) * pow(input_x[5], 1);
        idvd_poly_feat[3844] = pow(input_x[0], 3) * pow(input_x[3], 3) * pow(input_x[4], 1) * pow(input_x[6], 1);
        idvd_poly_feat[3845] = pow(input_x[0], 3) * pow(input_x[3], 3) * pow(input_x[5], 2);
        idvd_poly_feat[3846] = pow(input_x[0], 3) * pow(input_x[3], 3) * pow(input_x[5], 1) * pow(input_x[6], 1);
        idvd_poly_feat[3847] = pow(input_x[0], 3) * pow(input_x[3], 3) * pow(input_x[6], 2);
        idvd_poly_feat[3848] = pow(input_x[0], 3) * pow(input_x[3], 2) * pow(input_x[4], 3);
        idvd_poly_feat[3849] = pow(input_x[0], 3) * pow(input_x[3], 2) * pow(input_x[4], 2) * pow(input_x[5], 1);
        idvd_poly_feat[3850] = pow(input_x[0], 3) * pow(input_x[3], 2) * pow(input_x[4], 2) * pow(input_x[6], 1);
        idvd_poly_feat[3851] = pow(input_x[0], 3) * pow(input_x[3], 2) * pow(input_x[4], 1) * pow(input_x[5], 2);
        idvd_poly_feat[3852] = pow(input_x[0], 3) * pow(input_x[3], 2) * pow(input_x[4], 1) * pow(input_x[5], 1) * pow(input_x[6], 1);
        idvd_poly_feat[3853] = pow(input_x[0], 3) * pow(input_x[3], 2) * pow(input_x[4], 1) * pow(input_x[6], 2);
        idvd_poly_feat[3854] = pow(input_x[0], 3) * pow(input_x[3], 2) * pow(input_x[5], 3);
        idvd_poly_feat[3855] = pow(input_x[0], 3) * pow(input_x[3], 2) * pow(input_x[5], 2) * pow(input_x[6], 1);
        idvd_poly_feat[3856] = pow(input_x[0], 3) * pow(input_x[3], 2) * pow(input_x[5], 1) * pow(input_x[6], 2);
        idvd_poly_feat[3857] = pow(input_x[0], 3) * pow(input_x[3], 2) * pow(input_x[6], 3);
        idvd_poly_feat[3858] = pow(input_x[0], 3) * pow(input_x[3], 1) * pow(input_x[4], 4);
        idvd_poly_feat[3859] = pow(input_x[0], 3) * pow(input_x[3], 1) * pow(input_x[4], 3) * pow(input_x[5], 1);
        idvd_poly_feat[3860] = pow(input_x[0], 3) * pow(input_x[3], 1) * pow(input_x[4], 3) * pow(input_x[6], 1);
        idvd_poly_feat[3861] = pow(input_x[0], 3) * pow(input_x[3], 1) * pow(input_x[4], 2) * pow(input_x[5], 2);
        idvd_poly_feat[3862] = pow(input_x[0], 3) * pow(input_x[3], 1) * pow(input_x[4], 2) * pow(input_x[5], 1) * pow(input_x[6], 1);
        idvd_poly_feat[3863] = pow(input_x[0], 3) * pow(input_x[3], 1) * pow(input_x[4], 2) * pow(input_x[6], 2);
        idvd_poly_feat[3864] = pow(input_x[0], 3) * pow(input_x[3], 1) * pow(input_x[4], 1) * pow(input_x[5], 3);
        idvd_poly_feat[3865] = pow(input_x[0], 3) * pow(input_x[3], 1) * pow(input_x[4], 1) * pow(input_x[5], 2) * pow(input_x[6], 1);
        idvd_poly_feat[3866] = pow(input_x[0], 3) * pow(input_x[3], 1) * pow(input_x[4], 1) * pow(input_x[5], 1) * pow(input_x[6], 2);
        idvd_poly_feat[3867] = pow(input_x[0], 3) * pow(input_x[3], 1) * pow(input_x[4], 1) * pow(input_x[6], 3);
        idvd_poly_feat[3868] = pow(input_x[0], 3) * pow(input_x[3], 1) * pow(input_x[5], 4);
        idvd_poly_feat[3869] = pow(input_x[0], 3) * pow(input_x[3], 1) * pow(input_x[5], 3) * pow(input_x[6], 1);
        idvd_poly_feat[3870] = pow(input_x[0], 3) * pow(input_x[3], 1) * pow(input_x[5], 2) * pow(input_x[6], 2);
        idvd_poly_feat[3871] = pow(input_x[0], 3) * pow(input_x[3], 1) * pow(input_x[5], 1) * pow(input_x[6], 3);
        idvd_poly_feat[3872] = pow(input_x[0], 3) * pow(input_x[3], 1) * pow(input_x[6], 4);
        idvd_poly_feat[3873] = pow(input_x[0], 3) * pow(input_x[4], 5);
        idvd_poly_feat[3874] = pow(input_x[0], 3) * pow(input_x[4], 4) * pow(input_x[5], 1);
        idvd_poly_feat[3875] = pow(input_x[0], 3) * pow(input_x[4], 4) * pow(input_x[6], 1);
        idvd_poly_feat[3876] = pow(input_x[0], 3) * pow(input_x[4], 3) * pow(input_x[5], 2);
        idvd_poly_feat[3877] = pow(input_x[0], 3) * pow(input_x[4], 3) * pow(input_x[5], 1) * pow(input_x[6], 1);
        idvd_poly_feat[3878] = pow(input_x[0], 3) * pow(input_x[4], 3) * pow(input_x[6], 2);
        idvd_poly_feat[3879] = pow(input_x[0], 3) * pow(input_x[4], 2) * pow(input_x[5], 3);
        idvd_poly_feat[3880] = pow(input_x[0], 3) * pow(input_x[4], 2) * pow(input_x[5], 2) * pow(input_x[6], 1);
        idvd_poly_feat[3881] = pow(input_x[0], 3) * pow(input_x[4], 2) * pow(input_x[5], 1) * pow(input_x[6], 2);
        idvd_poly_feat[3882] = pow(input_x[0], 3) * pow(input_x[4], 2) * pow(input_x[6], 3);
        idvd_poly_feat[3883] = pow(input_x[0], 3) * pow(input_x[4], 1) * pow(input_x[5], 4);
        idvd_poly_feat[3884] = pow(input_x[0], 3) * pow(input_x[4], 1) * pow(input_x[5], 3) * pow(input_x[6], 1);
        idvd_poly_feat[3885] = pow(input_x[0], 3) * pow(input_x[4], 1) * pow(input_x[5], 2) * pow(input_x[6], 2);
        idvd_poly_feat[3886] = pow(input_x[0], 3) * pow(input_x[4], 1) * pow(input_x[5], 1) * pow(input_x[6], 3);
        idvd_poly_feat[3887] = pow(input_x[0], 3) * pow(input_x[4], 1) * pow(input_x[6], 4);
        idvd_poly_feat[3888] = pow(input_x[0], 3) * pow(input_x[5], 5);
        idvd_poly_feat[3889] = pow(input_x[0], 3) * pow(input_x[5], 4) * pow(input_x[6], 1);
        idvd_poly_feat[3890] = pow(input_x[0], 3) * pow(input_x[5], 3) * pow(input_x[6], 2);
        idvd_poly_feat[3891] = pow(input_x[0], 3) * pow(input_x[5], 2) * pow(input_x[6], 3);
        idvd_poly_feat[3892] = pow(input_x[0], 3) * pow(input_x[5], 1) * pow(input_x[6], 4);
        idvd_poly_feat[3893] = pow(input_x[0], 3) * pow(input_x[6], 5);
        idvd_poly_feat[3894] = pow(input_x[0], 2) * pow(input_x[1], 6);
        idvd_poly_feat[3895] = pow(input_x[0], 2) * pow(input_x[1], 5) * pow(input_x[2], 1);
        idvd_poly_feat[3896] = pow(input_x[0], 2) * pow(input_x[1], 5) * pow(input_x[3], 1);
        idvd_poly_feat[3897] = pow(input_x[0], 2) * pow(input_x[1], 5) * pow(input_x[4], 1);
        idvd_poly_feat[3898] = pow(input_x[0], 2) * pow(input_x[1], 5) * pow(input_x[5], 1);
        idvd_poly_feat[3899] = pow(input_x[0], 2) * pow(input_x[1], 5) * pow(input_x[6], 1);
        idvd_poly_feat[3900] = pow(input_x[0], 2) * pow(input_x[1], 4) * pow(input_x[2], 2);
        idvd_poly_feat[3901] = pow(input_x[0], 2) * pow(input_x[1], 4) * pow(input_x[2], 1) * pow(input_x[3], 1);
        idvd_poly_feat[3902] = pow(input_x[0], 2) * pow(input_x[1], 4) * pow(input_x[2], 1) * pow(input_x[4], 1);
        idvd_poly_feat[3903] = pow(input_x[0], 2) * pow(input_x[1], 4) * pow(input_x[2], 1) * pow(input_x[5], 1);
        idvd_poly_feat[3904] = pow(input_x[0], 2) * pow(input_x[1], 4) * pow(input_x[2], 1) * pow(input_x[6], 1);
        idvd_poly_feat[3905] = pow(input_x[0], 2) * pow(input_x[1], 4) * pow(input_x[3], 2);
        idvd_poly_feat[3906] = pow(input_x[0], 2) * pow(input_x[1], 4) * pow(input_x[3], 1) * pow(input_x[4], 1);
        idvd_poly_feat[3907] = pow(input_x[0], 2) * pow(input_x[1], 4) * pow(input_x[3], 1) * pow(input_x[5], 1);
        idvd_poly_feat[3908] = pow(input_x[0], 2) * pow(input_x[1], 4) * pow(input_x[3], 1) * pow(input_x[6], 1);
        idvd_poly_feat[3909] = pow(input_x[0], 2) * pow(input_x[1], 4) * pow(input_x[4], 2);
        idvd_poly_feat[3910] = pow(input_x[0], 2) * pow(input_x[1], 4) * pow(input_x[4], 1) * pow(input_x[5], 1);
        idvd_poly_feat[3911] = pow(input_x[0], 2) * pow(input_x[1], 4) * pow(input_x[4], 1) * pow(input_x[6], 1);
        idvd_poly_feat[3912] = pow(input_x[0], 2) * pow(input_x[1], 4) * pow(input_x[5], 2);
        idvd_poly_feat[3913] = pow(input_x[0], 2) * pow(input_x[1], 4) * pow(input_x[5], 1) * pow(input_x[6], 1);
        idvd_poly_feat[3914] = pow(input_x[0], 2) * pow(input_x[1], 4) * pow(input_x[6], 2);
        idvd_poly_feat[3915] = pow(input_x[0], 2) * pow(input_x[1], 3) * pow(input_x[2], 3);
        idvd_poly_feat[3916] = pow(input_x[0], 2) * pow(input_x[1], 3) * pow(input_x[2], 2) * pow(input_x[3], 1);
        idvd_poly_feat[3917] = pow(input_x[0], 2) * pow(input_x[1], 3) * pow(input_x[2], 2) * pow(input_x[4], 1);
        idvd_poly_feat[3918] = pow(input_x[0], 2) * pow(input_x[1], 3) * pow(input_x[2], 2) * pow(input_x[5], 1);
        idvd_poly_feat[3919] = pow(input_x[0], 2) * pow(input_x[1], 3) * pow(input_x[2], 2) * pow(input_x[6], 1);
        idvd_poly_feat[3920] = pow(input_x[0], 2) * pow(input_x[1], 3) * pow(input_x[2], 1) * pow(input_x[3], 2);
        idvd_poly_feat[3921] = pow(input_x[0], 2) * pow(input_x[1], 3) * pow(input_x[2], 1) * pow(input_x[3], 1) * pow(input_x[4], 1);
        idvd_poly_feat[3922] = pow(input_x[0], 2) * pow(input_x[1], 3) * pow(input_x[2], 1) * pow(input_x[3], 1) * pow(input_x[5], 1);
        idvd_poly_feat[3923] = pow(input_x[0], 2) * pow(input_x[1], 3) * pow(input_x[2], 1) * pow(input_x[3], 1) * pow(input_x[6], 1);
        idvd_poly_feat[3924] = pow(input_x[0], 2) * pow(input_x[1], 3) * pow(input_x[2], 1) * pow(input_x[4], 2);
        idvd_poly_feat[3925] = pow(input_x[0], 2) * pow(input_x[1], 3) * pow(input_x[2], 1) * pow(input_x[4], 1) * pow(input_x[5], 1);
        idvd_poly_feat[3926] = pow(input_x[0], 2) * pow(input_x[1], 3) * pow(input_x[2], 1) * pow(input_x[4], 1) * pow(input_x[6], 1);
        idvd_poly_feat[3927] = pow(input_x[0], 2) * pow(input_x[1], 3) * pow(input_x[2], 1) * pow(input_x[5], 2);
        idvd_poly_feat[3928] = pow(input_x[0], 2) * pow(input_x[1], 3) * pow(input_x[2], 1) * pow(input_x[5], 1) * pow(input_x[6], 1);
        idvd_poly_feat[3929] = pow(input_x[0], 2) * pow(input_x[1], 3) * pow(input_x[2], 1) * pow(input_x[6], 2);
        idvd_poly_feat[3930] = pow(input_x[0], 2) * pow(input_x[1], 3) * pow(input_x[3], 3);
        idvd_poly_feat[3931] = pow(input_x[0], 2) * pow(input_x[1], 3) * pow(input_x[3], 2) * pow(input_x[4], 1);
        idvd_poly_feat[3932] = pow(input_x[0], 2) * pow(input_x[1], 3) * pow(input_x[3], 2) * pow(input_x[5], 1);
        idvd_poly_feat[3933] = pow(input_x[0], 2) * pow(input_x[1], 3) * pow(input_x[3], 2) * pow(input_x[6], 1);
        idvd_poly_feat[3934] = pow(input_x[0], 2) * pow(input_x[1], 3) * pow(input_x[3], 1) * pow(input_x[4], 2);
        idvd_poly_feat[3935] = pow(input_x[0], 2) * pow(input_x[1], 3) * pow(input_x[3], 1) * pow(input_x[4], 1) * pow(input_x[5], 1);
        idvd_poly_feat[3936] = pow(input_x[0], 2) * pow(input_x[1], 3) * pow(input_x[3], 1) * pow(input_x[4], 1) * pow(input_x[6], 1);
        idvd_poly_feat[3937] = pow(input_x[0], 2) * pow(input_x[1], 3) * pow(input_x[3], 1) * pow(input_x[5], 2);
        idvd_poly_feat[3938] = pow(input_x[0], 2) * pow(input_x[1], 3) * pow(input_x[3], 1) * pow(input_x[5], 1) * pow(input_x[6], 1);
        idvd_poly_feat[3939] = pow(input_x[0], 2) * pow(input_x[1], 3) * pow(input_x[3], 1) * pow(input_x[6], 2);
        idvd_poly_feat[3940] = pow(input_x[0], 2) * pow(input_x[1], 3) * pow(input_x[4], 3);
        idvd_poly_feat[3941] = pow(input_x[0], 2) * pow(input_x[1], 3) * pow(input_x[4], 2) * pow(input_x[5], 1);
        idvd_poly_feat[3942] = pow(input_x[0], 2) * pow(input_x[1], 3) * pow(input_x[4], 2) * pow(input_x[6], 1);
        idvd_poly_feat[3943] = pow(input_x[0], 2) * pow(input_x[1], 3) * pow(input_x[4], 1) * pow(input_x[5], 2);
        idvd_poly_feat[3944] = pow(input_x[0], 2) * pow(input_x[1], 3) * pow(input_x[4], 1) * pow(input_x[5], 1) * pow(input_x[6], 1);
        idvd_poly_feat[3945] = pow(input_x[0], 2) * pow(input_x[1], 3) * pow(input_x[4], 1) * pow(input_x[6], 2);
        idvd_poly_feat[3946] = pow(input_x[0], 2) * pow(input_x[1], 3) * pow(input_x[5], 3);
        idvd_poly_feat[3947] = pow(input_x[0], 2) * pow(input_x[1], 3) * pow(input_x[5], 2) * pow(input_x[6], 1);
        idvd_poly_feat[3948] = pow(input_x[0], 2) * pow(input_x[1], 3) * pow(input_x[5], 1) * pow(input_x[6], 2);
        idvd_poly_feat[3949] = pow(input_x[0], 2) * pow(input_x[1], 3) * pow(input_x[6], 3);
        idvd_poly_feat[3950] = pow(input_x[0], 2) * pow(input_x[1], 2) * pow(input_x[2], 4);
        idvd_poly_feat[3951] = pow(input_x[0], 2) * pow(input_x[1], 2) * pow(input_x[2], 3) * pow(input_x[3], 1);
        idvd_poly_feat[3952] = pow(input_x[0], 2) * pow(input_x[1], 2) * pow(input_x[2], 3) * pow(input_x[4], 1);
        idvd_poly_feat[3953] = pow(input_x[0], 2) * pow(input_x[1], 2) * pow(input_x[2], 3) * pow(input_x[5], 1);
        idvd_poly_feat[3954] = pow(input_x[0], 2) * pow(input_x[1], 2) * pow(input_x[2], 3) * pow(input_x[6], 1);
        idvd_poly_feat[3955] = pow(input_x[0], 2) * pow(input_x[1], 2) * pow(input_x[2], 2) * pow(input_x[3], 2);
        idvd_poly_feat[3956] = pow(input_x[0], 2) * pow(input_x[1], 2) * pow(input_x[2], 2) * pow(input_x[3], 1) * pow(input_x[4], 1);
        idvd_poly_feat[3957] = pow(input_x[0], 2) * pow(input_x[1], 2) * pow(input_x[2], 2) * pow(input_x[3], 1) * pow(input_x[5], 1);
        idvd_poly_feat[3958] = pow(input_x[0], 2) * pow(input_x[1], 2) * pow(input_x[2], 2) * pow(input_x[3], 1) * pow(input_x[6], 1);
        idvd_poly_feat[3959] = pow(input_x[0], 2) * pow(input_x[1], 2) * pow(input_x[2], 2) * pow(input_x[4], 2);
        idvd_poly_feat[3960] = pow(input_x[0], 2) * pow(input_x[1], 2) * pow(input_x[2], 2) * pow(input_x[4], 1) * pow(input_x[5], 1);
        idvd_poly_feat[3961] = pow(input_x[0], 2) * pow(input_x[1], 2) * pow(input_x[2], 2) * pow(input_x[4], 1) * pow(input_x[6], 1);
        idvd_poly_feat[3962] = pow(input_x[0], 2) * pow(input_x[1], 2) * pow(input_x[2], 2) * pow(input_x[5], 2);
        idvd_poly_feat[3963] = pow(input_x[0], 2) * pow(input_x[1], 2) * pow(input_x[2], 2) * pow(input_x[5], 1) * pow(input_x[6], 1);
        idvd_poly_feat[3964] = pow(input_x[0], 2) * pow(input_x[1], 2) * pow(input_x[2], 2) * pow(input_x[6], 2);
        idvd_poly_feat[3965] = pow(input_x[0], 2) * pow(input_x[1], 2) * pow(input_x[2], 1) * pow(input_x[3], 3);
        idvd_poly_feat[3966] = pow(input_x[0], 2) * pow(input_x[1], 2) * pow(input_x[2], 1) * pow(input_x[3], 2) * pow(input_x[4], 1);
        idvd_poly_feat[3967] = pow(input_x[0], 2) * pow(input_x[1], 2) * pow(input_x[2], 1) * pow(input_x[3], 2) * pow(input_x[5], 1);
        idvd_poly_feat[3968] = pow(input_x[0], 2) * pow(input_x[1], 2) * pow(input_x[2], 1) * pow(input_x[3], 2) * pow(input_x[6], 1);
        idvd_poly_feat[3969] = pow(input_x[0], 2) * pow(input_x[1], 2) * pow(input_x[2], 1) * pow(input_x[3], 1) * pow(input_x[4], 2);
        idvd_poly_feat[3970] = pow(input_x[0], 2) * pow(input_x[1], 2) * pow(input_x[2], 1) * pow(input_x[3], 1) * pow(input_x[4], 1) * pow(input_x[5], 1);
        idvd_poly_feat[3971] = pow(input_x[0], 2) * pow(input_x[1], 2) * pow(input_x[2], 1) * pow(input_x[3], 1) * pow(input_x[4], 1) * pow(input_x[6], 1);
        idvd_poly_feat[3972] = pow(input_x[0], 2) * pow(input_x[1], 2) * pow(input_x[2], 1) * pow(input_x[3], 1) * pow(input_x[5], 2);
        idvd_poly_feat[3973] = pow(input_x[0], 2) * pow(input_x[1], 2) * pow(input_x[2], 1) * pow(input_x[3], 1) * pow(input_x[5], 1) * pow(input_x[6], 1);
        idvd_poly_feat[3974] = pow(input_x[0], 2) * pow(input_x[1], 2) * pow(input_x[2], 1) * pow(input_x[3], 1) * pow(input_x[6], 2);
        idvd_poly_feat[3975] = pow(input_x[0], 2) * pow(input_x[1], 2) * pow(input_x[2], 1) * pow(input_x[4], 3);
        idvd_poly_feat[3976] = pow(input_x[0], 2) * pow(input_x[1], 2) * pow(input_x[2], 1) * pow(input_x[4], 2) * pow(input_x[5], 1);
        idvd_poly_feat[3977] = pow(input_x[0], 2) * pow(input_x[1], 2) * pow(input_x[2], 1) * pow(input_x[4], 2) * pow(input_x[6], 1);
        idvd_poly_feat[3978] = pow(input_x[0], 2) * pow(input_x[1], 2) * pow(input_x[2], 1) * pow(input_x[4], 1) * pow(input_x[5], 2);
        idvd_poly_feat[3979] = pow(input_x[0], 2) * pow(input_x[1], 2) * pow(input_x[2], 1) * pow(input_x[4], 1) * pow(input_x[5], 1) * pow(input_x[6], 1);
        idvd_poly_feat[3980] = pow(input_x[0], 2) * pow(input_x[1], 2) * pow(input_x[2], 1) * pow(input_x[4], 1) * pow(input_x[6], 2);
        idvd_poly_feat[3981] = pow(input_x[0], 2) * pow(input_x[1], 2) * pow(input_x[2], 1) * pow(input_x[5], 3);
        idvd_poly_feat[3982] = pow(input_x[0], 2) * pow(input_x[1], 2) * pow(input_x[2], 1) * pow(input_x[5], 2) * pow(input_x[6], 1);
        idvd_poly_feat[3983] = pow(input_x[0], 2) * pow(input_x[1], 2) * pow(input_x[2], 1) * pow(input_x[5], 1) * pow(input_x[6], 2);
        idvd_poly_feat[3984] = pow(input_x[0], 2) * pow(input_x[1], 2) * pow(input_x[2], 1) * pow(input_x[6], 3);
        idvd_poly_feat[3985] = pow(input_x[0], 2) * pow(input_x[1], 2) * pow(input_x[3], 4);
        idvd_poly_feat[3986] = pow(input_x[0], 2) * pow(input_x[1], 2) * pow(input_x[3], 3) * pow(input_x[4], 1);
        idvd_poly_feat[3987] = pow(input_x[0], 2) * pow(input_x[1], 2) * pow(input_x[3], 3) * pow(input_x[5], 1);
        idvd_poly_feat[3988] = pow(input_x[0], 2) * pow(input_x[1], 2) * pow(input_x[3], 3) * pow(input_x[6], 1);
        idvd_poly_feat[3989] = pow(input_x[0], 2) * pow(input_x[1], 2) * pow(input_x[3], 2) * pow(input_x[4], 2);
        idvd_poly_feat[3990] = pow(input_x[0], 2) * pow(input_x[1], 2) * pow(input_x[3], 2) * pow(input_x[4], 1) * pow(input_x[5], 1);
        idvd_poly_feat[3991] = pow(input_x[0], 2) * pow(input_x[1], 2) * pow(input_x[3], 2) * pow(input_x[4], 1) * pow(input_x[6], 1);
        idvd_poly_feat[3992] = pow(input_x[0], 2) * pow(input_x[1], 2) * pow(input_x[3], 2) * pow(input_x[5], 2);
        idvd_poly_feat[3993] = pow(input_x[0], 2) * pow(input_x[1], 2) * pow(input_x[3], 2) * pow(input_x[5], 1) * pow(input_x[6], 1);
        idvd_poly_feat[3994] = pow(input_x[0], 2) * pow(input_x[1], 2) * pow(input_x[3], 2) * pow(input_x[6], 2);
        idvd_poly_feat[3995] = pow(input_x[0], 2) * pow(input_x[1], 2) * pow(input_x[3], 1) * pow(input_x[4], 3);
        idvd_poly_feat[3996] = pow(input_x[0], 2) * pow(input_x[1], 2) * pow(input_x[3], 1) * pow(input_x[4], 2) * pow(input_x[5], 1);
        idvd_poly_feat[3997] = pow(input_x[0], 2) * pow(input_x[1], 2) * pow(input_x[3], 1) * pow(input_x[4], 2) * pow(input_x[6], 1);
        idvd_poly_feat[3998] = pow(input_x[0], 2) * pow(input_x[1], 2) * pow(input_x[3], 1) * pow(input_x[4], 1) * pow(input_x[5], 2);
        idvd_poly_feat[3999] = pow(input_x[0], 2) * pow(input_x[1], 2) * pow(input_x[3], 1) * pow(input_x[4], 1) * pow(input_x[5], 1) * pow(input_x[6], 1);
        idvd_poly_feat[4000] = pow(input_x[0], 2) * pow(input_x[1], 2) * pow(input_x[3], 1) * pow(input_x[4], 1) * pow(input_x[6], 2);
        idvd_poly_feat[4001] = pow(input_x[0], 2) * pow(input_x[1], 2) * pow(input_x[3], 1) * pow(input_x[5], 3);
        idvd_poly_feat[4002] = pow(input_x[0], 2) * pow(input_x[1], 2) * pow(input_x[3], 1) * pow(input_x[5], 2) * pow(input_x[6], 1);
        idvd_poly_feat[4003] = pow(input_x[0], 2) * pow(input_x[1], 2) * pow(input_x[3], 1) * pow(input_x[5], 1) * pow(input_x[6], 2);
        idvd_poly_feat[4004] = pow(input_x[0], 2) * pow(input_x[1], 2) * pow(input_x[3], 1) * pow(input_x[6], 3);
        idvd_poly_feat[4005] = pow(input_x[0], 2) * pow(input_x[1], 2) * pow(input_x[4], 4);
        idvd_poly_feat[4006] = pow(input_x[0], 2) * pow(input_x[1], 2) * pow(input_x[4], 3) * pow(input_x[5], 1);
        idvd_poly_feat[4007] = pow(input_x[0], 2) * pow(input_x[1], 2) * pow(input_x[4], 3) * pow(input_x[6], 1);
        idvd_poly_feat[4008] = pow(input_x[0], 2) * pow(input_x[1], 2) * pow(input_x[4], 2) * pow(input_x[5], 2);
        idvd_poly_feat[4009] = pow(input_x[0], 2) * pow(input_x[1], 2) * pow(input_x[4], 2) * pow(input_x[5], 1) * pow(input_x[6], 1);
        idvd_poly_feat[4010] = pow(input_x[0], 2) * pow(input_x[1], 2) * pow(input_x[4], 2) * pow(input_x[6], 2);
        idvd_poly_feat[4011] = pow(input_x[0], 2) * pow(input_x[1], 2) * pow(input_x[4], 1) * pow(input_x[5], 3);
        idvd_poly_feat[4012] = pow(input_x[0], 2) * pow(input_x[1], 2) * pow(input_x[4], 1) * pow(input_x[5], 2) * pow(input_x[6], 1);
        idvd_poly_feat[4013] = pow(input_x[0], 2) * pow(input_x[1], 2) * pow(input_x[4], 1) * pow(input_x[5], 1) * pow(input_x[6], 2);
        idvd_poly_feat[4014] = pow(input_x[0], 2) * pow(input_x[1], 2) * pow(input_x[4], 1) * pow(input_x[6], 3);
        idvd_poly_feat[4015] = pow(input_x[0], 2) * pow(input_x[1], 2) * pow(input_x[5], 4);
        idvd_poly_feat[4016] = pow(input_x[0], 2) * pow(input_x[1], 2) * pow(input_x[5], 3) * pow(input_x[6], 1);
        idvd_poly_feat[4017] = pow(input_x[0], 2) * pow(input_x[1], 2) * pow(input_x[5], 2) * pow(input_x[6], 2);
        idvd_poly_feat[4018] = pow(input_x[0], 2) * pow(input_x[1], 2) * pow(input_x[5], 1) * pow(input_x[6], 3);
        idvd_poly_feat[4019] = pow(input_x[0], 2) * pow(input_x[1], 2) * pow(input_x[6], 4);
        idvd_poly_feat[4020] = pow(input_x[0], 2) * pow(input_x[1], 1) * pow(input_x[2], 5);
        idvd_poly_feat[4021] = pow(input_x[0], 2) * pow(input_x[1], 1) * pow(input_x[2], 4) * pow(input_x[3], 1);
        idvd_poly_feat[4022] = pow(input_x[0], 2) * pow(input_x[1], 1) * pow(input_x[2], 4) * pow(input_x[4], 1);
        idvd_poly_feat[4023] = pow(input_x[0], 2) * pow(input_x[1], 1) * pow(input_x[2], 4) * pow(input_x[5], 1);
        idvd_poly_feat[4024] = pow(input_x[0], 2) * pow(input_x[1], 1) * pow(input_x[2], 4) * pow(input_x[6], 1);
        idvd_poly_feat[4025] = pow(input_x[0], 2) * pow(input_x[1], 1) * pow(input_x[2], 3) * pow(input_x[3], 2);
        idvd_poly_feat[4026] = pow(input_x[0], 2) * pow(input_x[1], 1) * pow(input_x[2], 3) * pow(input_x[3], 1) * pow(input_x[4], 1);
        idvd_poly_feat[4027] = pow(input_x[0], 2) * pow(input_x[1], 1) * pow(input_x[2], 3) * pow(input_x[3], 1) * pow(input_x[5], 1);
        idvd_poly_feat[4028] = pow(input_x[0], 2) * pow(input_x[1], 1) * pow(input_x[2], 3) * pow(input_x[3], 1) * pow(input_x[6], 1);
        idvd_poly_feat[4029] = pow(input_x[0], 2) * pow(input_x[1], 1) * pow(input_x[2], 3) * pow(input_x[4], 2);
        idvd_poly_feat[4030] = pow(input_x[0], 2) * pow(input_x[1], 1) * pow(input_x[2], 3) * pow(input_x[4], 1) * pow(input_x[5], 1);
        idvd_poly_feat[4031] = pow(input_x[0], 2) * pow(input_x[1], 1) * pow(input_x[2], 3) * pow(input_x[4], 1) * pow(input_x[6], 1);
        idvd_poly_feat[4032] = pow(input_x[0], 2) * pow(input_x[1], 1) * pow(input_x[2], 3) * pow(input_x[5], 2);
        idvd_poly_feat[4033] = pow(input_x[0], 2) * pow(input_x[1], 1) * pow(input_x[2], 3) * pow(input_x[5], 1) * pow(input_x[6], 1);
        idvd_poly_feat[4034] = pow(input_x[0], 2) * pow(input_x[1], 1) * pow(input_x[2], 3) * pow(input_x[6], 2);
        idvd_poly_feat[4035] = pow(input_x[0], 2) * pow(input_x[1], 1) * pow(input_x[2], 2) * pow(input_x[3], 3);
        idvd_poly_feat[4036] = pow(input_x[0], 2) * pow(input_x[1], 1) * pow(input_x[2], 2) * pow(input_x[3], 2) * pow(input_x[4], 1);
        idvd_poly_feat[4037] = pow(input_x[0], 2) * pow(input_x[1], 1) * pow(input_x[2], 2) * pow(input_x[3], 2) * pow(input_x[5], 1);
        idvd_poly_feat[4038] = pow(input_x[0], 2) * pow(input_x[1], 1) * pow(input_x[2], 2) * pow(input_x[3], 2) * pow(input_x[6], 1);
        idvd_poly_feat[4039] = pow(input_x[0], 2) * pow(input_x[1], 1) * pow(input_x[2], 2) * pow(input_x[3], 1) * pow(input_x[4], 2);
        idvd_poly_feat[4040] = pow(input_x[0], 2) * pow(input_x[1], 1) * pow(input_x[2], 2) * pow(input_x[3], 1) * pow(input_x[4], 1) * pow(input_x[5], 1);
        idvd_poly_feat[4041] = pow(input_x[0], 2) * pow(input_x[1], 1) * pow(input_x[2], 2) * pow(input_x[3], 1) * pow(input_x[4], 1) * pow(input_x[6], 1);
        idvd_poly_feat[4042] = pow(input_x[0], 2) * pow(input_x[1], 1) * pow(input_x[2], 2) * pow(input_x[3], 1) * pow(input_x[5], 2);
        idvd_poly_feat[4043] = pow(input_x[0], 2) * pow(input_x[1], 1) * pow(input_x[2], 2) * pow(input_x[3], 1) * pow(input_x[5], 1) * pow(input_x[6], 1);
        idvd_poly_feat[4044] = pow(input_x[0], 2) * pow(input_x[1], 1) * pow(input_x[2], 2) * pow(input_x[3], 1) * pow(input_x[6], 2);
        idvd_poly_feat[4045] = pow(input_x[0], 2) * pow(input_x[1], 1) * pow(input_x[2], 2) * pow(input_x[4], 3);
        idvd_poly_feat[4046] = pow(input_x[0], 2) * pow(input_x[1], 1) * pow(input_x[2], 2) * pow(input_x[4], 2) * pow(input_x[5], 1);
        idvd_poly_feat[4047] = pow(input_x[0], 2) * pow(input_x[1], 1) * pow(input_x[2], 2) * pow(input_x[4], 2) * pow(input_x[6], 1);
        idvd_poly_feat[4048] = pow(input_x[0], 2) * pow(input_x[1], 1) * pow(input_x[2], 2) * pow(input_x[4], 1) * pow(input_x[5], 2);
        idvd_poly_feat[4049] = pow(input_x[0], 2) * pow(input_x[1], 1) * pow(input_x[2], 2) * pow(input_x[4], 1) * pow(input_x[5], 1) * pow(input_x[6], 1);
        idvd_poly_feat[4050] = pow(input_x[0], 2) * pow(input_x[1], 1) * pow(input_x[2], 2) * pow(input_x[4], 1) * pow(input_x[6], 2);
        idvd_poly_feat[4051] = pow(input_x[0], 2) * pow(input_x[1], 1) * pow(input_x[2], 2) * pow(input_x[5], 3);
        idvd_poly_feat[4052] = pow(input_x[0], 2) * pow(input_x[1], 1) * pow(input_x[2], 2) * pow(input_x[5], 2) * pow(input_x[6], 1);
        idvd_poly_feat[4053] = pow(input_x[0], 2) * pow(input_x[1], 1) * pow(input_x[2], 2) * pow(input_x[5], 1) * pow(input_x[6], 2);
        idvd_poly_feat[4054] = pow(input_x[0], 2) * pow(input_x[1], 1) * pow(input_x[2], 2) * pow(input_x[6], 3);
        idvd_poly_feat[4055] = pow(input_x[0], 2) * pow(input_x[1], 1) * pow(input_x[2], 1) * pow(input_x[3], 4);
        idvd_poly_feat[4056] = pow(input_x[0], 2) * pow(input_x[1], 1) * pow(input_x[2], 1) * pow(input_x[3], 3) * pow(input_x[4], 1);
        idvd_poly_feat[4057] = pow(input_x[0], 2) * pow(input_x[1], 1) * pow(input_x[2], 1) * pow(input_x[3], 3) * pow(input_x[5], 1);
        idvd_poly_feat[4058] = pow(input_x[0], 2) * pow(input_x[1], 1) * pow(input_x[2], 1) * pow(input_x[3], 3) * pow(input_x[6], 1);
        idvd_poly_feat[4059] = pow(input_x[0], 2) * pow(input_x[1], 1) * pow(input_x[2], 1) * pow(input_x[3], 2) * pow(input_x[4], 2);
        idvd_poly_feat[4060] = pow(input_x[0], 2) * pow(input_x[1], 1) * pow(input_x[2], 1) * pow(input_x[3], 2) * pow(input_x[4], 1) * pow(input_x[5], 1);
        idvd_poly_feat[4061] = pow(input_x[0], 2) * pow(input_x[1], 1) * pow(input_x[2], 1) * pow(input_x[3], 2) * pow(input_x[4], 1) * pow(input_x[6], 1);
        idvd_poly_feat[4062] = pow(input_x[0], 2) * pow(input_x[1], 1) * pow(input_x[2], 1) * pow(input_x[3], 2) * pow(input_x[5], 2);
        idvd_poly_feat[4063] = pow(input_x[0], 2) * pow(input_x[1], 1) * pow(input_x[2], 1) * pow(input_x[3], 2) * pow(input_x[5], 1) * pow(input_x[6], 1);
        idvd_poly_feat[4064] = pow(input_x[0], 2) * pow(input_x[1], 1) * pow(input_x[2], 1) * pow(input_x[3], 2) * pow(input_x[6], 2);
        idvd_poly_feat[4065] = pow(input_x[0], 2) * pow(input_x[1], 1) * pow(input_x[2], 1) * pow(input_x[3], 1) * pow(input_x[4], 3);
        idvd_poly_feat[4066] = pow(input_x[0], 2) * pow(input_x[1], 1) * pow(input_x[2], 1) * pow(input_x[3], 1) * pow(input_x[4], 2) * pow(input_x[5], 1);
        idvd_poly_feat[4067] = pow(input_x[0], 2) * pow(input_x[1], 1) * pow(input_x[2], 1) * pow(input_x[3], 1) * pow(input_x[4], 2) * pow(input_x[6], 1);
        idvd_poly_feat[4068] = pow(input_x[0], 2) * pow(input_x[1], 1) * pow(input_x[2], 1) * pow(input_x[3], 1) * pow(input_x[4], 1) * pow(input_x[5], 2);
        idvd_poly_feat[4069] = pow(input_x[0], 2) * pow(input_x[1], 1) * pow(input_x[2], 1) * pow(input_x[3], 1) * pow(input_x[4], 1) * pow(input_x[5], 1) * pow(input_x[6], 1);
        idvd_poly_feat[4070] = pow(input_x[0], 2) * pow(input_x[1], 1) * pow(input_x[2], 1) * pow(input_x[3], 1) * pow(input_x[4], 1) * pow(input_x[6], 2);
        idvd_poly_feat[4071] = pow(input_x[0], 2) * pow(input_x[1], 1) * pow(input_x[2], 1) * pow(input_x[3], 1) * pow(input_x[5], 3);
        idvd_poly_feat[4072] = pow(input_x[0], 2) * pow(input_x[1], 1) * pow(input_x[2], 1) * pow(input_x[3], 1) * pow(input_x[5], 2) * pow(input_x[6], 1);
        idvd_poly_feat[4073] = pow(input_x[0], 2) * pow(input_x[1], 1) * pow(input_x[2], 1) * pow(input_x[3], 1) * pow(input_x[5], 1) * pow(input_x[6], 2);
        idvd_poly_feat[4074] = pow(input_x[0], 2) * pow(input_x[1], 1) * pow(input_x[2], 1) * pow(input_x[3], 1) * pow(input_x[6], 3);
        idvd_poly_feat[4075] = pow(input_x[0], 2) * pow(input_x[1], 1) * pow(input_x[2], 1) * pow(input_x[4], 4);
        idvd_poly_feat[4076] = pow(input_x[0], 2) * pow(input_x[1], 1) * pow(input_x[2], 1) * pow(input_x[4], 3) * pow(input_x[5], 1);
        idvd_poly_feat[4077] = pow(input_x[0], 2) * pow(input_x[1], 1) * pow(input_x[2], 1) * pow(input_x[4], 3) * pow(input_x[6], 1);
        idvd_poly_feat[4078] = pow(input_x[0], 2) * pow(input_x[1], 1) * pow(input_x[2], 1) * pow(input_x[4], 2) * pow(input_x[5], 2);
        idvd_poly_feat[4079] = pow(input_x[0], 2) * pow(input_x[1], 1) * pow(input_x[2], 1) * pow(input_x[4], 2) * pow(input_x[5], 1) * pow(input_x[6], 1);
        idvd_poly_feat[4080] = pow(input_x[0], 2) * pow(input_x[1], 1) * pow(input_x[2], 1) * pow(input_x[4], 2) * pow(input_x[6], 2);
        idvd_poly_feat[4081] = pow(input_x[0], 2) * pow(input_x[1], 1) * pow(input_x[2], 1) * pow(input_x[4], 1) * pow(input_x[5], 3);
        idvd_poly_feat[4082] = pow(input_x[0], 2) * pow(input_x[1], 1) * pow(input_x[2], 1) * pow(input_x[4], 1) * pow(input_x[5], 2) * pow(input_x[6], 1);
        idvd_poly_feat[4083] = pow(input_x[0], 2) * pow(input_x[1], 1) * pow(input_x[2], 1) * pow(input_x[4], 1) * pow(input_x[5], 1) * pow(input_x[6], 2);
        idvd_poly_feat[4084] = pow(input_x[0], 2) * pow(input_x[1], 1) * pow(input_x[2], 1) * pow(input_x[4], 1) * pow(input_x[6], 3);
        idvd_poly_feat[4085] = pow(input_x[0], 2) * pow(input_x[1], 1) * pow(input_x[2], 1) * pow(input_x[5], 4);
        idvd_poly_feat[4086] = pow(input_x[0], 2) * pow(input_x[1], 1) * pow(input_x[2], 1) * pow(input_x[5], 3) * pow(input_x[6], 1);
        idvd_poly_feat[4087] = pow(input_x[0], 2) * pow(input_x[1], 1) * pow(input_x[2], 1) * pow(input_x[5], 2) * pow(input_x[6], 2);
        idvd_poly_feat[4088] = pow(input_x[0], 2) * pow(input_x[1], 1) * pow(input_x[2], 1) * pow(input_x[5], 1) * pow(input_x[6], 3);
        idvd_poly_feat[4089] = pow(input_x[0], 2) * pow(input_x[1], 1) * pow(input_x[2], 1) * pow(input_x[6], 4);
        idvd_poly_feat[4090] = pow(input_x[0], 2) * pow(input_x[1], 1) * pow(input_x[3], 5);
        idvd_poly_feat[4091] = pow(input_x[0], 2) * pow(input_x[1], 1) * pow(input_x[3], 4) * pow(input_x[4], 1);
        idvd_poly_feat[4092] = pow(input_x[0], 2) * pow(input_x[1], 1) * pow(input_x[3], 4) * pow(input_x[5], 1);
        idvd_poly_feat[4093] = pow(input_x[0], 2) * pow(input_x[1], 1) * pow(input_x[3], 4) * pow(input_x[6], 1);
        idvd_poly_feat[4094] = pow(input_x[0], 2) * pow(input_x[1], 1) * pow(input_x[3], 3) * pow(input_x[4], 2);
        idvd_poly_feat[4095] = pow(input_x[0], 2) * pow(input_x[1], 1) * pow(input_x[3], 3) * pow(input_x[4], 1) * pow(input_x[5], 1);
        idvd_poly_feat[4096] = pow(input_x[0], 2) * pow(input_x[1], 1) * pow(input_x[3], 3) * pow(input_x[4], 1) * pow(input_x[6], 1);
        idvd_poly_feat[4097] = pow(input_x[0], 2) * pow(input_x[1], 1) * pow(input_x[3], 3) * pow(input_x[5], 2);
        idvd_poly_feat[4098] = pow(input_x[0], 2) * pow(input_x[1], 1) * pow(input_x[3], 3) * pow(input_x[5], 1) * pow(input_x[6], 1);
        idvd_poly_feat[4099] = pow(input_x[0], 2) * pow(input_x[1], 1) * pow(input_x[3], 3) * pow(input_x[6], 2);
        idvd_poly_feat[4100] = pow(input_x[0], 2) * pow(input_x[1], 1) * pow(input_x[3], 2) * pow(input_x[4], 3);
        idvd_poly_feat[4101] = pow(input_x[0], 2) * pow(input_x[1], 1) * pow(input_x[3], 2) * pow(input_x[4], 2) * pow(input_x[5], 1);
        idvd_poly_feat[4102] = pow(input_x[0], 2) * pow(input_x[1], 1) * pow(input_x[3], 2) * pow(input_x[4], 2) * pow(input_x[6], 1);
        idvd_poly_feat[4103] = pow(input_x[0], 2) * pow(input_x[1], 1) * pow(input_x[3], 2) * pow(input_x[4], 1) * pow(input_x[5], 2);
        idvd_poly_feat[4104] = pow(input_x[0], 2) * pow(input_x[1], 1) * pow(input_x[3], 2) * pow(input_x[4], 1) * pow(input_x[5], 1) * pow(input_x[6], 1);
        idvd_poly_feat[4105] = pow(input_x[0], 2) * pow(input_x[1], 1) * pow(input_x[3], 2) * pow(input_x[4], 1) * pow(input_x[6], 2);
        idvd_poly_feat[4106] = pow(input_x[0], 2) * pow(input_x[1], 1) * pow(input_x[3], 2) * pow(input_x[5], 3);
        idvd_poly_feat[4107] = pow(input_x[0], 2) * pow(input_x[1], 1) * pow(input_x[3], 2) * pow(input_x[5], 2) * pow(input_x[6], 1);
        idvd_poly_feat[4108] = pow(input_x[0], 2) * pow(input_x[1], 1) * pow(input_x[3], 2) * pow(input_x[5], 1) * pow(input_x[6], 2);
        idvd_poly_feat[4109] = pow(input_x[0], 2) * pow(input_x[1], 1) * pow(input_x[3], 2) * pow(input_x[6], 3);
        idvd_poly_feat[4110] = pow(input_x[0], 2) * pow(input_x[1], 1) * pow(input_x[3], 1) * pow(input_x[4], 4);
        idvd_poly_feat[4111] = pow(input_x[0], 2) * pow(input_x[1], 1) * pow(input_x[3], 1) * pow(input_x[4], 3) * pow(input_x[5], 1);
        idvd_poly_feat[4112] = pow(input_x[0], 2) * pow(input_x[1], 1) * pow(input_x[3], 1) * pow(input_x[4], 3) * pow(input_x[6], 1);
        idvd_poly_feat[4113] = pow(input_x[0], 2) * pow(input_x[1], 1) * pow(input_x[3], 1) * pow(input_x[4], 2) * pow(input_x[5], 2);
        idvd_poly_feat[4114] = pow(input_x[0], 2) * pow(input_x[1], 1) * pow(input_x[3], 1) * pow(input_x[4], 2) * pow(input_x[5], 1) * pow(input_x[6], 1);
        idvd_poly_feat[4115] = pow(input_x[0], 2) * pow(input_x[1], 1) * pow(input_x[3], 1) * pow(input_x[4], 2) * pow(input_x[6], 2);
        idvd_poly_feat[4116] = pow(input_x[0], 2) * pow(input_x[1], 1) * pow(input_x[3], 1) * pow(input_x[4], 1) * pow(input_x[5], 3);
        idvd_poly_feat[4117] = pow(input_x[0], 2) * pow(input_x[1], 1) * pow(input_x[3], 1) * pow(input_x[4], 1) * pow(input_x[5], 2) * pow(input_x[6], 1);
        idvd_poly_feat[4118] = pow(input_x[0], 2) * pow(input_x[1], 1) * pow(input_x[3], 1) * pow(input_x[4], 1) * pow(input_x[5], 1) * pow(input_x[6], 2);
        idvd_poly_feat[4119] = pow(input_x[0], 2) * pow(input_x[1], 1) * pow(input_x[3], 1) * pow(input_x[4], 1) * pow(input_x[6], 3);
        idvd_poly_feat[4120] = pow(input_x[0], 2) * pow(input_x[1], 1) * pow(input_x[3], 1) * pow(input_x[5], 4);
        idvd_poly_feat[4121] = pow(input_x[0], 2) * pow(input_x[1], 1) * pow(input_x[3], 1) * pow(input_x[5], 3) * pow(input_x[6], 1);
        idvd_poly_feat[4122] = pow(input_x[0], 2) * pow(input_x[1], 1) * pow(input_x[3], 1) * pow(input_x[5], 2) * pow(input_x[6], 2);
        idvd_poly_feat[4123] = pow(input_x[0], 2) * pow(input_x[1], 1) * pow(input_x[3], 1) * pow(input_x[5], 1) * pow(input_x[6], 3);
        idvd_poly_feat[4124] = pow(input_x[0], 2) * pow(input_x[1], 1) * pow(input_x[3], 1) * pow(input_x[6], 4);
        idvd_poly_feat[4125] = pow(input_x[0], 2) * pow(input_x[1], 1) * pow(input_x[4], 5);
        idvd_poly_feat[4126] = pow(input_x[0], 2) * pow(input_x[1], 1) * pow(input_x[4], 4) * pow(input_x[5], 1);
        idvd_poly_feat[4127] = pow(input_x[0], 2) * pow(input_x[1], 1) * pow(input_x[4], 4) * pow(input_x[6], 1);
        idvd_poly_feat[4128] = pow(input_x[0], 2) * pow(input_x[1], 1) * pow(input_x[4], 3) * pow(input_x[5], 2);
        idvd_poly_feat[4129] = pow(input_x[0], 2) * pow(input_x[1], 1) * pow(input_x[4], 3) * pow(input_x[5], 1) * pow(input_x[6], 1);
        idvd_poly_feat[4130] = pow(input_x[0], 2) * pow(input_x[1], 1) * pow(input_x[4], 3) * pow(input_x[6], 2);
        idvd_poly_feat[4131] = pow(input_x[0], 2) * pow(input_x[1], 1) * pow(input_x[4], 2) * pow(input_x[5], 3);
        idvd_poly_feat[4132] = pow(input_x[0], 2) * pow(input_x[1], 1) * pow(input_x[4], 2) * pow(input_x[5], 2) * pow(input_x[6], 1);
        idvd_poly_feat[4133] = pow(input_x[0], 2) * pow(input_x[1], 1) * pow(input_x[4], 2) * pow(input_x[5], 1) * pow(input_x[6], 2);
        idvd_poly_feat[4134] = pow(input_x[0], 2) * pow(input_x[1], 1) * pow(input_x[4], 2) * pow(input_x[6], 3);
        idvd_poly_feat[4135] = pow(input_x[0], 2) * pow(input_x[1], 1) * pow(input_x[4], 1) * pow(input_x[5], 4);
        idvd_poly_feat[4136] = pow(input_x[0], 2) * pow(input_x[1], 1) * pow(input_x[4], 1) * pow(input_x[5], 3) * pow(input_x[6], 1);
        idvd_poly_feat[4137] = pow(input_x[0], 2) * pow(input_x[1], 1) * pow(input_x[4], 1) * pow(input_x[5], 2) * pow(input_x[6], 2);
        idvd_poly_feat[4138] = pow(input_x[0], 2) * pow(input_x[1], 1) * pow(input_x[4], 1) * pow(input_x[5], 1) * pow(input_x[6], 3);
        idvd_poly_feat[4139] = pow(input_x[0], 2) * pow(input_x[1], 1) * pow(input_x[4], 1) * pow(input_x[6], 4);
        idvd_poly_feat[4140] = pow(input_x[0], 2) * pow(input_x[1], 1) * pow(input_x[5], 5);
        idvd_poly_feat[4141] = pow(input_x[0], 2) * pow(input_x[1], 1) * pow(input_x[5], 4) * pow(input_x[6], 1);
        idvd_poly_feat[4142] = pow(input_x[0], 2) * pow(input_x[1], 1) * pow(input_x[5], 3) * pow(input_x[6], 2);
        idvd_poly_feat[4143] = pow(input_x[0], 2) * pow(input_x[1], 1) * pow(input_x[5], 2) * pow(input_x[6], 3);
        idvd_poly_feat[4144] = pow(input_x[0], 2) * pow(input_x[1], 1) * pow(input_x[5], 1) * pow(input_x[6], 4);
        idvd_poly_feat[4145] = pow(input_x[0], 2) * pow(input_x[1], 1) * pow(input_x[6], 5);
        idvd_poly_feat[4146] = pow(input_x[0], 2) * pow(input_x[2], 6);
        idvd_poly_feat[4147] = pow(input_x[0], 2) * pow(input_x[2], 5) * pow(input_x[3], 1);
        idvd_poly_feat[4148] = pow(input_x[0], 2) * pow(input_x[2], 5) * pow(input_x[4], 1);
        idvd_poly_feat[4149] = pow(input_x[0], 2) * pow(input_x[2], 5) * pow(input_x[5], 1);
        idvd_poly_feat[4150] = pow(input_x[0], 2) * pow(input_x[2], 5) * pow(input_x[6], 1);
        idvd_poly_feat[4151] = pow(input_x[0], 2) * pow(input_x[2], 4) * pow(input_x[3], 2);
        idvd_poly_feat[4152] = pow(input_x[0], 2) * pow(input_x[2], 4) * pow(input_x[3], 1) * pow(input_x[4], 1);
        idvd_poly_feat[4153] = pow(input_x[0], 2) * pow(input_x[2], 4) * pow(input_x[3], 1) * pow(input_x[5], 1);
        idvd_poly_feat[4154] = pow(input_x[0], 2) * pow(input_x[2], 4) * pow(input_x[3], 1) * pow(input_x[6], 1);
        idvd_poly_feat[4155] = pow(input_x[0], 2) * pow(input_x[2], 4) * pow(input_x[4], 2);
        idvd_poly_feat[4156] = pow(input_x[0], 2) * pow(input_x[2], 4) * pow(input_x[4], 1) * pow(input_x[5], 1);
        idvd_poly_feat[4157] = pow(input_x[0], 2) * pow(input_x[2], 4) * pow(input_x[4], 1) * pow(input_x[6], 1);
        idvd_poly_feat[4158] = pow(input_x[0], 2) * pow(input_x[2], 4) * pow(input_x[5], 2);
        idvd_poly_feat[4159] = pow(input_x[0], 2) * pow(input_x[2], 4) * pow(input_x[5], 1) * pow(input_x[6], 1);
        idvd_poly_feat[4160] = pow(input_x[0], 2) * pow(input_x[2], 4) * pow(input_x[6], 2);
        idvd_poly_feat[4161] = pow(input_x[0], 2) * pow(input_x[2], 3) * pow(input_x[3], 3);
        idvd_poly_feat[4162] = pow(input_x[0], 2) * pow(input_x[2], 3) * pow(input_x[3], 2) * pow(input_x[4], 1);
        idvd_poly_feat[4163] = pow(input_x[0], 2) * pow(input_x[2], 3) * pow(input_x[3], 2) * pow(input_x[5], 1);
        idvd_poly_feat[4164] = pow(input_x[0], 2) * pow(input_x[2], 3) * pow(input_x[3], 2) * pow(input_x[6], 1);
        idvd_poly_feat[4165] = pow(input_x[0], 2) * pow(input_x[2], 3) * pow(input_x[3], 1) * pow(input_x[4], 2);
        idvd_poly_feat[4166] = pow(input_x[0], 2) * pow(input_x[2], 3) * pow(input_x[3], 1) * pow(input_x[4], 1) * pow(input_x[5], 1);
        idvd_poly_feat[4167] = pow(input_x[0], 2) * pow(input_x[2], 3) * pow(input_x[3], 1) * pow(input_x[4], 1) * pow(input_x[6], 1);
        idvd_poly_feat[4168] = pow(input_x[0], 2) * pow(input_x[2], 3) * pow(input_x[3], 1) * pow(input_x[5], 2);
        idvd_poly_feat[4169] = pow(input_x[0], 2) * pow(input_x[2], 3) * pow(input_x[3], 1) * pow(input_x[5], 1) * pow(input_x[6], 1);
        idvd_poly_feat[4170] = pow(input_x[0], 2) * pow(input_x[2], 3) * pow(input_x[3], 1) * pow(input_x[6], 2);
        idvd_poly_feat[4171] = pow(input_x[0], 2) * pow(input_x[2], 3) * pow(input_x[4], 3);
        idvd_poly_feat[4172] = pow(input_x[0], 2) * pow(input_x[2], 3) * pow(input_x[4], 2) * pow(input_x[5], 1);
        idvd_poly_feat[4173] = pow(input_x[0], 2) * pow(input_x[2], 3) * pow(input_x[4], 2) * pow(input_x[6], 1);
        idvd_poly_feat[4174] = pow(input_x[0], 2) * pow(input_x[2], 3) * pow(input_x[4], 1) * pow(input_x[5], 2);
        idvd_poly_feat[4175] = pow(input_x[0], 2) * pow(input_x[2], 3) * pow(input_x[4], 1) * pow(input_x[5], 1) * pow(input_x[6], 1);
        idvd_poly_feat[4176] = pow(input_x[0], 2) * pow(input_x[2], 3) * pow(input_x[4], 1) * pow(input_x[6], 2);
        idvd_poly_feat[4177] = pow(input_x[0], 2) * pow(input_x[2], 3) * pow(input_x[5], 3);
        idvd_poly_feat[4178] = pow(input_x[0], 2) * pow(input_x[2], 3) * pow(input_x[5], 2) * pow(input_x[6], 1);
        idvd_poly_feat[4179] = pow(input_x[0], 2) * pow(input_x[2], 3) * pow(input_x[5], 1) * pow(input_x[6], 2);
        idvd_poly_feat[4180] = pow(input_x[0], 2) * pow(input_x[2], 3) * pow(input_x[6], 3);
        idvd_poly_feat[4181] = pow(input_x[0], 2) * pow(input_x[2], 2) * pow(input_x[3], 4);
        idvd_poly_feat[4182] = pow(input_x[0], 2) * pow(input_x[2], 2) * pow(input_x[3], 3) * pow(input_x[4], 1);
        idvd_poly_feat[4183] = pow(input_x[0], 2) * pow(input_x[2], 2) * pow(input_x[3], 3) * pow(input_x[5], 1);
        idvd_poly_feat[4184] = pow(input_x[0], 2) * pow(input_x[2], 2) * pow(input_x[3], 3) * pow(input_x[6], 1);
        idvd_poly_feat[4185] = pow(input_x[0], 2) * pow(input_x[2], 2) * pow(input_x[3], 2) * pow(input_x[4], 2);
        idvd_poly_feat[4186] = pow(input_x[0], 2) * pow(input_x[2], 2) * pow(input_x[3], 2) * pow(input_x[4], 1) * pow(input_x[5], 1);
        idvd_poly_feat[4187] = pow(input_x[0], 2) * pow(input_x[2], 2) * pow(input_x[3], 2) * pow(input_x[4], 1) * pow(input_x[6], 1);
        idvd_poly_feat[4188] = pow(input_x[0], 2) * pow(input_x[2], 2) * pow(input_x[3], 2) * pow(input_x[5], 2);
        idvd_poly_feat[4189] = pow(input_x[0], 2) * pow(input_x[2], 2) * pow(input_x[3], 2) * pow(input_x[5], 1) * pow(input_x[6], 1);
        idvd_poly_feat[4190] = pow(input_x[0], 2) * pow(input_x[2], 2) * pow(input_x[3], 2) * pow(input_x[6], 2);
        idvd_poly_feat[4191] = pow(input_x[0], 2) * pow(input_x[2], 2) * pow(input_x[3], 1) * pow(input_x[4], 3);
        idvd_poly_feat[4192] = pow(input_x[0], 2) * pow(input_x[2], 2) * pow(input_x[3], 1) * pow(input_x[4], 2) * pow(input_x[5], 1);
        idvd_poly_feat[4193] = pow(input_x[0], 2) * pow(input_x[2], 2) * pow(input_x[3], 1) * pow(input_x[4], 2) * pow(input_x[6], 1);
        idvd_poly_feat[4194] = pow(input_x[0], 2) * pow(input_x[2], 2) * pow(input_x[3], 1) * pow(input_x[4], 1) * pow(input_x[5], 2);
        idvd_poly_feat[4195] = pow(input_x[0], 2) * pow(input_x[2], 2) * pow(input_x[3], 1) * pow(input_x[4], 1) * pow(input_x[5], 1) * pow(input_x[6], 1);
        idvd_poly_feat[4196] = pow(input_x[0], 2) * pow(input_x[2], 2) * pow(input_x[3], 1) * pow(input_x[4], 1) * pow(input_x[6], 2);
        idvd_poly_feat[4197] = pow(input_x[0], 2) * pow(input_x[2], 2) * pow(input_x[3], 1) * pow(input_x[5], 3);
        idvd_poly_feat[4198] = pow(input_x[0], 2) * pow(input_x[2], 2) * pow(input_x[3], 1) * pow(input_x[5], 2) * pow(input_x[6], 1);
        idvd_poly_feat[4199] = pow(input_x[0], 2) * pow(input_x[2], 2) * pow(input_x[3], 1) * pow(input_x[5], 1) * pow(input_x[6], 2);
        idvd_poly_feat[4200] = pow(input_x[0], 2) * pow(input_x[2], 2) * pow(input_x[3], 1) * pow(input_x[6], 3);
        idvd_poly_feat[4201] = pow(input_x[0], 2) * pow(input_x[2], 2) * pow(input_x[4], 4);
        idvd_poly_feat[4202] = pow(input_x[0], 2) * pow(input_x[2], 2) * pow(input_x[4], 3) * pow(input_x[5], 1);
        idvd_poly_feat[4203] = pow(input_x[0], 2) * pow(input_x[2], 2) * pow(input_x[4], 3) * pow(input_x[6], 1);
        idvd_poly_feat[4204] = pow(input_x[0], 2) * pow(input_x[2], 2) * pow(input_x[4], 2) * pow(input_x[5], 2);
        idvd_poly_feat[4205] = pow(input_x[0], 2) * pow(input_x[2], 2) * pow(input_x[4], 2) * pow(input_x[5], 1) * pow(input_x[6], 1);
        idvd_poly_feat[4206] = pow(input_x[0], 2) * pow(input_x[2], 2) * pow(input_x[4], 2) * pow(input_x[6], 2);
        idvd_poly_feat[4207] = pow(input_x[0], 2) * pow(input_x[2], 2) * pow(input_x[4], 1) * pow(input_x[5], 3);
        idvd_poly_feat[4208] = pow(input_x[0], 2) * pow(input_x[2], 2) * pow(input_x[4], 1) * pow(input_x[5], 2) * pow(input_x[6], 1);
        idvd_poly_feat[4209] = pow(input_x[0], 2) * pow(input_x[2], 2) * pow(input_x[4], 1) * pow(input_x[5], 1) * pow(input_x[6], 2);
        idvd_poly_feat[4210] = pow(input_x[0], 2) * pow(input_x[2], 2) * pow(input_x[4], 1) * pow(input_x[6], 3);
        idvd_poly_feat[4211] = pow(input_x[0], 2) * pow(input_x[2], 2) * pow(input_x[5], 4);
        idvd_poly_feat[4212] = pow(input_x[0], 2) * pow(input_x[2], 2) * pow(input_x[5], 3) * pow(input_x[6], 1);
        idvd_poly_feat[4213] = pow(input_x[0], 2) * pow(input_x[2], 2) * pow(input_x[5], 2) * pow(input_x[6], 2);
        idvd_poly_feat[4214] = pow(input_x[0], 2) * pow(input_x[2], 2) * pow(input_x[5], 1) * pow(input_x[6], 3);
        idvd_poly_feat[4215] = pow(input_x[0], 2) * pow(input_x[2], 2) * pow(input_x[6], 4);
        idvd_poly_feat[4216] = pow(input_x[0], 2) * pow(input_x[2], 1) * pow(input_x[3], 5);
        idvd_poly_feat[4217] = pow(input_x[0], 2) * pow(input_x[2], 1) * pow(input_x[3], 4) * pow(input_x[4], 1);
        idvd_poly_feat[4218] = pow(input_x[0], 2) * pow(input_x[2], 1) * pow(input_x[3], 4) * pow(input_x[5], 1);
        idvd_poly_feat[4219] = pow(input_x[0], 2) * pow(input_x[2], 1) * pow(input_x[3], 4) * pow(input_x[6], 1);
        idvd_poly_feat[4220] = pow(input_x[0], 2) * pow(input_x[2], 1) * pow(input_x[3], 3) * pow(input_x[4], 2);
        idvd_poly_feat[4221] = pow(input_x[0], 2) * pow(input_x[2], 1) * pow(input_x[3], 3) * pow(input_x[4], 1) * pow(input_x[5], 1);
        idvd_poly_feat[4222] = pow(input_x[0], 2) * pow(input_x[2], 1) * pow(input_x[3], 3) * pow(input_x[4], 1) * pow(input_x[6], 1);
        idvd_poly_feat[4223] = pow(input_x[0], 2) * pow(input_x[2], 1) * pow(input_x[3], 3) * pow(input_x[5], 2);
        idvd_poly_feat[4224] = pow(input_x[0], 2) * pow(input_x[2], 1) * pow(input_x[3], 3) * pow(input_x[5], 1) * pow(input_x[6], 1);
        idvd_poly_feat[4225] = pow(input_x[0], 2) * pow(input_x[2], 1) * pow(input_x[3], 3) * pow(input_x[6], 2);
        idvd_poly_feat[4226] = pow(input_x[0], 2) * pow(input_x[2], 1) * pow(input_x[3], 2) * pow(input_x[4], 3);
        idvd_poly_feat[4227] = pow(input_x[0], 2) * pow(input_x[2], 1) * pow(input_x[3], 2) * pow(input_x[4], 2) * pow(input_x[5], 1);
        idvd_poly_feat[4228] = pow(input_x[0], 2) * pow(input_x[2], 1) * pow(input_x[3], 2) * pow(input_x[4], 2) * pow(input_x[6], 1);
        idvd_poly_feat[4229] = pow(input_x[0], 2) * pow(input_x[2], 1) * pow(input_x[3], 2) * pow(input_x[4], 1) * pow(input_x[5], 2);
        idvd_poly_feat[4230] = pow(input_x[0], 2) * pow(input_x[2], 1) * pow(input_x[3], 2) * pow(input_x[4], 1) * pow(input_x[5], 1) * pow(input_x[6], 1);
        idvd_poly_feat[4231] = pow(input_x[0], 2) * pow(input_x[2], 1) * pow(input_x[3], 2) * pow(input_x[4], 1) * pow(input_x[6], 2);
        idvd_poly_feat[4232] = pow(input_x[0], 2) * pow(input_x[2], 1) * pow(input_x[3], 2) * pow(input_x[5], 3);
        idvd_poly_feat[4233] = pow(input_x[0], 2) * pow(input_x[2], 1) * pow(input_x[3], 2) * pow(input_x[5], 2) * pow(input_x[6], 1);
        idvd_poly_feat[4234] = pow(input_x[0], 2) * pow(input_x[2], 1) * pow(input_x[3], 2) * pow(input_x[5], 1) * pow(input_x[6], 2);
        idvd_poly_feat[4235] = pow(input_x[0], 2) * pow(input_x[2], 1) * pow(input_x[3], 2) * pow(input_x[6], 3);
        idvd_poly_feat[4236] = pow(input_x[0], 2) * pow(input_x[2], 1) * pow(input_x[3], 1) * pow(input_x[4], 4);
        idvd_poly_feat[4237] = pow(input_x[0], 2) * pow(input_x[2], 1) * pow(input_x[3], 1) * pow(input_x[4], 3) * pow(input_x[5], 1);
        idvd_poly_feat[4238] = pow(input_x[0], 2) * pow(input_x[2], 1) * pow(input_x[3], 1) * pow(input_x[4], 3) * pow(input_x[6], 1);
        idvd_poly_feat[4239] = pow(input_x[0], 2) * pow(input_x[2], 1) * pow(input_x[3], 1) * pow(input_x[4], 2) * pow(input_x[5], 2);
        idvd_poly_feat[4240] = pow(input_x[0], 2) * pow(input_x[2], 1) * pow(input_x[3], 1) * pow(input_x[4], 2) * pow(input_x[5], 1) * pow(input_x[6], 1);
        idvd_poly_feat[4241] = pow(input_x[0], 2) * pow(input_x[2], 1) * pow(input_x[3], 1) * pow(input_x[4], 2) * pow(input_x[6], 2);
        idvd_poly_feat[4242] = pow(input_x[0], 2) * pow(input_x[2], 1) * pow(input_x[3], 1) * pow(input_x[4], 1) * pow(input_x[5], 3);
        idvd_poly_feat[4243] = pow(input_x[0], 2) * pow(input_x[2], 1) * pow(input_x[3], 1) * pow(input_x[4], 1) * pow(input_x[5], 2) * pow(input_x[6], 1);
        idvd_poly_feat[4244] = pow(input_x[0], 2) * pow(input_x[2], 1) * pow(input_x[3], 1) * pow(input_x[4], 1) * pow(input_x[5], 1) * pow(input_x[6], 2);
        idvd_poly_feat[4245] = pow(input_x[0], 2) * pow(input_x[2], 1) * pow(input_x[3], 1) * pow(input_x[4], 1) * pow(input_x[6], 3);
        idvd_poly_feat[4246] = pow(input_x[0], 2) * pow(input_x[2], 1) * pow(input_x[3], 1) * pow(input_x[5], 4);
        idvd_poly_feat[4247] = pow(input_x[0], 2) * pow(input_x[2], 1) * pow(input_x[3], 1) * pow(input_x[5], 3) * pow(input_x[6], 1);
        idvd_poly_feat[4248] = pow(input_x[0], 2) * pow(input_x[2], 1) * pow(input_x[3], 1) * pow(input_x[5], 2) * pow(input_x[6], 2);
        idvd_poly_feat[4249] = pow(input_x[0], 2) * pow(input_x[2], 1) * pow(input_x[3], 1) * pow(input_x[5], 1) * pow(input_x[6], 3);
        idvd_poly_feat[4250] = pow(input_x[0], 2) * pow(input_x[2], 1) * pow(input_x[3], 1) * pow(input_x[6], 4);
        idvd_poly_feat[4251] = pow(input_x[0], 2) * pow(input_x[2], 1) * pow(input_x[4], 5);
        idvd_poly_feat[4252] = pow(input_x[0], 2) * pow(input_x[2], 1) * pow(input_x[4], 4) * pow(input_x[5], 1);
        idvd_poly_feat[4253] = pow(input_x[0], 2) * pow(input_x[2], 1) * pow(input_x[4], 4) * pow(input_x[6], 1);
        idvd_poly_feat[4254] = pow(input_x[0], 2) * pow(input_x[2], 1) * pow(input_x[4], 3) * pow(input_x[5], 2);
        idvd_poly_feat[4255] = pow(input_x[0], 2) * pow(input_x[2], 1) * pow(input_x[4], 3) * pow(input_x[5], 1) * pow(input_x[6], 1);
        idvd_poly_feat[4256] = pow(input_x[0], 2) * pow(input_x[2], 1) * pow(input_x[4], 3) * pow(input_x[6], 2);
        idvd_poly_feat[4257] = pow(input_x[0], 2) * pow(input_x[2], 1) * pow(input_x[4], 2) * pow(input_x[5], 3);
        idvd_poly_feat[4258] = pow(input_x[0], 2) * pow(input_x[2], 1) * pow(input_x[4], 2) * pow(input_x[5], 2) * pow(input_x[6], 1);
        idvd_poly_feat[4259] = pow(input_x[0], 2) * pow(input_x[2], 1) * pow(input_x[4], 2) * pow(input_x[5], 1) * pow(input_x[6], 2);
        idvd_poly_feat[4260] = pow(input_x[0], 2) * pow(input_x[2], 1) * pow(input_x[4], 2) * pow(input_x[6], 3);
        idvd_poly_feat[4261] = pow(input_x[0], 2) * pow(input_x[2], 1) * pow(input_x[4], 1) * pow(input_x[5], 4);
        idvd_poly_feat[4262] = pow(input_x[0], 2) * pow(input_x[2], 1) * pow(input_x[4], 1) * pow(input_x[5], 3) * pow(input_x[6], 1);
        idvd_poly_feat[4263] = pow(input_x[0], 2) * pow(input_x[2], 1) * pow(input_x[4], 1) * pow(input_x[5], 2) * pow(input_x[6], 2);
        idvd_poly_feat[4264] = pow(input_x[0], 2) * pow(input_x[2], 1) * pow(input_x[4], 1) * pow(input_x[5], 1) * pow(input_x[6], 3);
        idvd_poly_feat[4265] = pow(input_x[0], 2) * pow(input_x[2], 1) * pow(input_x[4], 1) * pow(input_x[6], 4);
        idvd_poly_feat[4266] = pow(input_x[0], 2) * pow(input_x[2], 1) * pow(input_x[5], 5);
        idvd_poly_feat[4267] = pow(input_x[0], 2) * pow(input_x[2], 1) * pow(input_x[5], 4) * pow(input_x[6], 1);
        idvd_poly_feat[4268] = pow(input_x[0], 2) * pow(input_x[2], 1) * pow(input_x[5], 3) * pow(input_x[6], 2);
        idvd_poly_feat[4269] = pow(input_x[0], 2) * pow(input_x[2], 1) * pow(input_x[5], 2) * pow(input_x[6], 3);
        idvd_poly_feat[4270] = pow(input_x[0], 2) * pow(input_x[2], 1) * pow(input_x[5], 1) * pow(input_x[6], 4);
        idvd_poly_feat[4271] = pow(input_x[0], 2) * pow(input_x[2], 1) * pow(input_x[6], 5);
        idvd_poly_feat[4272] = pow(input_x[0], 2) * pow(input_x[3], 6);
        idvd_poly_feat[4273] = pow(input_x[0], 2) * pow(input_x[3], 5) * pow(input_x[4], 1);
        idvd_poly_feat[4274] = pow(input_x[0], 2) * pow(input_x[3], 5) * pow(input_x[5], 1);
        idvd_poly_feat[4275] = pow(input_x[0], 2) * pow(input_x[3], 5) * pow(input_x[6], 1);
        idvd_poly_feat[4276] = pow(input_x[0], 2) * pow(input_x[3], 4) * pow(input_x[4], 2);
        idvd_poly_feat[4277] = pow(input_x[0], 2) * pow(input_x[3], 4) * pow(input_x[4], 1) * pow(input_x[5], 1);
        idvd_poly_feat[4278] = pow(input_x[0], 2) * pow(input_x[3], 4) * pow(input_x[4], 1) * pow(input_x[6], 1);
        idvd_poly_feat[4279] = pow(input_x[0], 2) * pow(input_x[3], 4) * pow(input_x[5], 2);
        idvd_poly_feat[4280] = pow(input_x[0], 2) * pow(input_x[3], 4) * pow(input_x[5], 1) * pow(input_x[6], 1);
        idvd_poly_feat[4281] = pow(input_x[0], 2) * pow(input_x[3], 4) * pow(input_x[6], 2);
        idvd_poly_feat[4282] = pow(input_x[0], 2) * pow(input_x[3], 3) * pow(input_x[4], 3);
        idvd_poly_feat[4283] = pow(input_x[0], 2) * pow(input_x[3], 3) * pow(input_x[4], 2) * pow(input_x[5], 1);
        idvd_poly_feat[4284] = pow(input_x[0], 2) * pow(input_x[3], 3) * pow(input_x[4], 2) * pow(input_x[6], 1);
        idvd_poly_feat[4285] = pow(input_x[0], 2) * pow(input_x[3], 3) * pow(input_x[4], 1) * pow(input_x[5], 2);
        idvd_poly_feat[4286] = pow(input_x[0], 2) * pow(input_x[3], 3) * pow(input_x[4], 1) * pow(input_x[5], 1) * pow(input_x[6], 1);
        idvd_poly_feat[4287] = pow(input_x[0], 2) * pow(input_x[3], 3) * pow(input_x[4], 1) * pow(input_x[6], 2);
        idvd_poly_feat[4288] = pow(input_x[0], 2) * pow(input_x[3], 3) * pow(input_x[5], 3);
        idvd_poly_feat[4289] = pow(input_x[0], 2) * pow(input_x[3], 3) * pow(input_x[5], 2) * pow(input_x[6], 1);
        idvd_poly_feat[4290] = pow(input_x[0], 2) * pow(input_x[3], 3) * pow(input_x[5], 1) * pow(input_x[6], 2);
        idvd_poly_feat[4291] = pow(input_x[0], 2) * pow(input_x[3], 3) * pow(input_x[6], 3);
        idvd_poly_feat[4292] = pow(input_x[0], 2) * pow(input_x[3], 2) * pow(input_x[4], 4);
        idvd_poly_feat[4293] = pow(input_x[0], 2) * pow(input_x[3], 2) * pow(input_x[4], 3) * pow(input_x[5], 1);
        idvd_poly_feat[4294] = pow(input_x[0], 2) * pow(input_x[3], 2) * pow(input_x[4], 3) * pow(input_x[6], 1);
        idvd_poly_feat[4295] = pow(input_x[0], 2) * pow(input_x[3], 2) * pow(input_x[4], 2) * pow(input_x[5], 2);
        idvd_poly_feat[4296] = pow(input_x[0], 2) * pow(input_x[3], 2) * pow(input_x[4], 2) * pow(input_x[5], 1) * pow(input_x[6], 1);
        idvd_poly_feat[4297] = pow(input_x[0], 2) * pow(input_x[3], 2) * pow(input_x[4], 2) * pow(input_x[6], 2);
        idvd_poly_feat[4298] = pow(input_x[0], 2) * pow(input_x[3], 2) * pow(input_x[4], 1) * pow(input_x[5], 3);
        idvd_poly_feat[4299] = pow(input_x[0], 2) * pow(input_x[3], 2) * pow(input_x[4], 1) * pow(input_x[5], 2) * pow(input_x[6], 1);
        idvd_poly_feat[4300] = pow(input_x[0], 2) * pow(input_x[3], 2) * pow(input_x[4], 1) * pow(input_x[5], 1) * pow(input_x[6], 2);
        idvd_poly_feat[4301] = pow(input_x[0], 2) * pow(input_x[3], 2) * pow(input_x[4], 1) * pow(input_x[6], 3);
        idvd_poly_feat[4302] = pow(input_x[0], 2) * pow(input_x[3], 2) * pow(input_x[5], 4);
        idvd_poly_feat[4303] = pow(input_x[0], 2) * pow(input_x[3], 2) * pow(input_x[5], 3) * pow(input_x[6], 1);
        idvd_poly_feat[4304] = pow(input_x[0], 2) * pow(input_x[3], 2) * pow(input_x[5], 2) * pow(input_x[6], 2);
        idvd_poly_feat[4305] = pow(input_x[0], 2) * pow(input_x[3], 2) * pow(input_x[5], 1) * pow(input_x[6], 3);
        idvd_poly_feat[4306] = pow(input_x[0], 2) * pow(input_x[3], 2) * pow(input_x[6], 4);
        idvd_poly_feat[4307] = pow(input_x[0], 2) * pow(input_x[3], 1) * pow(input_x[4], 5);
        idvd_poly_feat[4308] = pow(input_x[0], 2) * pow(input_x[3], 1) * pow(input_x[4], 4) * pow(input_x[5], 1);
        idvd_poly_feat[4309] = pow(input_x[0], 2) * pow(input_x[3], 1) * pow(input_x[4], 4) * pow(input_x[6], 1);
        idvd_poly_feat[4310] = pow(input_x[0], 2) * pow(input_x[3], 1) * pow(input_x[4], 3) * pow(input_x[5], 2);
        idvd_poly_feat[4311] = pow(input_x[0], 2) * pow(input_x[3], 1) * pow(input_x[4], 3) * pow(input_x[5], 1) * pow(input_x[6], 1);
        idvd_poly_feat[4312] = pow(input_x[0], 2) * pow(input_x[3], 1) * pow(input_x[4], 3) * pow(input_x[6], 2);
        idvd_poly_feat[4313] = pow(input_x[0], 2) * pow(input_x[3], 1) * pow(input_x[4], 2) * pow(input_x[5], 3);
        idvd_poly_feat[4314] = pow(input_x[0], 2) * pow(input_x[3], 1) * pow(input_x[4], 2) * pow(input_x[5], 2) * pow(input_x[6], 1);
        idvd_poly_feat[4315] = pow(input_x[0], 2) * pow(input_x[3], 1) * pow(input_x[4], 2) * pow(input_x[5], 1) * pow(input_x[6], 2);
        idvd_poly_feat[4316] = pow(input_x[0], 2) * pow(input_x[3], 1) * pow(input_x[4], 2) * pow(input_x[6], 3);
        idvd_poly_feat[4317] = pow(input_x[0], 2) * pow(input_x[3], 1) * pow(input_x[4], 1) * pow(input_x[5], 4);
        idvd_poly_feat[4318] = pow(input_x[0], 2) * pow(input_x[3], 1) * pow(input_x[4], 1) * pow(input_x[5], 3) * pow(input_x[6], 1);
        idvd_poly_feat[4319] = pow(input_x[0], 2) * pow(input_x[3], 1) * pow(input_x[4], 1) * pow(input_x[5], 2) * pow(input_x[6], 2);
        idvd_poly_feat[4320] = pow(input_x[0], 2) * pow(input_x[3], 1) * pow(input_x[4], 1) * pow(input_x[5], 1) * pow(input_x[6], 3);
        idvd_poly_feat[4321] = pow(input_x[0], 2) * pow(input_x[3], 1) * pow(input_x[4], 1) * pow(input_x[6], 4);
        idvd_poly_feat[4322] = pow(input_x[0], 2) * pow(input_x[3], 1) * pow(input_x[5], 5);
        idvd_poly_feat[4323] = pow(input_x[0], 2) * pow(input_x[3], 1) * pow(input_x[5], 4) * pow(input_x[6], 1);
        idvd_poly_feat[4324] = pow(input_x[0], 2) * pow(input_x[3], 1) * pow(input_x[5], 3) * pow(input_x[6], 2);
        idvd_poly_feat[4325] = pow(input_x[0], 2) * pow(input_x[3], 1) * pow(input_x[5], 2) * pow(input_x[6], 3);
        idvd_poly_feat[4326] = pow(input_x[0], 2) * pow(input_x[3], 1) * pow(input_x[5], 1) * pow(input_x[6], 4);
        idvd_poly_feat[4327] = pow(input_x[0], 2) * pow(input_x[3], 1) * pow(input_x[6], 5);
        idvd_poly_feat[4328] = pow(input_x[0], 2) * pow(input_x[4], 6);
        idvd_poly_feat[4329] = pow(input_x[0], 2) * pow(input_x[4], 5) * pow(input_x[5], 1);
        idvd_poly_feat[4330] = pow(input_x[0], 2) * pow(input_x[4], 5) * pow(input_x[6], 1);
        idvd_poly_feat[4331] = pow(input_x[0], 2) * pow(input_x[4], 4) * pow(input_x[5], 2);
        idvd_poly_feat[4332] = pow(input_x[0], 2) * pow(input_x[4], 4) * pow(input_x[5], 1) * pow(input_x[6], 1);
        idvd_poly_feat[4333] = pow(input_x[0], 2) * pow(input_x[4], 4) * pow(input_x[6], 2);
        idvd_poly_feat[4334] = pow(input_x[0], 2) * pow(input_x[4], 3) * pow(input_x[5], 3);
        idvd_poly_feat[4335] = pow(input_x[0], 2) * pow(input_x[4], 3) * pow(input_x[5], 2) * pow(input_x[6], 1);
        idvd_poly_feat[4336] = pow(input_x[0], 2) * pow(input_x[4], 3) * pow(input_x[5], 1) * pow(input_x[6], 2);
        idvd_poly_feat[4337] = pow(input_x[0], 2) * pow(input_x[4], 3) * pow(input_x[6], 3);
        idvd_poly_feat[4338] = pow(input_x[0], 2) * pow(input_x[4], 2) * pow(input_x[5], 4);
        idvd_poly_feat[4339] = pow(input_x[0], 2) * pow(input_x[4], 2) * pow(input_x[5], 3) * pow(input_x[6], 1);
        idvd_poly_feat[4340] = pow(input_x[0], 2) * pow(input_x[4], 2) * pow(input_x[5], 2) * pow(input_x[6], 2);
        idvd_poly_feat[4341] = pow(input_x[0], 2) * pow(input_x[4], 2) * pow(input_x[5], 1) * pow(input_x[6], 3);
        idvd_poly_feat[4342] = pow(input_x[0], 2) * pow(input_x[4], 2) * pow(input_x[6], 4);
        idvd_poly_feat[4343] = pow(input_x[0], 2) * pow(input_x[4], 1) * pow(input_x[5], 5);
        idvd_poly_feat[4344] = pow(input_x[0], 2) * pow(input_x[4], 1) * pow(input_x[5], 4) * pow(input_x[6], 1);
        idvd_poly_feat[4345] = pow(input_x[0], 2) * pow(input_x[4], 1) * pow(input_x[5], 3) * pow(input_x[6], 2);
        idvd_poly_feat[4346] = pow(input_x[0], 2) * pow(input_x[4], 1) * pow(input_x[5], 2) * pow(input_x[6], 3);
        idvd_poly_feat[4347] = pow(input_x[0], 2) * pow(input_x[4], 1) * pow(input_x[5], 1) * pow(input_x[6], 4);
        idvd_poly_feat[4348] = pow(input_x[0], 2) * pow(input_x[4], 1) * pow(input_x[6], 5);
        idvd_poly_feat[4349] = pow(input_x[0], 2) * pow(input_x[5], 6);
        idvd_poly_feat[4350] = pow(input_x[0], 2) * pow(input_x[5], 5) * pow(input_x[6], 1);
        idvd_poly_feat[4351] = pow(input_x[0], 2) * pow(input_x[5], 4) * pow(input_x[6], 2);
        idvd_poly_feat[4352] = pow(input_x[0], 2) * pow(input_x[5], 3) * pow(input_x[6], 3);
        idvd_poly_feat[4353] = pow(input_x[0], 2) * pow(input_x[5], 2) * pow(input_x[6], 4);
        idvd_poly_feat[4354] = pow(input_x[0], 2) * pow(input_x[5], 1) * pow(input_x[6], 5);
        idvd_poly_feat[4355] = pow(input_x[0], 2) * pow(input_x[6], 6);
        idvd_poly_feat[4356] = pow(input_x[0], 1) * pow(input_x[1], 7);
        idvd_poly_feat[4357] = pow(input_x[0], 1) * pow(input_x[1], 6) * pow(input_x[2], 1);
        idvd_poly_feat[4358] = pow(input_x[0], 1) * pow(input_x[1], 6) * pow(input_x[3], 1);
        idvd_poly_feat[4359] = pow(input_x[0], 1) * pow(input_x[1], 6) * pow(input_x[4], 1);
        idvd_poly_feat[4360] = pow(input_x[0], 1) * pow(input_x[1], 6) * pow(input_x[5], 1);
        idvd_poly_feat[4361] = pow(input_x[0], 1) * pow(input_x[1], 6) * pow(input_x[6], 1);
        idvd_poly_feat[4362] = pow(input_x[0], 1) * pow(input_x[1], 5) * pow(input_x[2], 2);
        idvd_poly_feat[4363] = pow(input_x[0], 1) * pow(input_x[1], 5) * pow(input_x[2], 1) * pow(input_x[3], 1);
        idvd_poly_feat[4364] = pow(input_x[0], 1) * pow(input_x[1], 5) * pow(input_x[2], 1) * pow(input_x[4], 1);
        idvd_poly_feat[4365] = pow(input_x[0], 1) * pow(input_x[1], 5) * pow(input_x[2], 1) * pow(input_x[5], 1);
        idvd_poly_feat[4366] = pow(input_x[0], 1) * pow(input_x[1], 5) * pow(input_x[2], 1) * pow(input_x[6], 1);
        idvd_poly_feat[4367] = pow(input_x[0], 1) * pow(input_x[1], 5) * pow(input_x[3], 2);
        idvd_poly_feat[4368] = pow(input_x[0], 1) * pow(input_x[1], 5) * pow(input_x[3], 1) * pow(input_x[4], 1);
        idvd_poly_feat[4369] = pow(input_x[0], 1) * pow(input_x[1], 5) * pow(input_x[3], 1) * pow(input_x[5], 1);
        idvd_poly_feat[4370] = pow(input_x[0], 1) * pow(input_x[1], 5) * pow(input_x[3], 1) * pow(input_x[6], 1);
        idvd_poly_feat[4371] = pow(input_x[0], 1) * pow(input_x[1], 5) * pow(input_x[4], 2);
        idvd_poly_feat[4372] = pow(input_x[0], 1) * pow(input_x[1], 5) * pow(input_x[4], 1) * pow(input_x[5], 1);
        idvd_poly_feat[4373] = pow(input_x[0], 1) * pow(input_x[1], 5) * pow(input_x[4], 1) * pow(input_x[6], 1);
        idvd_poly_feat[4374] = pow(input_x[0], 1) * pow(input_x[1], 5) * pow(input_x[5], 2);
        idvd_poly_feat[4375] = pow(input_x[0], 1) * pow(input_x[1], 5) * pow(input_x[5], 1) * pow(input_x[6], 1);
        idvd_poly_feat[4376] = pow(input_x[0], 1) * pow(input_x[1], 5) * pow(input_x[6], 2);
        idvd_poly_feat[4377] = pow(input_x[0], 1) * pow(input_x[1], 4) * pow(input_x[2], 3);
        idvd_poly_feat[4378] = pow(input_x[0], 1) * pow(input_x[1], 4) * pow(input_x[2], 2) * pow(input_x[3], 1);
        idvd_poly_feat[4379] = pow(input_x[0], 1) * pow(input_x[1], 4) * pow(input_x[2], 2) * pow(input_x[4], 1);
        idvd_poly_feat[4380] = pow(input_x[0], 1) * pow(input_x[1], 4) * pow(input_x[2], 2) * pow(input_x[5], 1);
        idvd_poly_feat[4381] = pow(input_x[0], 1) * pow(input_x[1], 4) * pow(input_x[2], 2) * pow(input_x[6], 1);
        idvd_poly_feat[4382] = pow(input_x[0], 1) * pow(input_x[1], 4) * pow(input_x[2], 1) * pow(input_x[3], 2);
        idvd_poly_feat[4383] = pow(input_x[0], 1) * pow(input_x[1], 4) * pow(input_x[2], 1) * pow(input_x[3], 1) * pow(input_x[4], 1);
        idvd_poly_feat[4384] = pow(input_x[0], 1) * pow(input_x[1], 4) * pow(input_x[2], 1) * pow(input_x[3], 1) * pow(input_x[5], 1);
        idvd_poly_feat[4385] = pow(input_x[0], 1) * pow(input_x[1], 4) * pow(input_x[2], 1) * pow(input_x[3], 1) * pow(input_x[6], 1);
        idvd_poly_feat[4386] = pow(input_x[0], 1) * pow(input_x[1], 4) * pow(input_x[2], 1) * pow(input_x[4], 2);
        idvd_poly_feat[4387] = pow(input_x[0], 1) * pow(input_x[1], 4) * pow(input_x[2], 1) * pow(input_x[4], 1) * pow(input_x[5], 1);
        idvd_poly_feat[4388] = pow(input_x[0], 1) * pow(input_x[1], 4) * pow(input_x[2], 1) * pow(input_x[4], 1) * pow(input_x[6], 1);
        idvd_poly_feat[4389] = pow(input_x[0], 1) * pow(input_x[1], 4) * pow(input_x[2], 1) * pow(input_x[5], 2);
        idvd_poly_feat[4390] = pow(input_x[0], 1) * pow(input_x[1], 4) * pow(input_x[2], 1) * pow(input_x[5], 1) * pow(input_x[6], 1);
        idvd_poly_feat[4391] = pow(input_x[0], 1) * pow(input_x[1], 4) * pow(input_x[2], 1) * pow(input_x[6], 2);
        idvd_poly_feat[4392] = pow(input_x[0], 1) * pow(input_x[1], 4) * pow(input_x[3], 3);
        idvd_poly_feat[4393] = pow(input_x[0], 1) * pow(input_x[1], 4) * pow(input_x[3], 2) * pow(input_x[4], 1);
        idvd_poly_feat[4394] = pow(input_x[0], 1) * pow(input_x[1], 4) * pow(input_x[3], 2) * pow(input_x[5], 1);
        idvd_poly_feat[4395] = pow(input_x[0], 1) * pow(input_x[1], 4) * pow(input_x[3], 2) * pow(input_x[6], 1);
        idvd_poly_feat[4396] = pow(input_x[0], 1) * pow(input_x[1], 4) * pow(input_x[3], 1) * pow(input_x[4], 2);
        idvd_poly_feat[4397] = pow(input_x[0], 1) * pow(input_x[1], 4) * pow(input_x[3], 1) * pow(input_x[4], 1) * pow(input_x[5], 1);
        idvd_poly_feat[4398] = pow(input_x[0], 1) * pow(input_x[1], 4) * pow(input_x[3], 1) * pow(input_x[4], 1) * pow(input_x[6], 1);
        idvd_poly_feat[4399] = pow(input_x[0], 1) * pow(input_x[1], 4) * pow(input_x[3], 1) * pow(input_x[5], 2);
        idvd_poly_feat[4400] = pow(input_x[0], 1) * pow(input_x[1], 4) * pow(input_x[3], 1) * pow(input_x[5], 1) * pow(input_x[6], 1);
        idvd_poly_feat[4401] = pow(input_x[0], 1) * pow(input_x[1], 4) * pow(input_x[3], 1) * pow(input_x[6], 2);
        idvd_poly_feat[4402] = pow(input_x[0], 1) * pow(input_x[1], 4) * pow(input_x[4], 3);
        idvd_poly_feat[4403] = pow(input_x[0], 1) * pow(input_x[1], 4) * pow(input_x[4], 2) * pow(input_x[5], 1);
        idvd_poly_feat[4404] = pow(input_x[0], 1) * pow(input_x[1], 4) * pow(input_x[4], 2) * pow(input_x[6], 1);
        idvd_poly_feat[4405] = pow(input_x[0], 1) * pow(input_x[1], 4) * pow(input_x[4], 1) * pow(input_x[5], 2);
        idvd_poly_feat[4406] = pow(input_x[0], 1) * pow(input_x[1], 4) * pow(input_x[4], 1) * pow(input_x[5], 1) * pow(input_x[6], 1);
        idvd_poly_feat[4407] = pow(input_x[0], 1) * pow(input_x[1], 4) * pow(input_x[4], 1) * pow(input_x[6], 2);
        idvd_poly_feat[4408] = pow(input_x[0], 1) * pow(input_x[1], 4) * pow(input_x[5], 3);
        idvd_poly_feat[4409] = pow(input_x[0], 1) * pow(input_x[1], 4) * pow(input_x[5], 2) * pow(input_x[6], 1);
        idvd_poly_feat[4410] = pow(input_x[0], 1) * pow(input_x[1], 4) * pow(input_x[5], 1) * pow(input_x[6], 2);
        idvd_poly_feat[4411] = pow(input_x[0], 1) * pow(input_x[1], 4) * pow(input_x[6], 3);
        idvd_poly_feat[4412] = pow(input_x[0], 1) * pow(input_x[1], 3) * pow(input_x[2], 4);
        idvd_poly_feat[4413] = pow(input_x[0], 1) * pow(input_x[1], 3) * pow(input_x[2], 3) * pow(input_x[3], 1);
        idvd_poly_feat[4414] = pow(input_x[0], 1) * pow(input_x[1], 3) * pow(input_x[2], 3) * pow(input_x[4], 1);
        idvd_poly_feat[4415] = pow(input_x[0], 1) * pow(input_x[1], 3) * pow(input_x[2], 3) * pow(input_x[5], 1);
        idvd_poly_feat[4416] = pow(input_x[0], 1) * pow(input_x[1], 3) * pow(input_x[2], 3) * pow(input_x[6], 1);
        idvd_poly_feat[4417] = pow(input_x[0], 1) * pow(input_x[1], 3) * pow(input_x[2], 2) * pow(input_x[3], 2);
        idvd_poly_feat[4418] = pow(input_x[0], 1) * pow(input_x[1], 3) * pow(input_x[2], 2) * pow(input_x[3], 1) * pow(input_x[4], 1);
        idvd_poly_feat[4419] = pow(input_x[0], 1) * pow(input_x[1], 3) * pow(input_x[2], 2) * pow(input_x[3], 1) * pow(input_x[5], 1);
        idvd_poly_feat[4420] = pow(input_x[0], 1) * pow(input_x[1], 3) * pow(input_x[2], 2) * pow(input_x[3], 1) * pow(input_x[6], 1);
        idvd_poly_feat[4421] = pow(input_x[0], 1) * pow(input_x[1], 3) * pow(input_x[2], 2) * pow(input_x[4], 2);
        idvd_poly_feat[4422] = pow(input_x[0], 1) * pow(input_x[1], 3) * pow(input_x[2], 2) * pow(input_x[4], 1) * pow(input_x[5], 1);
        idvd_poly_feat[4423] = pow(input_x[0], 1) * pow(input_x[1], 3) * pow(input_x[2], 2) * pow(input_x[4], 1) * pow(input_x[6], 1);
        idvd_poly_feat[4424] = pow(input_x[0], 1) * pow(input_x[1], 3) * pow(input_x[2], 2) * pow(input_x[5], 2);
        idvd_poly_feat[4425] = pow(input_x[0], 1) * pow(input_x[1], 3) * pow(input_x[2], 2) * pow(input_x[5], 1) * pow(input_x[6], 1);
        idvd_poly_feat[4426] = pow(input_x[0], 1) * pow(input_x[1], 3) * pow(input_x[2], 2) * pow(input_x[6], 2);
        idvd_poly_feat[4427] = pow(input_x[0], 1) * pow(input_x[1], 3) * pow(input_x[2], 1) * pow(input_x[3], 3);
        idvd_poly_feat[4428] = pow(input_x[0], 1) * pow(input_x[1], 3) * pow(input_x[2], 1) * pow(input_x[3], 2) * pow(input_x[4], 1);
        idvd_poly_feat[4429] = pow(input_x[0], 1) * pow(input_x[1], 3) * pow(input_x[2], 1) * pow(input_x[3], 2) * pow(input_x[5], 1);
        idvd_poly_feat[4430] = pow(input_x[0], 1) * pow(input_x[1], 3) * pow(input_x[2], 1) * pow(input_x[3], 2) * pow(input_x[6], 1);
        idvd_poly_feat[4431] = pow(input_x[0], 1) * pow(input_x[1], 3) * pow(input_x[2], 1) * pow(input_x[3], 1) * pow(input_x[4], 2);
        idvd_poly_feat[4432] = pow(input_x[0], 1) * pow(input_x[1], 3) * pow(input_x[2], 1) * pow(input_x[3], 1) * pow(input_x[4], 1) * pow(input_x[5], 1);
        idvd_poly_feat[4433] = pow(input_x[0], 1) * pow(input_x[1], 3) * pow(input_x[2], 1) * pow(input_x[3], 1) * pow(input_x[4], 1) * pow(input_x[6], 1);
        idvd_poly_feat[4434] = pow(input_x[0], 1) * pow(input_x[1], 3) * pow(input_x[2], 1) * pow(input_x[3], 1) * pow(input_x[5], 2);
        idvd_poly_feat[4435] = pow(input_x[0], 1) * pow(input_x[1], 3) * pow(input_x[2], 1) * pow(input_x[3], 1) * pow(input_x[5], 1) * pow(input_x[6], 1);
        idvd_poly_feat[4436] = pow(input_x[0], 1) * pow(input_x[1], 3) * pow(input_x[2], 1) * pow(input_x[3], 1) * pow(input_x[6], 2);
        idvd_poly_feat[4437] = pow(input_x[0], 1) * pow(input_x[1], 3) * pow(input_x[2], 1) * pow(input_x[4], 3);
        idvd_poly_feat[4438] = pow(input_x[0], 1) * pow(input_x[1], 3) * pow(input_x[2], 1) * pow(input_x[4], 2) * pow(input_x[5], 1);
        idvd_poly_feat[4439] = pow(input_x[0], 1) * pow(input_x[1], 3) * pow(input_x[2], 1) * pow(input_x[4], 2) * pow(input_x[6], 1);
        idvd_poly_feat[4440] = pow(input_x[0], 1) * pow(input_x[1], 3) * pow(input_x[2], 1) * pow(input_x[4], 1) * pow(input_x[5], 2);
        idvd_poly_feat[4441] = pow(input_x[0], 1) * pow(input_x[1], 3) * pow(input_x[2], 1) * pow(input_x[4], 1) * pow(input_x[5], 1) * pow(input_x[6], 1);
        idvd_poly_feat[4442] = pow(input_x[0], 1) * pow(input_x[1], 3) * pow(input_x[2], 1) * pow(input_x[4], 1) * pow(input_x[6], 2);
        idvd_poly_feat[4443] = pow(input_x[0], 1) * pow(input_x[1], 3) * pow(input_x[2], 1) * pow(input_x[5], 3);
        idvd_poly_feat[4444] = pow(input_x[0], 1) * pow(input_x[1], 3) * pow(input_x[2], 1) * pow(input_x[5], 2) * pow(input_x[6], 1);
        idvd_poly_feat[4445] = pow(input_x[0], 1) * pow(input_x[1], 3) * pow(input_x[2], 1) * pow(input_x[5], 1) * pow(input_x[6], 2);
        idvd_poly_feat[4446] = pow(input_x[0], 1) * pow(input_x[1], 3) * pow(input_x[2], 1) * pow(input_x[6], 3);
        idvd_poly_feat[4447] = pow(input_x[0], 1) * pow(input_x[1], 3) * pow(input_x[3], 4);
        idvd_poly_feat[4448] = pow(input_x[0], 1) * pow(input_x[1], 3) * pow(input_x[3], 3) * pow(input_x[4], 1);
        idvd_poly_feat[4449] = pow(input_x[0], 1) * pow(input_x[1], 3) * pow(input_x[3], 3) * pow(input_x[5], 1);
        idvd_poly_feat[4450] = pow(input_x[0], 1) * pow(input_x[1], 3) * pow(input_x[3], 3) * pow(input_x[6], 1);
        idvd_poly_feat[4451] = pow(input_x[0], 1) * pow(input_x[1], 3) * pow(input_x[3], 2) * pow(input_x[4], 2);
        idvd_poly_feat[4452] = pow(input_x[0], 1) * pow(input_x[1], 3) * pow(input_x[3], 2) * pow(input_x[4], 1) * pow(input_x[5], 1);
        idvd_poly_feat[4453] = pow(input_x[0], 1) * pow(input_x[1], 3) * pow(input_x[3], 2) * pow(input_x[4], 1) * pow(input_x[6], 1);
        idvd_poly_feat[4454] = pow(input_x[0], 1) * pow(input_x[1], 3) * pow(input_x[3], 2) * pow(input_x[5], 2);
        idvd_poly_feat[4455] = pow(input_x[0], 1) * pow(input_x[1], 3) * pow(input_x[3], 2) * pow(input_x[5], 1) * pow(input_x[6], 1);
        idvd_poly_feat[4456] = pow(input_x[0], 1) * pow(input_x[1], 3) * pow(input_x[3], 2) * pow(input_x[6], 2);
        idvd_poly_feat[4457] = pow(input_x[0], 1) * pow(input_x[1], 3) * pow(input_x[3], 1) * pow(input_x[4], 3);
        idvd_poly_feat[4458] = pow(input_x[0], 1) * pow(input_x[1], 3) * pow(input_x[3], 1) * pow(input_x[4], 2) * pow(input_x[5], 1);
        idvd_poly_feat[4459] = pow(input_x[0], 1) * pow(input_x[1], 3) * pow(input_x[3], 1) * pow(input_x[4], 2) * pow(input_x[6], 1);
        idvd_poly_feat[4460] = pow(input_x[0], 1) * pow(input_x[1], 3) * pow(input_x[3], 1) * pow(input_x[4], 1) * pow(input_x[5], 2);
        idvd_poly_feat[4461] = pow(input_x[0], 1) * pow(input_x[1], 3) * pow(input_x[3], 1) * pow(input_x[4], 1) * pow(input_x[5], 1) * pow(input_x[6], 1);
        idvd_poly_feat[4462] = pow(input_x[0], 1) * pow(input_x[1], 3) * pow(input_x[3], 1) * pow(input_x[4], 1) * pow(input_x[6], 2);
        idvd_poly_feat[4463] = pow(input_x[0], 1) * pow(input_x[1], 3) * pow(input_x[3], 1) * pow(input_x[5], 3);
        idvd_poly_feat[4464] = pow(input_x[0], 1) * pow(input_x[1], 3) * pow(input_x[3], 1) * pow(input_x[5], 2) * pow(input_x[6], 1);
        idvd_poly_feat[4465] = pow(input_x[0], 1) * pow(input_x[1], 3) * pow(input_x[3], 1) * pow(input_x[5], 1) * pow(input_x[6], 2);
        idvd_poly_feat[4466] = pow(input_x[0], 1) * pow(input_x[1], 3) * pow(input_x[3], 1) * pow(input_x[6], 3);
        idvd_poly_feat[4467] = pow(input_x[0], 1) * pow(input_x[1], 3) * pow(input_x[4], 4);
        idvd_poly_feat[4468] = pow(input_x[0], 1) * pow(input_x[1], 3) * pow(input_x[4], 3) * pow(input_x[5], 1);
        idvd_poly_feat[4469] = pow(input_x[0], 1) * pow(input_x[1], 3) * pow(input_x[4], 3) * pow(input_x[6], 1);
        idvd_poly_feat[4470] = pow(input_x[0], 1) * pow(input_x[1], 3) * pow(input_x[4], 2) * pow(input_x[5], 2);
        idvd_poly_feat[4471] = pow(input_x[0], 1) * pow(input_x[1], 3) * pow(input_x[4], 2) * pow(input_x[5], 1) * pow(input_x[6], 1);
        idvd_poly_feat[4472] = pow(input_x[0], 1) * pow(input_x[1], 3) * pow(input_x[4], 2) * pow(input_x[6], 2);
        idvd_poly_feat[4473] = pow(input_x[0], 1) * pow(input_x[1], 3) * pow(input_x[4], 1) * pow(input_x[5], 3);
        idvd_poly_feat[4474] = pow(input_x[0], 1) * pow(input_x[1], 3) * pow(input_x[4], 1) * pow(input_x[5], 2) * pow(input_x[6], 1);
        idvd_poly_feat[4475] = pow(input_x[0], 1) * pow(input_x[1], 3) * pow(input_x[4], 1) * pow(input_x[5], 1) * pow(input_x[6], 2);
        idvd_poly_feat[4476] = pow(input_x[0], 1) * pow(input_x[1], 3) * pow(input_x[4], 1) * pow(input_x[6], 3);
        idvd_poly_feat[4477] = pow(input_x[0], 1) * pow(input_x[1], 3) * pow(input_x[5], 4);
        idvd_poly_feat[4478] = pow(input_x[0], 1) * pow(input_x[1], 3) * pow(input_x[5], 3) * pow(input_x[6], 1);
        idvd_poly_feat[4479] = pow(input_x[0], 1) * pow(input_x[1], 3) * pow(input_x[5], 2) * pow(input_x[6], 2);
        idvd_poly_feat[4480] = pow(input_x[0], 1) * pow(input_x[1], 3) * pow(input_x[5], 1) * pow(input_x[6], 3);
        idvd_poly_feat[4481] = pow(input_x[0], 1) * pow(input_x[1], 3) * pow(input_x[6], 4);
        idvd_poly_feat[4482] = pow(input_x[0], 1) * pow(input_x[1], 2) * pow(input_x[2], 5);
        idvd_poly_feat[4483] = pow(input_x[0], 1) * pow(input_x[1], 2) * pow(input_x[2], 4) * pow(input_x[3], 1);
        idvd_poly_feat[4484] = pow(input_x[0], 1) * pow(input_x[1], 2) * pow(input_x[2], 4) * pow(input_x[4], 1);
        idvd_poly_feat[4485] = pow(input_x[0], 1) * pow(input_x[1], 2) * pow(input_x[2], 4) * pow(input_x[5], 1);
        idvd_poly_feat[4486] = pow(input_x[0], 1) * pow(input_x[1], 2) * pow(input_x[2], 4) * pow(input_x[6], 1);
        idvd_poly_feat[4487] = pow(input_x[0], 1) * pow(input_x[1], 2) * pow(input_x[2], 3) * pow(input_x[3], 2);
        idvd_poly_feat[4488] = pow(input_x[0], 1) * pow(input_x[1], 2) * pow(input_x[2], 3) * pow(input_x[3], 1) * pow(input_x[4], 1);
        idvd_poly_feat[4489] = pow(input_x[0], 1) * pow(input_x[1], 2) * pow(input_x[2], 3) * pow(input_x[3], 1) * pow(input_x[5], 1);
        idvd_poly_feat[4490] = pow(input_x[0], 1) * pow(input_x[1], 2) * pow(input_x[2], 3) * pow(input_x[3], 1) * pow(input_x[6], 1);
        idvd_poly_feat[4491] = pow(input_x[0], 1) * pow(input_x[1], 2) * pow(input_x[2], 3) * pow(input_x[4], 2);
        idvd_poly_feat[4492] = pow(input_x[0], 1) * pow(input_x[1], 2) * pow(input_x[2], 3) * pow(input_x[4], 1) * pow(input_x[5], 1);
        idvd_poly_feat[4493] = pow(input_x[0], 1) * pow(input_x[1], 2) * pow(input_x[2], 3) * pow(input_x[4], 1) * pow(input_x[6], 1);
        idvd_poly_feat[4494] = pow(input_x[0], 1) * pow(input_x[1], 2) * pow(input_x[2], 3) * pow(input_x[5], 2);
        idvd_poly_feat[4495] = pow(input_x[0], 1) * pow(input_x[1], 2) * pow(input_x[2], 3) * pow(input_x[5], 1) * pow(input_x[6], 1);
        idvd_poly_feat[4496] = pow(input_x[0], 1) * pow(input_x[1], 2) * pow(input_x[2], 3) * pow(input_x[6], 2);
        idvd_poly_feat[4497] = pow(input_x[0], 1) * pow(input_x[1], 2) * pow(input_x[2], 2) * pow(input_x[3], 3);
        idvd_poly_feat[4498] = pow(input_x[0], 1) * pow(input_x[1], 2) * pow(input_x[2], 2) * pow(input_x[3], 2) * pow(input_x[4], 1);
        idvd_poly_feat[4499] = pow(input_x[0], 1) * pow(input_x[1], 2) * pow(input_x[2], 2) * pow(input_x[3], 2) * pow(input_x[5], 1);
        idvd_poly_feat[4500] = pow(input_x[0], 1) * pow(input_x[1], 2) * pow(input_x[2], 2) * pow(input_x[3], 2) * pow(input_x[6], 1);
        idvd_poly_feat[4501] = pow(input_x[0], 1) * pow(input_x[1], 2) * pow(input_x[2], 2) * pow(input_x[3], 1) * pow(input_x[4], 2);
        idvd_poly_feat[4502] = pow(input_x[0], 1) * pow(input_x[1], 2) * pow(input_x[2], 2) * pow(input_x[3], 1) * pow(input_x[4], 1) * pow(input_x[5], 1);
        idvd_poly_feat[4503] = pow(input_x[0], 1) * pow(input_x[1], 2) * pow(input_x[2], 2) * pow(input_x[3], 1) * pow(input_x[4], 1) * pow(input_x[6], 1);
        idvd_poly_feat[4504] = pow(input_x[0], 1) * pow(input_x[1], 2) * pow(input_x[2], 2) * pow(input_x[3], 1) * pow(input_x[5], 2);
        idvd_poly_feat[4505] = pow(input_x[0], 1) * pow(input_x[1], 2) * pow(input_x[2], 2) * pow(input_x[3], 1) * pow(input_x[5], 1) * pow(input_x[6], 1);
        idvd_poly_feat[4506] = pow(input_x[0], 1) * pow(input_x[1], 2) * pow(input_x[2], 2) * pow(input_x[3], 1) * pow(input_x[6], 2);
        idvd_poly_feat[4507] = pow(input_x[0], 1) * pow(input_x[1], 2) * pow(input_x[2], 2) * pow(input_x[4], 3);
        idvd_poly_feat[4508] = pow(input_x[0], 1) * pow(input_x[1], 2) * pow(input_x[2], 2) * pow(input_x[4], 2) * pow(input_x[5], 1);
        idvd_poly_feat[4509] = pow(input_x[0], 1) * pow(input_x[1], 2) * pow(input_x[2], 2) * pow(input_x[4], 2) * pow(input_x[6], 1);
        idvd_poly_feat[4510] = pow(input_x[0], 1) * pow(input_x[1], 2) * pow(input_x[2], 2) * pow(input_x[4], 1) * pow(input_x[5], 2);
        idvd_poly_feat[4511] = pow(input_x[0], 1) * pow(input_x[1], 2) * pow(input_x[2], 2) * pow(input_x[4], 1) * pow(input_x[5], 1) * pow(input_x[6], 1);
        idvd_poly_feat[4512] = pow(input_x[0], 1) * pow(input_x[1], 2) * pow(input_x[2], 2) * pow(input_x[4], 1) * pow(input_x[6], 2);
        idvd_poly_feat[4513] = pow(input_x[0], 1) * pow(input_x[1], 2) * pow(input_x[2], 2) * pow(input_x[5], 3);
        idvd_poly_feat[4514] = pow(input_x[0], 1) * pow(input_x[1], 2) * pow(input_x[2], 2) * pow(input_x[5], 2) * pow(input_x[6], 1);
        idvd_poly_feat[4515] = pow(input_x[0], 1) * pow(input_x[1], 2) * pow(input_x[2], 2) * pow(input_x[5], 1) * pow(input_x[6], 2);
        idvd_poly_feat[4516] = pow(input_x[0], 1) * pow(input_x[1], 2) * pow(input_x[2], 2) * pow(input_x[6], 3);
        idvd_poly_feat[4517] = pow(input_x[0], 1) * pow(input_x[1], 2) * pow(input_x[2], 1) * pow(input_x[3], 4);
        idvd_poly_feat[4518] = pow(input_x[0], 1) * pow(input_x[1], 2) * pow(input_x[2], 1) * pow(input_x[3], 3) * pow(input_x[4], 1);
        idvd_poly_feat[4519] = pow(input_x[0], 1) * pow(input_x[1], 2) * pow(input_x[2], 1) * pow(input_x[3], 3) * pow(input_x[5], 1);
        idvd_poly_feat[4520] = pow(input_x[0], 1) * pow(input_x[1], 2) * pow(input_x[2], 1) * pow(input_x[3], 3) * pow(input_x[6], 1);
        idvd_poly_feat[4521] = pow(input_x[0], 1) * pow(input_x[1], 2) * pow(input_x[2], 1) * pow(input_x[3], 2) * pow(input_x[4], 2);
        idvd_poly_feat[4522] = pow(input_x[0], 1) * pow(input_x[1], 2) * pow(input_x[2], 1) * pow(input_x[3], 2) * pow(input_x[4], 1) * pow(input_x[5], 1);
        idvd_poly_feat[4523] = pow(input_x[0], 1) * pow(input_x[1], 2) * pow(input_x[2], 1) * pow(input_x[3], 2) * pow(input_x[4], 1) * pow(input_x[6], 1);
        idvd_poly_feat[4524] = pow(input_x[0], 1) * pow(input_x[1], 2) * pow(input_x[2], 1) * pow(input_x[3], 2) * pow(input_x[5], 2);
        idvd_poly_feat[4525] = pow(input_x[0], 1) * pow(input_x[1], 2) * pow(input_x[2], 1) * pow(input_x[3], 2) * pow(input_x[5], 1) * pow(input_x[6], 1);
        idvd_poly_feat[4526] = pow(input_x[0], 1) * pow(input_x[1], 2) * pow(input_x[2], 1) * pow(input_x[3], 2) * pow(input_x[6], 2);
        idvd_poly_feat[4527] = pow(input_x[0], 1) * pow(input_x[1], 2) * pow(input_x[2], 1) * pow(input_x[3], 1) * pow(input_x[4], 3);
        idvd_poly_feat[4528] = pow(input_x[0], 1) * pow(input_x[1], 2) * pow(input_x[2], 1) * pow(input_x[3], 1) * pow(input_x[4], 2) * pow(input_x[5], 1);
        idvd_poly_feat[4529] = pow(input_x[0], 1) * pow(input_x[1], 2) * pow(input_x[2], 1) * pow(input_x[3], 1) * pow(input_x[4], 2) * pow(input_x[6], 1);
        idvd_poly_feat[4530] = pow(input_x[0], 1) * pow(input_x[1], 2) * pow(input_x[2], 1) * pow(input_x[3], 1) * pow(input_x[4], 1) * pow(input_x[5], 2);
        idvd_poly_feat[4531] = pow(input_x[0], 1) * pow(input_x[1], 2) * pow(input_x[2], 1) * pow(input_x[3], 1) * pow(input_x[4], 1) * pow(input_x[5], 1) * pow(input_x[6], 1);
        idvd_poly_feat[4532] = pow(input_x[0], 1) * pow(input_x[1], 2) * pow(input_x[2], 1) * pow(input_x[3], 1) * pow(input_x[4], 1) * pow(input_x[6], 2);
        idvd_poly_feat[4533] = pow(input_x[0], 1) * pow(input_x[1], 2) * pow(input_x[2], 1) * pow(input_x[3], 1) * pow(input_x[5], 3);
        idvd_poly_feat[4534] = pow(input_x[0], 1) * pow(input_x[1], 2) * pow(input_x[2], 1) * pow(input_x[3], 1) * pow(input_x[5], 2) * pow(input_x[6], 1);
        idvd_poly_feat[4535] = pow(input_x[0], 1) * pow(input_x[1], 2) * pow(input_x[2], 1) * pow(input_x[3], 1) * pow(input_x[5], 1) * pow(input_x[6], 2);
        idvd_poly_feat[4536] = pow(input_x[0], 1) * pow(input_x[1], 2) * pow(input_x[2], 1) * pow(input_x[3], 1) * pow(input_x[6], 3);
        idvd_poly_feat[4537] = pow(input_x[0], 1) * pow(input_x[1], 2) * pow(input_x[2], 1) * pow(input_x[4], 4);
        idvd_poly_feat[4538] = pow(input_x[0], 1) * pow(input_x[1], 2) * pow(input_x[2], 1) * pow(input_x[4], 3) * pow(input_x[5], 1);
        idvd_poly_feat[4539] = pow(input_x[0], 1) * pow(input_x[1], 2) * pow(input_x[2], 1) * pow(input_x[4], 3) * pow(input_x[6], 1);
        idvd_poly_feat[4540] = pow(input_x[0], 1) * pow(input_x[1], 2) * pow(input_x[2], 1) * pow(input_x[4], 2) * pow(input_x[5], 2);
        idvd_poly_feat[4541] = pow(input_x[0], 1) * pow(input_x[1], 2) * pow(input_x[2], 1) * pow(input_x[4], 2) * pow(input_x[5], 1) * pow(input_x[6], 1);
        idvd_poly_feat[4542] = pow(input_x[0], 1) * pow(input_x[1], 2) * pow(input_x[2], 1) * pow(input_x[4], 2) * pow(input_x[6], 2);
        idvd_poly_feat[4543] = pow(input_x[0], 1) * pow(input_x[1], 2) * pow(input_x[2], 1) * pow(input_x[4], 1) * pow(input_x[5], 3);
        idvd_poly_feat[4544] = pow(input_x[0], 1) * pow(input_x[1], 2) * pow(input_x[2], 1) * pow(input_x[4], 1) * pow(input_x[5], 2) * pow(input_x[6], 1);
        idvd_poly_feat[4545] = pow(input_x[0], 1) * pow(input_x[1], 2) * pow(input_x[2], 1) * pow(input_x[4], 1) * pow(input_x[5], 1) * pow(input_x[6], 2);
        idvd_poly_feat[4546] = pow(input_x[0], 1) * pow(input_x[1], 2) * pow(input_x[2], 1) * pow(input_x[4], 1) * pow(input_x[6], 3);
        idvd_poly_feat[4547] = pow(input_x[0], 1) * pow(input_x[1], 2) * pow(input_x[2], 1) * pow(input_x[5], 4);
        idvd_poly_feat[4548] = pow(input_x[0], 1) * pow(input_x[1], 2) * pow(input_x[2], 1) * pow(input_x[5], 3) * pow(input_x[6], 1);
        idvd_poly_feat[4549] = pow(input_x[0], 1) * pow(input_x[1], 2) * pow(input_x[2], 1) * pow(input_x[5], 2) * pow(input_x[6], 2);
        idvd_poly_feat[4550] = pow(input_x[0], 1) * pow(input_x[1], 2) * pow(input_x[2], 1) * pow(input_x[5], 1) * pow(input_x[6], 3);
        idvd_poly_feat[4551] = pow(input_x[0], 1) * pow(input_x[1], 2) * pow(input_x[2], 1) * pow(input_x[6], 4);
        idvd_poly_feat[4552] = pow(input_x[0], 1) * pow(input_x[1], 2) * pow(input_x[3], 5);
        idvd_poly_feat[4553] = pow(input_x[0], 1) * pow(input_x[1], 2) * pow(input_x[3], 4) * pow(input_x[4], 1);
        idvd_poly_feat[4554] = pow(input_x[0], 1) * pow(input_x[1], 2) * pow(input_x[3], 4) * pow(input_x[5], 1);
        idvd_poly_feat[4555] = pow(input_x[0], 1) * pow(input_x[1], 2) * pow(input_x[3], 4) * pow(input_x[6], 1);
        idvd_poly_feat[4556] = pow(input_x[0], 1) * pow(input_x[1], 2) * pow(input_x[3], 3) * pow(input_x[4], 2);
        idvd_poly_feat[4557] = pow(input_x[0], 1) * pow(input_x[1], 2) * pow(input_x[3], 3) * pow(input_x[4], 1) * pow(input_x[5], 1);
        idvd_poly_feat[4558] = pow(input_x[0], 1) * pow(input_x[1], 2) * pow(input_x[3], 3) * pow(input_x[4], 1) * pow(input_x[6], 1);
        idvd_poly_feat[4559] = pow(input_x[0], 1) * pow(input_x[1], 2) * pow(input_x[3], 3) * pow(input_x[5], 2);
        idvd_poly_feat[4560] = pow(input_x[0], 1) * pow(input_x[1], 2) * pow(input_x[3], 3) * pow(input_x[5], 1) * pow(input_x[6], 1);
        idvd_poly_feat[4561] = pow(input_x[0], 1) * pow(input_x[1], 2) * pow(input_x[3], 3) * pow(input_x[6], 2);
        idvd_poly_feat[4562] = pow(input_x[0], 1) * pow(input_x[1], 2) * pow(input_x[3], 2) * pow(input_x[4], 3);
        idvd_poly_feat[4563] = pow(input_x[0], 1) * pow(input_x[1], 2) * pow(input_x[3], 2) * pow(input_x[4], 2) * pow(input_x[5], 1);
        idvd_poly_feat[4564] = pow(input_x[0], 1) * pow(input_x[1], 2) * pow(input_x[3], 2) * pow(input_x[4], 2) * pow(input_x[6], 1);
        idvd_poly_feat[4565] = pow(input_x[0], 1) * pow(input_x[1], 2) * pow(input_x[3], 2) * pow(input_x[4], 1) * pow(input_x[5], 2);
        idvd_poly_feat[4566] = pow(input_x[0], 1) * pow(input_x[1], 2) * pow(input_x[3], 2) * pow(input_x[4], 1) * pow(input_x[5], 1) * pow(input_x[6], 1);
        idvd_poly_feat[4567] = pow(input_x[0], 1) * pow(input_x[1], 2) * pow(input_x[3], 2) * pow(input_x[4], 1) * pow(input_x[6], 2);
        idvd_poly_feat[4568] = pow(input_x[0], 1) * pow(input_x[1], 2) * pow(input_x[3], 2) * pow(input_x[5], 3);
        idvd_poly_feat[4569] = pow(input_x[0], 1) * pow(input_x[1], 2) * pow(input_x[3], 2) * pow(input_x[5], 2) * pow(input_x[6], 1);
        idvd_poly_feat[4570] = pow(input_x[0], 1) * pow(input_x[1], 2) * pow(input_x[3], 2) * pow(input_x[5], 1) * pow(input_x[6], 2);
        idvd_poly_feat[4571] = pow(input_x[0], 1) * pow(input_x[1], 2) * pow(input_x[3], 2) * pow(input_x[6], 3);
        idvd_poly_feat[4572] = pow(input_x[0], 1) * pow(input_x[1], 2) * pow(input_x[3], 1) * pow(input_x[4], 4);
        idvd_poly_feat[4573] = pow(input_x[0], 1) * pow(input_x[1], 2) * pow(input_x[3], 1) * pow(input_x[4], 3) * pow(input_x[5], 1);
        idvd_poly_feat[4574] = pow(input_x[0], 1) * pow(input_x[1], 2) * pow(input_x[3], 1) * pow(input_x[4], 3) * pow(input_x[6], 1);
        idvd_poly_feat[4575] = pow(input_x[0], 1) * pow(input_x[1], 2) * pow(input_x[3], 1) * pow(input_x[4], 2) * pow(input_x[5], 2);
        idvd_poly_feat[4576] = pow(input_x[0], 1) * pow(input_x[1], 2) * pow(input_x[3], 1) * pow(input_x[4], 2) * pow(input_x[5], 1) * pow(input_x[6], 1);
        idvd_poly_feat[4577] = pow(input_x[0], 1) * pow(input_x[1], 2) * pow(input_x[3], 1) * pow(input_x[4], 2) * pow(input_x[6], 2);
        idvd_poly_feat[4578] = pow(input_x[0], 1) * pow(input_x[1], 2) * pow(input_x[3], 1) * pow(input_x[4], 1) * pow(input_x[5], 3);
        idvd_poly_feat[4579] = pow(input_x[0], 1) * pow(input_x[1], 2) * pow(input_x[3], 1) * pow(input_x[4], 1) * pow(input_x[5], 2) * pow(input_x[6], 1);
        idvd_poly_feat[4580] = pow(input_x[0], 1) * pow(input_x[1], 2) * pow(input_x[3], 1) * pow(input_x[4], 1) * pow(input_x[5], 1) * pow(input_x[6], 2);
        idvd_poly_feat[4581] = pow(input_x[0], 1) * pow(input_x[1], 2) * pow(input_x[3], 1) * pow(input_x[4], 1) * pow(input_x[6], 3);
        idvd_poly_feat[4582] = pow(input_x[0], 1) * pow(input_x[1], 2) * pow(input_x[3], 1) * pow(input_x[5], 4);
        idvd_poly_feat[4583] = pow(input_x[0], 1) * pow(input_x[1], 2) * pow(input_x[3], 1) * pow(input_x[5], 3) * pow(input_x[6], 1);
        idvd_poly_feat[4584] = pow(input_x[0], 1) * pow(input_x[1], 2) * pow(input_x[3], 1) * pow(input_x[5], 2) * pow(input_x[6], 2);
        idvd_poly_feat[4585] = pow(input_x[0], 1) * pow(input_x[1], 2) * pow(input_x[3], 1) * pow(input_x[5], 1) * pow(input_x[6], 3);
        idvd_poly_feat[4586] = pow(input_x[0], 1) * pow(input_x[1], 2) * pow(input_x[3], 1) * pow(input_x[6], 4);
        idvd_poly_feat[4587] = pow(input_x[0], 1) * pow(input_x[1], 2) * pow(input_x[4], 5);
        idvd_poly_feat[4588] = pow(input_x[0], 1) * pow(input_x[1], 2) * pow(input_x[4], 4) * pow(input_x[5], 1);
        idvd_poly_feat[4589] = pow(input_x[0], 1) * pow(input_x[1], 2) * pow(input_x[4], 4) * pow(input_x[6], 1);
        idvd_poly_feat[4590] = pow(input_x[0], 1) * pow(input_x[1], 2) * pow(input_x[4], 3) * pow(input_x[5], 2);
        idvd_poly_feat[4591] = pow(input_x[0], 1) * pow(input_x[1], 2) * pow(input_x[4], 3) * pow(input_x[5], 1) * pow(input_x[6], 1);
        idvd_poly_feat[4592] = pow(input_x[0], 1) * pow(input_x[1], 2) * pow(input_x[4], 3) * pow(input_x[6], 2);
        idvd_poly_feat[4593] = pow(input_x[0], 1) * pow(input_x[1], 2) * pow(input_x[4], 2) * pow(input_x[5], 3);
        idvd_poly_feat[4594] = pow(input_x[0], 1) * pow(input_x[1], 2) * pow(input_x[4], 2) * pow(input_x[5], 2) * pow(input_x[6], 1);
        idvd_poly_feat[4595] = pow(input_x[0], 1) * pow(input_x[1], 2) * pow(input_x[4], 2) * pow(input_x[5], 1) * pow(input_x[6], 2);
        idvd_poly_feat[4596] = pow(input_x[0], 1) * pow(input_x[1], 2) * pow(input_x[4], 2) * pow(input_x[6], 3);
        idvd_poly_feat[4597] = pow(input_x[0], 1) * pow(input_x[1], 2) * pow(input_x[4], 1) * pow(input_x[5], 4);
        idvd_poly_feat[4598] = pow(input_x[0], 1) * pow(input_x[1], 2) * pow(input_x[4], 1) * pow(input_x[5], 3) * pow(input_x[6], 1);
        idvd_poly_feat[4599] = pow(input_x[0], 1) * pow(input_x[1], 2) * pow(input_x[4], 1) * pow(input_x[5], 2) * pow(input_x[6], 2);
        idvd_poly_feat[4600] = pow(input_x[0], 1) * pow(input_x[1], 2) * pow(input_x[4], 1) * pow(input_x[5], 1) * pow(input_x[6], 3);
        idvd_poly_feat[4601] = pow(input_x[0], 1) * pow(input_x[1], 2) * pow(input_x[4], 1) * pow(input_x[6], 4);
        idvd_poly_feat[4602] = pow(input_x[0], 1) * pow(input_x[1], 2) * pow(input_x[5], 5);
        idvd_poly_feat[4603] = pow(input_x[0], 1) * pow(input_x[1], 2) * pow(input_x[5], 4) * pow(input_x[6], 1);
        idvd_poly_feat[4604] = pow(input_x[0], 1) * pow(input_x[1], 2) * pow(input_x[5], 3) * pow(input_x[6], 2);
        idvd_poly_feat[4605] = pow(input_x[0], 1) * pow(input_x[1], 2) * pow(input_x[5], 2) * pow(input_x[6], 3);
        idvd_poly_feat[4606] = pow(input_x[0], 1) * pow(input_x[1], 2) * pow(input_x[5], 1) * pow(input_x[6], 4);
        idvd_poly_feat[4607] = pow(input_x[0], 1) * pow(input_x[1], 2) * pow(input_x[6], 5);
        idvd_poly_feat[4608] = pow(input_x[0], 1) * pow(input_x[1], 1) * pow(input_x[2], 6);
        idvd_poly_feat[4609] = pow(input_x[0], 1) * pow(input_x[1], 1) * pow(input_x[2], 5) * pow(input_x[3], 1);
        idvd_poly_feat[4610] = pow(input_x[0], 1) * pow(input_x[1], 1) * pow(input_x[2], 5) * pow(input_x[4], 1);
        idvd_poly_feat[4611] = pow(input_x[0], 1) * pow(input_x[1], 1) * pow(input_x[2], 5) * pow(input_x[5], 1);
        idvd_poly_feat[4612] = pow(input_x[0], 1) * pow(input_x[1], 1) * pow(input_x[2], 5) * pow(input_x[6], 1);
        idvd_poly_feat[4613] = pow(input_x[0], 1) * pow(input_x[1], 1) * pow(input_x[2], 4) * pow(input_x[3], 2);
        idvd_poly_feat[4614] = pow(input_x[0], 1) * pow(input_x[1], 1) * pow(input_x[2], 4) * pow(input_x[3], 1) * pow(input_x[4], 1);
        idvd_poly_feat[4615] = pow(input_x[0], 1) * pow(input_x[1], 1) * pow(input_x[2], 4) * pow(input_x[3], 1) * pow(input_x[5], 1);
        idvd_poly_feat[4616] = pow(input_x[0], 1) * pow(input_x[1], 1) * pow(input_x[2], 4) * pow(input_x[3], 1) * pow(input_x[6], 1);
        idvd_poly_feat[4617] = pow(input_x[0], 1) * pow(input_x[1], 1) * pow(input_x[2], 4) * pow(input_x[4], 2);
        idvd_poly_feat[4618] = pow(input_x[0], 1) * pow(input_x[1], 1) * pow(input_x[2], 4) * pow(input_x[4], 1) * pow(input_x[5], 1);
        idvd_poly_feat[4619] = pow(input_x[0], 1) * pow(input_x[1], 1) * pow(input_x[2], 4) * pow(input_x[4], 1) * pow(input_x[6], 1);
        idvd_poly_feat[4620] = pow(input_x[0], 1) * pow(input_x[1], 1) * pow(input_x[2], 4) * pow(input_x[5], 2);
        idvd_poly_feat[4621] = pow(input_x[0], 1) * pow(input_x[1], 1) * pow(input_x[2], 4) * pow(input_x[5], 1) * pow(input_x[6], 1);
        idvd_poly_feat[4622] = pow(input_x[0], 1) * pow(input_x[1], 1) * pow(input_x[2], 4) * pow(input_x[6], 2);
        idvd_poly_feat[4623] = pow(input_x[0], 1) * pow(input_x[1], 1) * pow(input_x[2], 3) * pow(input_x[3], 3);
        idvd_poly_feat[4624] = pow(input_x[0], 1) * pow(input_x[1], 1) * pow(input_x[2], 3) * pow(input_x[3], 2) * pow(input_x[4], 1);
        idvd_poly_feat[4625] = pow(input_x[0], 1) * pow(input_x[1], 1) * pow(input_x[2], 3) * pow(input_x[3], 2) * pow(input_x[5], 1);
        idvd_poly_feat[4626] = pow(input_x[0], 1) * pow(input_x[1], 1) * pow(input_x[2], 3) * pow(input_x[3], 2) * pow(input_x[6], 1);
        idvd_poly_feat[4627] = pow(input_x[0], 1) * pow(input_x[1], 1) * pow(input_x[2], 3) * pow(input_x[3], 1) * pow(input_x[4], 2);
        idvd_poly_feat[4628] = pow(input_x[0], 1) * pow(input_x[1], 1) * pow(input_x[2], 3) * pow(input_x[3], 1) * pow(input_x[4], 1) * pow(input_x[5], 1);
        idvd_poly_feat[4629] = pow(input_x[0], 1) * pow(input_x[1], 1) * pow(input_x[2], 3) * pow(input_x[3], 1) * pow(input_x[4], 1) * pow(input_x[6], 1);
        idvd_poly_feat[4630] = pow(input_x[0], 1) * pow(input_x[1], 1) * pow(input_x[2], 3) * pow(input_x[3], 1) * pow(input_x[5], 2);
        idvd_poly_feat[4631] = pow(input_x[0], 1) * pow(input_x[1], 1) * pow(input_x[2], 3) * pow(input_x[3], 1) * pow(input_x[5], 1) * pow(input_x[6], 1);
        idvd_poly_feat[4632] = pow(input_x[0], 1) * pow(input_x[1], 1) * pow(input_x[2], 3) * pow(input_x[3], 1) * pow(input_x[6], 2);
        idvd_poly_feat[4633] = pow(input_x[0], 1) * pow(input_x[1], 1) * pow(input_x[2], 3) * pow(input_x[4], 3);
        idvd_poly_feat[4634] = pow(input_x[0], 1) * pow(input_x[1], 1) * pow(input_x[2], 3) * pow(input_x[4], 2) * pow(input_x[5], 1);
        idvd_poly_feat[4635] = pow(input_x[0], 1) * pow(input_x[1], 1) * pow(input_x[2], 3) * pow(input_x[4], 2) * pow(input_x[6], 1);
        idvd_poly_feat[4636] = pow(input_x[0], 1) * pow(input_x[1], 1) * pow(input_x[2], 3) * pow(input_x[4], 1) * pow(input_x[5], 2);
        idvd_poly_feat[4637] = pow(input_x[0], 1) * pow(input_x[1], 1) * pow(input_x[2], 3) * pow(input_x[4], 1) * pow(input_x[5], 1) * pow(input_x[6], 1);
        idvd_poly_feat[4638] = pow(input_x[0], 1) * pow(input_x[1], 1) * pow(input_x[2], 3) * pow(input_x[4], 1) * pow(input_x[6], 2);
        idvd_poly_feat[4639] = pow(input_x[0], 1) * pow(input_x[1], 1) * pow(input_x[2], 3) * pow(input_x[5], 3);
        idvd_poly_feat[4640] = pow(input_x[0], 1) * pow(input_x[1], 1) * pow(input_x[2], 3) * pow(input_x[5], 2) * pow(input_x[6], 1);
        idvd_poly_feat[4641] = pow(input_x[0], 1) * pow(input_x[1], 1) * pow(input_x[2], 3) * pow(input_x[5], 1) * pow(input_x[6], 2);
        idvd_poly_feat[4642] = pow(input_x[0], 1) * pow(input_x[1], 1) * pow(input_x[2], 3) * pow(input_x[6], 3);
        idvd_poly_feat[4643] = pow(input_x[0], 1) * pow(input_x[1], 1) * pow(input_x[2], 2) * pow(input_x[3], 4);
        idvd_poly_feat[4644] = pow(input_x[0], 1) * pow(input_x[1], 1) * pow(input_x[2], 2) * pow(input_x[3], 3) * pow(input_x[4], 1);
        idvd_poly_feat[4645] = pow(input_x[0], 1) * pow(input_x[1], 1) * pow(input_x[2], 2) * pow(input_x[3], 3) * pow(input_x[5], 1);
        idvd_poly_feat[4646] = pow(input_x[0], 1) * pow(input_x[1], 1) * pow(input_x[2], 2) * pow(input_x[3], 3) * pow(input_x[6], 1);
        idvd_poly_feat[4647] = pow(input_x[0], 1) * pow(input_x[1], 1) * pow(input_x[2], 2) * pow(input_x[3], 2) * pow(input_x[4], 2);
        idvd_poly_feat[4648] = pow(input_x[0], 1) * pow(input_x[1], 1) * pow(input_x[2], 2) * pow(input_x[3], 2) * pow(input_x[4], 1) * pow(input_x[5], 1);
        idvd_poly_feat[4649] = pow(input_x[0], 1) * pow(input_x[1], 1) * pow(input_x[2], 2) * pow(input_x[3], 2) * pow(input_x[4], 1) * pow(input_x[6], 1);
        idvd_poly_feat[4650] = pow(input_x[0], 1) * pow(input_x[1], 1) * pow(input_x[2], 2) * pow(input_x[3], 2) * pow(input_x[5], 2);
        idvd_poly_feat[4651] = pow(input_x[0], 1) * pow(input_x[1], 1) * pow(input_x[2], 2) * pow(input_x[3], 2) * pow(input_x[5], 1) * pow(input_x[6], 1);
        idvd_poly_feat[4652] = pow(input_x[0], 1) * pow(input_x[1], 1) * pow(input_x[2], 2) * pow(input_x[3], 2) * pow(input_x[6], 2);
        idvd_poly_feat[4653] = pow(input_x[0], 1) * pow(input_x[1], 1) * pow(input_x[2], 2) * pow(input_x[3], 1) * pow(input_x[4], 3);
        idvd_poly_feat[4654] = pow(input_x[0], 1) * pow(input_x[1], 1) * pow(input_x[2], 2) * pow(input_x[3], 1) * pow(input_x[4], 2) * pow(input_x[5], 1);
        idvd_poly_feat[4655] = pow(input_x[0], 1) * pow(input_x[1], 1) * pow(input_x[2], 2) * pow(input_x[3], 1) * pow(input_x[4], 2) * pow(input_x[6], 1);
        idvd_poly_feat[4656] = pow(input_x[0], 1) * pow(input_x[1], 1) * pow(input_x[2], 2) * pow(input_x[3], 1) * pow(input_x[4], 1) * pow(input_x[5], 2);
        idvd_poly_feat[4657] = pow(input_x[0], 1) * pow(input_x[1], 1) * pow(input_x[2], 2) * pow(input_x[3], 1) * pow(input_x[4], 1) * pow(input_x[5], 1) * pow(input_x[6], 1);
        idvd_poly_feat[4658] = pow(input_x[0], 1) * pow(input_x[1], 1) * pow(input_x[2], 2) * pow(input_x[3], 1) * pow(input_x[4], 1) * pow(input_x[6], 2);
        idvd_poly_feat[4659] = pow(input_x[0], 1) * pow(input_x[1], 1) * pow(input_x[2], 2) * pow(input_x[3], 1) * pow(input_x[5], 3);
        idvd_poly_feat[4660] = pow(input_x[0], 1) * pow(input_x[1], 1) * pow(input_x[2], 2) * pow(input_x[3], 1) * pow(input_x[5], 2) * pow(input_x[6], 1);
        idvd_poly_feat[4661] = pow(input_x[0], 1) * pow(input_x[1], 1) * pow(input_x[2], 2) * pow(input_x[3], 1) * pow(input_x[5], 1) * pow(input_x[6], 2);
        idvd_poly_feat[4662] = pow(input_x[0], 1) * pow(input_x[1], 1) * pow(input_x[2], 2) * pow(input_x[3], 1) * pow(input_x[6], 3);
        idvd_poly_feat[4663] = pow(input_x[0], 1) * pow(input_x[1], 1) * pow(input_x[2], 2) * pow(input_x[4], 4);
        idvd_poly_feat[4664] = pow(input_x[0], 1) * pow(input_x[1], 1) * pow(input_x[2], 2) * pow(input_x[4], 3) * pow(input_x[5], 1);
        idvd_poly_feat[4665] = pow(input_x[0], 1) * pow(input_x[1], 1) * pow(input_x[2], 2) * pow(input_x[4], 3) * pow(input_x[6], 1);
        idvd_poly_feat[4666] = pow(input_x[0], 1) * pow(input_x[1], 1) * pow(input_x[2], 2) * pow(input_x[4], 2) * pow(input_x[5], 2);
        idvd_poly_feat[4667] = pow(input_x[0], 1) * pow(input_x[1], 1) * pow(input_x[2], 2) * pow(input_x[4], 2) * pow(input_x[5], 1) * pow(input_x[6], 1);
        idvd_poly_feat[4668] = pow(input_x[0], 1) * pow(input_x[1], 1) * pow(input_x[2], 2) * pow(input_x[4], 2) * pow(input_x[6], 2);
        idvd_poly_feat[4669] = pow(input_x[0], 1) * pow(input_x[1], 1) * pow(input_x[2], 2) * pow(input_x[4], 1) * pow(input_x[5], 3);
        idvd_poly_feat[4670] = pow(input_x[0], 1) * pow(input_x[1], 1) * pow(input_x[2], 2) * pow(input_x[4], 1) * pow(input_x[5], 2) * pow(input_x[6], 1);
        idvd_poly_feat[4671] = pow(input_x[0], 1) * pow(input_x[1], 1) * pow(input_x[2], 2) * pow(input_x[4], 1) * pow(input_x[5], 1) * pow(input_x[6], 2);
        idvd_poly_feat[4672] = pow(input_x[0], 1) * pow(input_x[1], 1) * pow(input_x[2], 2) * pow(input_x[4], 1) * pow(input_x[6], 3);
        idvd_poly_feat[4673] = pow(input_x[0], 1) * pow(input_x[1], 1) * pow(input_x[2], 2) * pow(input_x[5], 4);
        idvd_poly_feat[4674] = pow(input_x[0], 1) * pow(input_x[1], 1) * pow(input_x[2], 2) * pow(input_x[5], 3) * pow(input_x[6], 1);
        idvd_poly_feat[4675] = pow(input_x[0], 1) * pow(input_x[1], 1) * pow(input_x[2], 2) * pow(input_x[5], 2) * pow(input_x[6], 2);
        idvd_poly_feat[4676] = pow(input_x[0], 1) * pow(input_x[1], 1) * pow(input_x[2], 2) * pow(input_x[5], 1) * pow(input_x[6], 3);
        idvd_poly_feat[4677] = pow(input_x[0], 1) * pow(input_x[1], 1) * pow(input_x[2], 2) * pow(input_x[6], 4);
        idvd_poly_feat[4678] = pow(input_x[0], 1) * pow(input_x[1], 1) * pow(input_x[2], 1) * pow(input_x[3], 5);
        idvd_poly_feat[4679] = pow(input_x[0], 1) * pow(input_x[1], 1) * pow(input_x[2], 1) * pow(input_x[3], 4) * pow(input_x[4], 1);
        idvd_poly_feat[4680] = pow(input_x[0], 1) * pow(input_x[1], 1) * pow(input_x[2], 1) * pow(input_x[3], 4) * pow(input_x[5], 1);
        idvd_poly_feat[4681] = pow(input_x[0], 1) * pow(input_x[1], 1) * pow(input_x[2], 1) * pow(input_x[3], 4) * pow(input_x[6], 1);
        idvd_poly_feat[4682] = pow(input_x[0], 1) * pow(input_x[1], 1) * pow(input_x[2], 1) * pow(input_x[3], 3) * pow(input_x[4], 2);
        idvd_poly_feat[4683] = pow(input_x[0], 1) * pow(input_x[1], 1) * pow(input_x[2], 1) * pow(input_x[3], 3) * pow(input_x[4], 1) * pow(input_x[5], 1);
        idvd_poly_feat[4684] = pow(input_x[0], 1) * pow(input_x[1], 1) * pow(input_x[2], 1) * pow(input_x[3], 3) * pow(input_x[4], 1) * pow(input_x[6], 1);
        idvd_poly_feat[4685] = pow(input_x[0], 1) * pow(input_x[1], 1) * pow(input_x[2], 1) * pow(input_x[3], 3) * pow(input_x[5], 2);
        idvd_poly_feat[4686] = pow(input_x[0], 1) * pow(input_x[1], 1) * pow(input_x[2], 1) * pow(input_x[3], 3) * pow(input_x[5], 1) * pow(input_x[6], 1);
        idvd_poly_feat[4687] = pow(input_x[0], 1) * pow(input_x[1], 1) * pow(input_x[2], 1) * pow(input_x[3], 3) * pow(input_x[6], 2);
        idvd_poly_feat[4688] = pow(input_x[0], 1) * pow(input_x[1], 1) * pow(input_x[2], 1) * pow(input_x[3], 2) * pow(input_x[4], 3);
        idvd_poly_feat[4689] = pow(input_x[0], 1) * pow(input_x[1], 1) * pow(input_x[2], 1) * pow(input_x[3], 2) * pow(input_x[4], 2) * pow(input_x[5], 1);
        idvd_poly_feat[4690] = pow(input_x[0], 1) * pow(input_x[1], 1) * pow(input_x[2], 1) * pow(input_x[3], 2) * pow(input_x[4], 2) * pow(input_x[6], 1);
        idvd_poly_feat[4691] = pow(input_x[0], 1) * pow(input_x[1], 1) * pow(input_x[2], 1) * pow(input_x[3], 2) * pow(input_x[4], 1) * pow(input_x[5], 2);
        idvd_poly_feat[4692] = pow(input_x[0], 1) * pow(input_x[1], 1) * pow(input_x[2], 1) * pow(input_x[3], 2) * pow(input_x[4], 1) * pow(input_x[5], 1) * pow(input_x[6], 1);
        idvd_poly_feat[4693] = pow(input_x[0], 1) * pow(input_x[1], 1) * pow(input_x[2], 1) * pow(input_x[3], 2) * pow(input_x[4], 1) * pow(input_x[6], 2);
        idvd_poly_feat[4694] = pow(input_x[0], 1) * pow(input_x[1], 1) * pow(input_x[2], 1) * pow(input_x[3], 2) * pow(input_x[5], 3);
        idvd_poly_feat[4695] = pow(input_x[0], 1) * pow(input_x[1], 1) * pow(input_x[2], 1) * pow(input_x[3], 2) * pow(input_x[5], 2) * pow(input_x[6], 1);
        idvd_poly_feat[4696] = pow(input_x[0], 1) * pow(input_x[1], 1) * pow(input_x[2], 1) * pow(input_x[3], 2) * pow(input_x[5], 1) * pow(input_x[6], 2);
        idvd_poly_feat[4697] = pow(input_x[0], 1) * pow(input_x[1], 1) * pow(input_x[2], 1) * pow(input_x[3], 2) * pow(input_x[6], 3);
        idvd_poly_feat[4698] = pow(input_x[0], 1) * pow(input_x[1], 1) * pow(input_x[2], 1) * pow(input_x[3], 1) * pow(input_x[4], 4);
        idvd_poly_feat[4699] = pow(input_x[0], 1) * pow(input_x[1], 1) * pow(input_x[2], 1) * pow(input_x[3], 1) * pow(input_x[4], 3) * pow(input_x[5], 1);
        idvd_poly_feat[4700] = pow(input_x[0], 1) * pow(input_x[1], 1) * pow(input_x[2], 1) * pow(input_x[3], 1) * pow(input_x[4], 3) * pow(input_x[6], 1);
        idvd_poly_feat[4701] = pow(input_x[0], 1) * pow(input_x[1], 1) * pow(input_x[2], 1) * pow(input_x[3], 1) * pow(input_x[4], 2) * pow(input_x[5], 2);
        idvd_poly_feat[4702] = pow(input_x[0], 1) * pow(input_x[1], 1) * pow(input_x[2], 1) * pow(input_x[3], 1) * pow(input_x[4], 2) * pow(input_x[5], 1) * pow(input_x[6], 1);
        idvd_poly_feat[4703] = pow(input_x[0], 1) * pow(input_x[1], 1) * pow(input_x[2], 1) * pow(input_x[3], 1) * pow(input_x[4], 2) * pow(input_x[6], 2);
        idvd_poly_feat[4704] = pow(input_x[0], 1) * pow(input_x[1], 1) * pow(input_x[2], 1) * pow(input_x[3], 1) * pow(input_x[4], 1) * pow(input_x[5], 3);
        idvd_poly_feat[4705] = pow(input_x[0], 1) * pow(input_x[1], 1) * pow(input_x[2], 1) * pow(input_x[3], 1) * pow(input_x[4], 1) * pow(input_x[5], 2) * pow(input_x[6], 1);
        idvd_poly_feat[4706] = pow(input_x[0], 1) * pow(input_x[1], 1) * pow(input_x[2], 1) * pow(input_x[3], 1) * pow(input_x[4], 1) * pow(input_x[5], 1) * pow(input_x[6], 2);
        idvd_poly_feat[4707] = pow(input_x[0], 1) * pow(input_x[1], 1) * pow(input_x[2], 1) * pow(input_x[3], 1) * pow(input_x[4], 1) * pow(input_x[6], 3);
        idvd_poly_feat[4708] = pow(input_x[0], 1) * pow(input_x[1], 1) * pow(input_x[2], 1) * pow(input_x[3], 1) * pow(input_x[5], 4);
        idvd_poly_feat[4709] = pow(input_x[0], 1) * pow(input_x[1], 1) * pow(input_x[2], 1) * pow(input_x[3], 1) * pow(input_x[5], 3) * pow(input_x[6], 1);
        idvd_poly_feat[4710] = pow(input_x[0], 1) * pow(input_x[1], 1) * pow(input_x[2], 1) * pow(input_x[3], 1) * pow(input_x[5], 2) * pow(input_x[6], 2);
        idvd_poly_feat[4711] = pow(input_x[0], 1) * pow(input_x[1], 1) * pow(input_x[2], 1) * pow(input_x[3], 1) * pow(input_x[5], 1) * pow(input_x[6], 3);
        idvd_poly_feat[4712] = pow(input_x[0], 1) * pow(input_x[1], 1) * pow(input_x[2], 1) * pow(input_x[3], 1) * pow(input_x[6], 4);
        idvd_poly_feat[4713] = pow(input_x[0], 1) * pow(input_x[1], 1) * pow(input_x[2], 1) * pow(input_x[4], 5);
        idvd_poly_feat[4714] = pow(input_x[0], 1) * pow(input_x[1], 1) * pow(input_x[2], 1) * pow(input_x[4], 4) * pow(input_x[5], 1);
        idvd_poly_feat[4715] = pow(input_x[0], 1) * pow(input_x[1], 1) * pow(input_x[2], 1) * pow(input_x[4], 4) * pow(input_x[6], 1);
        idvd_poly_feat[4716] = pow(input_x[0], 1) * pow(input_x[1], 1) * pow(input_x[2], 1) * pow(input_x[4], 3) * pow(input_x[5], 2);
        idvd_poly_feat[4717] = pow(input_x[0], 1) * pow(input_x[1], 1) * pow(input_x[2], 1) * pow(input_x[4], 3) * pow(input_x[5], 1) * pow(input_x[6], 1);
        idvd_poly_feat[4718] = pow(input_x[0], 1) * pow(input_x[1], 1) * pow(input_x[2], 1) * pow(input_x[4], 3) * pow(input_x[6], 2);
        idvd_poly_feat[4719] = pow(input_x[0], 1) * pow(input_x[1], 1) * pow(input_x[2], 1) * pow(input_x[4], 2) * pow(input_x[5], 3);
        idvd_poly_feat[4720] = pow(input_x[0], 1) * pow(input_x[1], 1) * pow(input_x[2], 1) * pow(input_x[4], 2) * pow(input_x[5], 2) * pow(input_x[6], 1);
        idvd_poly_feat[4721] = pow(input_x[0], 1) * pow(input_x[1], 1) * pow(input_x[2], 1) * pow(input_x[4], 2) * pow(input_x[5], 1) * pow(input_x[6], 2);
        idvd_poly_feat[4722] = pow(input_x[0], 1) * pow(input_x[1], 1) * pow(input_x[2], 1) * pow(input_x[4], 2) * pow(input_x[6], 3);
        idvd_poly_feat[4723] = pow(input_x[0], 1) * pow(input_x[1], 1) * pow(input_x[2], 1) * pow(input_x[4], 1) * pow(input_x[5], 4);
        idvd_poly_feat[4724] = pow(input_x[0], 1) * pow(input_x[1], 1) * pow(input_x[2], 1) * pow(input_x[4], 1) * pow(input_x[5], 3) * pow(input_x[6], 1);
        idvd_poly_feat[4725] = pow(input_x[0], 1) * pow(input_x[1], 1) * pow(input_x[2], 1) * pow(input_x[4], 1) * pow(input_x[5], 2) * pow(input_x[6], 2);
        idvd_poly_feat[4726] = pow(input_x[0], 1) * pow(input_x[1], 1) * pow(input_x[2], 1) * pow(input_x[4], 1) * pow(input_x[5], 1) * pow(input_x[6], 3);
        idvd_poly_feat[4727] = pow(input_x[0], 1) * pow(input_x[1], 1) * pow(input_x[2], 1) * pow(input_x[4], 1) * pow(input_x[6], 4);
        idvd_poly_feat[4728] = pow(input_x[0], 1) * pow(input_x[1], 1) * pow(input_x[2], 1) * pow(input_x[5], 5);
        idvd_poly_feat[4729] = pow(input_x[0], 1) * pow(input_x[1], 1) * pow(input_x[2], 1) * pow(input_x[5], 4) * pow(input_x[6], 1);
        idvd_poly_feat[4730] = pow(input_x[0], 1) * pow(input_x[1], 1) * pow(input_x[2], 1) * pow(input_x[5], 3) * pow(input_x[6], 2);
        idvd_poly_feat[4731] = pow(input_x[0], 1) * pow(input_x[1], 1) * pow(input_x[2], 1) * pow(input_x[5], 2) * pow(input_x[6], 3);
        idvd_poly_feat[4732] = pow(input_x[0], 1) * pow(input_x[1], 1) * pow(input_x[2], 1) * pow(input_x[5], 1) * pow(input_x[6], 4);
        idvd_poly_feat[4733] = pow(input_x[0], 1) * pow(input_x[1], 1) * pow(input_x[2], 1) * pow(input_x[6], 5);
        idvd_poly_feat[4734] = pow(input_x[0], 1) * pow(input_x[1], 1) * pow(input_x[3], 6);
        idvd_poly_feat[4735] = pow(input_x[0], 1) * pow(input_x[1], 1) * pow(input_x[3], 5) * pow(input_x[4], 1);
        idvd_poly_feat[4736] = pow(input_x[0], 1) * pow(input_x[1], 1) * pow(input_x[3], 5) * pow(input_x[5], 1);
        idvd_poly_feat[4737] = pow(input_x[0], 1) * pow(input_x[1], 1) * pow(input_x[3], 5) * pow(input_x[6], 1);
        idvd_poly_feat[4738] = pow(input_x[0], 1) * pow(input_x[1], 1) * pow(input_x[3], 4) * pow(input_x[4], 2);
        idvd_poly_feat[4739] = pow(input_x[0], 1) * pow(input_x[1], 1) * pow(input_x[3], 4) * pow(input_x[4], 1) * pow(input_x[5], 1);
        idvd_poly_feat[4740] = pow(input_x[0], 1) * pow(input_x[1], 1) * pow(input_x[3], 4) * pow(input_x[4], 1) * pow(input_x[6], 1);
        idvd_poly_feat[4741] = pow(input_x[0], 1) * pow(input_x[1], 1) * pow(input_x[3], 4) * pow(input_x[5], 2);
        idvd_poly_feat[4742] = pow(input_x[0], 1) * pow(input_x[1], 1) * pow(input_x[3], 4) * pow(input_x[5], 1) * pow(input_x[6], 1);
        idvd_poly_feat[4743] = pow(input_x[0], 1) * pow(input_x[1], 1) * pow(input_x[3], 4) * pow(input_x[6], 2);
        idvd_poly_feat[4744] = pow(input_x[0], 1) * pow(input_x[1], 1) * pow(input_x[3], 3) * pow(input_x[4], 3);
        idvd_poly_feat[4745] = pow(input_x[0], 1) * pow(input_x[1], 1) * pow(input_x[3], 3) * pow(input_x[4], 2) * pow(input_x[5], 1);
        idvd_poly_feat[4746] = pow(input_x[0], 1) * pow(input_x[1], 1) * pow(input_x[3], 3) * pow(input_x[4], 2) * pow(input_x[6], 1);
        idvd_poly_feat[4747] = pow(input_x[0], 1) * pow(input_x[1], 1) * pow(input_x[3], 3) * pow(input_x[4], 1) * pow(input_x[5], 2);
        idvd_poly_feat[4748] = pow(input_x[0], 1) * pow(input_x[1], 1) * pow(input_x[3], 3) * pow(input_x[4], 1) * pow(input_x[5], 1) * pow(input_x[6], 1);
        idvd_poly_feat[4749] = pow(input_x[0], 1) * pow(input_x[1], 1) * pow(input_x[3], 3) * pow(input_x[4], 1) * pow(input_x[6], 2);
        idvd_poly_feat[4750] = pow(input_x[0], 1) * pow(input_x[1], 1) * pow(input_x[3], 3) * pow(input_x[5], 3);
        idvd_poly_feat[4751] = pow(input_x[0], 1) * pow(input_x[1], 1) * pow(input_x[3], 3) * pow(input_x[5], 2) * pow(input_x[6], 1);
        idvd_poly_feat[4752] = pow(input_x[0], 1) * pow(input_x[1], 1) * pow(input_x[3], 3) * pow(input_x[5], 1) * pow(input_x[6], 2);
        idvd_poly_feat[4753] = pow(input_x[0], 1) * pow(input_x[1], 1) * pow(input_x[3], 3) * pow(input_x[6], 3);
        idvd_poly_feat[4754] = pow(input_x[0], 1) * pow(input_x[1], 1) * pow(input_x[3], 2) * pow(input_x[4], 4);
        idvd_poly_feat[4755] = pow(input_x[0], 1) * pow(input_x[1], 1) * pow(input_x[3], 2) * pow(input_x[4], 3) * pow(input_x[5], 1);
        idvd_poly_feat[4756] = pow(input_x[0], 1) * pow(input_x[1], 1) * pow(input_x[3], 2) * pow(input_x[4], 3) * pow(input_x[6], 1);
        idvd_poly_feat[4757] = pow(input_x[0], 1) * pow(input_x[1], 1) * pow(input_x[3], 2) * pow(input_x[4], 2) * pow(input_x[5], 2);
        idvd_poly_feat[4758] = pow(input_x[0], 1) * pow(input_x[1], 1) * pow(input_x[3], 2) * pow(input_x[4], 2) * pow(input_x[5], 1) * pow(input_x[6], 1);
        idvd_poly_feat[4759] = pow(input_x[0], 1) * pow(input_x[1], 1) * pow(input_x[3], 2) * pow(input_x[4], 2) * pow(input_x[6], 2);
        idvd_poly_feat[4760] = pow(input_x[0], 1) * pow(input_x[1], 1) * pow(input_x[3], 2) * pow(input_x[4], 1) * pow(input_x[5], 3);
        idvd_poly_feat[4761] = pow(input_x[0], 1) * pow(input_x[1], 1) * pow(input_x[3], 2) * pow(input_x[4], 1) * pow(input_x[5], 2) * pow(input_x[6], 1);
        idvd_poly_feat[4762] = pow(input_x[0], 1) * pow(input_x[1], 1) * pow(input_x[3], 2) * pow(input_x[4], 1) * pow(input_x[5], 1) * pow(input_x[6], 2);
        idvd_poly_feat[4763] = pow(input_x[0], 1) * pow(input_x[1], 1) * pow(input_x[3], 2) * pow(input_x[4], 1) * pow(input_x[6], 3);
        idvd_poly_feat[4764] = pow(input_x[0], 1) * pow(input_x[1], 1) * pow(input_x[3], 2) * pow(input_x[5], 4);
        idvd_poly_feat[4765] = pow(input_x[0], 1) * pow(input_x[1], 1) * pow(input_x[3], 2) * pow(input_x[5], 3) * pow(input_x[6], 1);
        idvd_poly_feat[4766] = pow(input_x[0], 1) * pow(input_x[1], 1) * pow(input_x[3], 2) * pow(input_x[5], 2) * pow(input_x[6], 2);
        idvd_poly_feat[4767] = pow(input_x[0], 1) * pow(input_x[1], 1) * pow(input_x[3], 2) * pow(input_x[5], 1) * pow(input_x[6], 3);
        idvd_poly_feat[4768] = pow(input_x[0], 1) * pow(input_x[1], 1) * pow(input_x[3], 2) * pow(input_x[6], 4);
        idvd_poly_feat[4769] = pow(input_x[0], 1) * pow(input_x[1], 1) * pow(input_x[3], 1) * pow(input_x[4], 5);
        idvd_poly_feat[4770] = pow(input_x[0], 1) * pow(input_x[1], 1) * pow(input_x[3], 1) * pow(input_x[4], 4) * pow(input_x[5], 1);
        idvd_poly_feat[4771] = pow(input_x[0], 1) * pow(input_x[1], 1) * pow(input_x[3], 1) * pow(input_x[4], 4) * pow(input_x[6], 1);
        idvd_poly_feat[4772] = pow(input_x[0], 1) * pow(input_x[1], 1) * pow(input_x[3], 1) * pow(input_x[4], 3) * pow(input_x[5], 2);
        idvd_poly_feat[4773] = pow(input_x[0], 1) * pow(input_x[1], 1) * pow(input_x[3], 1) * pow(input_x[4], 3) * pow(input_x[5], 1) * pow(input_x[6], 1);
        idvd_poly_feat[4774] = pow(input_x[0], 1) * pow(input_x[1], 1) * pow(input_x[3], 1) * pow(input_x[4], 3) * pow(input_x[6], 2);
        idvd_poly_feat[4775] = pow(input_x[0], 1) * pow(input_x[1], 1) * pow(input_x[3], 1) * pow(input_x[4], 2) * pow(input_x[5], 3);
        idvd_poly_feat[4776] = pow(input_x[0], 1) * pow(input_x[1], 1) * pow(input_x[3], 1) * pow(input_x[4], 2) * pow(input_x[5], 2) * pow(input_x[6], 1);
        idvd_poly_feat[4777] = pow(input_x[0], 1) * pow(input_x[1], 1) * pow(input_x[3], 1) * pow(input_x[4], 2) * pow(input_x[5], 1) * pow(input_x[6], 2);
        idvd_poly_feat[4778] = pow(input_x[0], 1) * pow(input_x[1], 1) * pow(input_x[3], 1) * pow(input_x[4], 2) * pow(input_x[6], 3);
        idvd_poly_feat[4779] = pow(input_x[0], 1) * pow(input_x[1], 1) * pow(input_x[3], 1) * pow(input_x[4], 1) * pow(input_x[5], 4);
        idvd_poly_feat[4780] = pow(input_x[0], 1) * pow(input_x[1], 1) * pow(input_x[3], 1) * pow(input_x[4], 1) * pow(input_x[5], 3) * pow(input_x[6], 1);
        idvd_poly_feat[4781] = pow(input_x[0], 1) * pow(input_x[1], 1) * pow(input_x[3], 1) * pow(input_x[4], 1) * pow(input_x[5], 2) * pow(input_x[6], 2);
        idvd_poly_feat[4782] = pow(input_x[0], 1) * pow(input_x[1], 1) * pow(input_x[3], 1) * pow(input_x[4], 1) * pow(input_x[5], 1) * pow(input_x[6], 3);
        idvd_poly_feat[4783] = pow(input_x[0], 1) * pow(input_x[1], 1) * pow(input_x[3], 1) * pow(input_x[4], 1) * pow(input_x[6], 4);
        idvd_poly_feat[4784] = pow(input_x[0], 1) * pow(input_x[1], 1) * pow(input_x[3], 1) * pow(input_x[5], 5);
        idvd_poly_feat[4785] = pow(input_x[0], 1) * pow(input_x[1], 1) * pow(input_x[3], 1) * pow(input_x[5], 4) * pow(input_x[6], 1);
        idvd_poly_feat[4786] = pow(input_x[0], 1) * pow(input_x[1], 1) * pow(input_x[3], 1) * pow(input_x[5], 3) * pow(input_x[6], 2);
        idvd_poly_feat[4787] = pow(input_x[0], 1) * pow(input_x[1], 1) * pow(input_x[3], 1) * pow(input_x[5], 2) * pow(input_x[6], 3);
        idvd_poly_feat[4788] = pow(input_x[0], 1) * pow(input_x[1], 1) * pow(input_x[3], 1) * pow(input_x[5], 1) * pow(input_x[6], 4);
        idvd_poly_feat[4789] = pow(input_x[0], 1) * pow(input_x[1], 1) * pow(input_x[3], 1) * pow(input_x[6], 5);
        idvd_poly_feat[4790] = pow(input_x[0], 1) * pow(input_x[1], 1) * pow(input_x[4], 6);
        idvd_poly_feat[4791] = pow(input_x[0], 1) * pow(input_x[1], 1) * pow(input_x[4], 5) * pow(input_x[5], 1);
        idvd_poly_feat[4792] = pow(input_x[0], 1) * pow(input_x[1], 1) * pow(input_x[4], 5) * pow(input_x[6], 1);
        idvd_poly_feat[4793] = pow(input_x[0], 1) * pow(input_x[1], 1) * pow(input_x[4], 4) * pow(input_x[5], 2);
        idvd_poly_feat[4794] = pow(input_x[0], 1) * pow(input_x[1], 1) * pow(input_x[4], 4) * pow(input_x[5], 1) * pow(input_x[6], 1);
        idvd_poly_feat[4795] = pow(input_x[0], 1) * pow(input_x[1], 1) * pow(input_x[4], 4) * pow(input_x[6], 2);
        idvd_poly_feat[4796] = pow(input_x[0], 1) * pow(input_x[1], 1) * pow(input_x[4], 3) * pow(input_x[5], 3);
        idvd_poly_feat[4797] = pow(input_x[0], 1) * pow(input_x[1], 1) * pow(input_x[4], 3) * pow(input_x[5], 2) * pow(input_x[6], 1);
        idvd_poly_feat[4798] = pow(input_x[0], 1) * pow(input_x[1], 1) * pow(input_x[4], 3) * pow(input_x[5], 1) * pow(input_x[6], 2);
        idvd_poly_feat[4799] = pow(input_x[0], 1) * pow(input_x[1], 1) * pow(input_x[4], 3) * pow(input_x[6], 3);
        idvd_poly_feat[4800] = pow(input_x[0], 1) * pow(input_x[1], 1) * pow(input_x[4], 2) * pow(input_x[5], 4);
        idvd_poly_feat[4801] = pow(input_x[0], 1) * pow(input_x[1], 1) * pow(input_x[4], 2) * pow(input_x[5], 3) * pow(input_x[6], 1);
        idvd_poly_feat[4802] = pow(input_x[0], 1) * pow(input_x[1], 1) * pow(input_x[4], 2) * pow(input_x[5], 2) * pow(input_x[6], 2);
        idvd_poly_feat[4803] = pow(input_x[0], 1) * pow(input_x[1], 1) * pow(input_x[4], 2) * pow(input_x[5], 1) * pow(input_x[6], 3);
        idvd_poly_feat[4804] = pow(input_x[0], 1) * pow(input_x[1], 1) * pow(input_x[4], 2) * pow(input_x[6], 4);
        idvd_poly_feat[4805] = pow(input_x[0], 1) * pow(input_x[1], 1) * pow(input_x[4], 1) * pow(input_x[5], 5);
        idvd_poly_feat[4806] = pow(input_x[0], 1) * pow(input_x[1], 1) * pow(input_x[4], 1) * pow(input_x[5], 4) * pow(input_x[6], 1);
        idvd_poly_feat[4807] = pow(input_x[0], 1) * pow(input_x[1], 1) * pow(input_x[4], 1) * pow(input_x[5], 3) * pow(input_x[6], 2);
        idvd_poly_feat[4808] = pow(input_x[0], 1) * pow(input_x[1], 1) * pow(input_x[4], 1) * pow(input_x[5], 2) * pow(input_x[6], 3);
        idvd_poly_feat[4809] = pow(input_x[0], 1) * pow(input_x[1], 1) * pow(input_x[4], 1) * pow(input_x[5], 1) * pow(input_x[6], 4);
        idvd_poly_feat[4810] = pow(input_x[0], 1) * pow(input_x[1], 1) * pow(input_x[4], 1) * pow(input_x[6], 5);
        idvd_poly_feat[4811] = pow(input_x[0], 1) * pow(input_x[1], 1) * pow(input_x[5], 6);
        idvd_poly_feat[4812] = pow(input_x[0], 1) * pow(input_x[1], 1) * pow(input_x[5], 5) * pow(input_x[6], 1);
        idvd_poly_feat[4813] = pow(input_x[0], 1) * pow(input_x[1], 1) * pow(input_x[5], 4) * pow(input_x[6], 2);
        idvd_poly_feat[4814] = pow(input_x[0], 1) * pow(input_x[1], 1) * pow(input_x[5], 3) * pow(input_x[6], 3);
        idvd_poly_feat[4815] = pow(input_x[0], 1) * pow(input_x[1], 1) * pow(input_x[5], 2) * pow(input_x[6], 4);
        idvd_poly_feat[4816] = pow(input_x[0], 1) * pow(input_x[1], 1) * pow(input_x[5], 1) * pow(input_x[6], 5);
        idvd_poly_feat[4817] = pow(input_x[0], 1) * pow(input_x[1], 1) * pow(input_x[6], 6);
        idvd_poly_feat[4818] = pow(input_x[0], 1) * pow(input_x[2], 7);
        idvd_poly_feat[4819] = pow(input_x[0], 1) * pow(input_x[2], 6) * pow(input_x[3], 1);
        idvd_poly_feat[4820] = pow(input_x[0], 1) * pow(input_x[2], 6) * pow(input_x[4], 1);
        idvd_poly_feat[4821] = pow(input_x[0], 1) * pow(input_x[2], 6) * pow(input_x[5], 1);
        idvd_poly_feat[4822] = pow(input_x[0], 1) * pow(input_x[2], 6) * pow(input_x[6], 1);
        idvd_poly_feat[4823] = pow(input_x[0], 1) * pow(input_x[2], 5) * pow(input_x[3], 2);
        idvd_poly_feat[4824] = pow(input_x[0], 1) * pow(input_x[2], 5) * pow(input_x[3], 1) * pow(input_x[4], 1);
        idvd_poly_feat[4825] = pow(input_x[0], 1) * pow(input_x[2], 5) * pow(input_x[3], 1) * pow(input_x[5], 1);
        idvd_poly_feat[4826] = pow(input_x[0], 1) * pow(input_x[2], 5) * pow(input_x[3], 1) * pow(input_x[6], 1);
        idvd_poly_feat[4827] = pow(input_x[0], 1) * pow(input_x[2], 5) * pow(input_x[4], 2);
        idvd_poly_feat[4828] = pow(input_x[0], 1) * pow(input_x[2], 5) * pow(input_x[4], 1) * pow(input_x[5], 1);
        idvd_poly_feat[4829] = pow(input_x[0], 1) * pow(input_x[2], 5) * pow(input_x[4], 1) * pow(input_x[6], 1);
        idvd_poly_feat[4830] = pow(input_x[0], 1) * pow(input_x[2], 5) * pow(input_x[5], 2);
        idvd_poly_feat[4831] = pow(input_x[0], 1) * pow(input_x[2], 5) * pow(input_x[5], 1) * pow(input_x[6], 1);
        idvd_poly_feat[4832] = pow(input_x[0], 1) * pow(input_x[2], 5) * pow(input_x[6], 2);
        idvd_poly_feat[4833] = pow(input_x[0], 1) * pow(input_x[2], 4) * pow(input_x[3], 3);
        idvd_poly_feat[4834] = pow(input_x[0], 1) * pow(input_x[2], 4) * pow(input_x[3], 2) * pow(input_x[4], 1);
        idvd_poly_feat[4835] = pow(input_x[0], 1) * pow(input_x[2], 4) * pow(input_x[3], 2) * pow(input_x[5], 1);
        idvd_poly_feat[4836] = pow(input_x[0], 1) * pow(input_x[2], 4) * pow(input_x[3], 2) * pow(input_x[6], 1);
        idvd_poly_feat[4837] = pow(input_x[0], 1) * pow(input_x[2], 4) * pow(input_x[3], 1) * pow(input_x[4], 2);
        idvd_poly_feat[4838] = pow(input_x[0], 1) * pow(input_x[2], 4) * pow(input_x[3], 1) * pow(input_x[4], 1) * pow(input_x[5], 1);
        idvd_poly_feat[4839] = pow(input_x[0], 1) * pow(input_x[2], 4) * pow(input_x[3], 1) * pow(input_x[4], 1) * pow(input_x[6], 1);
        idvd_poly_feat[4840] = pow(input_x[0], 1) * pow(input_x[2], 4) * pow(input_x[3], 1) * pow(input_x[5], 2);
        idvd_poly_feat[4841] = pow(input_x[0], 1) * pow(input_x[2], 4) * pow(input_x[3], 1) * pow(input_x[5], 1) * pow(input_x[6], 1);
        idvd_poly_feat[4842] = pow(input_x[0], 1) * pow(input_x[2], 4) * pow(input_x[3], 1) * pow(input_x[6], 2);
        idvd_poly_feat[4843] = pow(input_x[0], 1) * pow(input_x[2], 4) * pow(input_x[4], 3);
        idvd_poly_feat[4844] = pow(input_x[0], 1) * pow(input_x[2], 4) * pow(input_x[4], 2) * pow(input_x[5], 1);
        idvd_poly_feat[4845] = pow(input_x[0], 1) * pow(input_x[2], 4) * pow(input_x[4], 2) * pow(input_x[6], 1);
        idvd_poly_feat[4846] = pow(input_x[0], 1) * pow(input_x[2], 4) * pow(input_x[4], 1) * pow(input_x[5], 2);
        idvd_poly_feat[4847] = pow(input_x[0], 1) * pow(input_x[2], 4) * pow(input_x[4], 1) * pow(input_x[5], 1) * pow(input_x[6], 1);
        idvd_poly_feat[4848] = pow(input_x[0], 1) * pow(input_x[2], 4) * pow(input_x[4], 1) * pow(input_x[6], 2);
        idvd_poly_feat[4849] = pow(input_x[0], 1) * pow(input_x[2], 4) * pow(input_x[5], 3);
        idvd_poly_feat[4850] = pow(input_x[0], 1) * pow(input_x[2], 4) * pow(input_x[5], 2) * pow(input_x[6], 1);
        idvd_poly_feat[4851] = pow(input_x[0], 1) * pow(input_x[2], 4) * pow(input_x[5], 1) * pow(input_x[6], 2);
        idvd_poly_feat[4852] = pow(input_x[0], 1) * pow(input_x[2], 4) * pow(input_x[6], 3);
        idvd_poly_feat[4853] = pow(input_x[0], 1) * pow(input_x[2], 3) * pow(input_x[3], 4);
        idvd_poly_feat[4854] = pow(input_x[0], 1) * pow(input_x[2], 3) * pow(input_x[3], 3) * pow(input_x[4], 1);
        idvd_poly_feat[4855] = pow(input_x[0], 1) * pow(input_x[2], 3) * pow(input_x[3], 3) * pow(input_x[5], 1);
        idvd_poly_feat[4856] = pow(input_x[0], 1) * pow(input_x[2], 3) * pow(input_x[3], 3) * pow(input_x[6], 1);
        idvd_poly_feat[4857] = pow(input_x[0], 1) * pow(input_x[2], 3) * pow(input_x[3], 2) * pow(input_x[4], 2);
        idvd_poly_feat[4858] = pow(input_x[0], 1) * pow(input_x[2], 3) * pow(input_x[3], 2) * pow(input_x[4], 1) * pow(input_x[5], 1);
        idvd_poly_feat[4859] = pow(input_x[0], 1) * pow(input_x[2], 3) * pow(input_x[3], 2) * pow(input_x[4], 1) * pow(input_x[6], 1);
        idvd_poly_feat[4860] = pow(input_x[0], 1) * pow(input_x[2], 3) * pow(input_x[3], 2) * pow(input_x[5], 2);
        idvd_poly_feat[4861] = pow(input_x[0], 1) * pow(input_x[2], 3) * pow(input_x[3], 2) * pow(input_x[5], 1) * pow(input_x[6], 1);
        idvd_poly_feat[4862] = pow(input_x[0], 1) * pow(input_x[2], 3) * pow(input_x[3], 2) * pow(input_x[6], 2);
        idvd_poly_feat[4863] = pow(input_x[0], 1) * pow(input_x[2], 3) * pow(input_x[3], 1) * pow(input_x[4], 3);
        idvd_poly_feat[4864] = pow(input_x[0], 1) * pow(input_x[2], 3) * pow(input_x[3], 1) * pow(input_x[4], 2) * pow(input_x[5], 1);
        idvd_poly_feat[4865] = pow(input_x[0], 1) * pow(input_x[2], 3) * pow(input_x[3], 1) * pow(input_x[4], 2) * pow(input_x[6], 1);
        idvd_poly_feat[4866] = pow(input_x[0], 1) * pow(input_x[2], 3) * pow(input_x[3], 1) * pow(input_x[4], 1) * pow(input_x[5], 2);
        idvd_poly_feat[4867] = pow(input_x[0], 1) * pow(input_x[2], 3) * pow(input_x[3], 1) * pow(input_x[4], 1) * pow(input_x[5], 1) * pow(input_x[6], 1);
        idvd_poly_feat[4868] = pow(input_x[0], 1) * pow(input_x[2], 3) * pow(input_x[3], 1) * pow(input_x[4], 1) * pow(input_x[6], 2);
        idvd_poly_feat[4869] = pow(input_x[0], 1) * pow(input_x[2], 3) * pow(input_x[3], 1) * pow(input_x[5], 3);
        idvd_poly_feat[4870] = pow(input_x[0], 1) * pow(input_x[2], 3) * pow(input_x[3], 1) * pow(input_x[5], 2) * pow(input_x[6], 1);
        idvd_poly_feat[4871] = pow(input_x[0], 1) * pow(input_x[2], 3) * pow(input_x[3], 1) * pow(input_x[5], 1) * pow(input_x[6], 2);
        idvd_poly_feat[4872] = pow(input_x[0], 1) * pow(input_x[2], 3) * pow(input_x[3], 1) * pow(input_x[6], 3);
        idvd_poly_feat[4873] = pow(input_x[0], 1) * pow(input_x[2], 3) * pow(input_x[4], 4);
        idvd_poly_feat[4874] = pow(input_x[0], 1) * pow(input_x[2], 3) * pow(input_x[4], 3) * pow(input_x[5], 1);
        idvd_poly_feat[4875] = pow(input_x[0], 1) * pow(input_x[2], 3) * pow(input_x[4], 3) * pow(input_x[6], 1);
        idvd_poly_feat[4876] = pow(input_x[0], 1) * pow(input_x[2], 3) * pow(input_x[4], 2) * pow(input_x[5], 2);
        idvd_poly_feat[4877] = pow(input_x[0], 1) * pow(input_x[2], 3) * pow(input_x[4], 2) * pow(input_x[5], 1) * pow(input_x[6], 1);
        idvd_poly_feat[4878] = pow(input_x[0], 1) * pow(input_x[2], 3) * pow(input_x[4], 2) * pow(input_x[6], 2);
        idvd_poly_feat[4879] = pow(input_x[0], 1) * pow(input_x[2], 3) * pow(input_x[4], 1) * pow(input_x[5], 3);
        idvd_poly_feat[4880] = pow(input_x[0], 1) * pow(input_x[2], 3) * pow(input_x[4], 1) * pow(input_x[5], 2) * pow(input_x[6], 1);
        idvd_poly_feat[4881] = pow(input_x[0], 1) * pow(input_x[2], 3) * pow(input_x[4], 1) * pow(input_x[5], 1) * pow(input_x[6], 2);
        idvd_poly_feat[4882] = pow(input_x[0], 1) * pow(input_x[2], 3) * pow(input_x[4], 1) * pow(input_x[6], 3);
        idvd_poly_feat[4883] = pow(input_x[0], 1) * pow(input_x[2], 3) * pow(input_x[5], 4);
        idvd_poly_feat[4884] = pow(input_x[0], 1) * pow(input_x[2], 3) * pow(input_x[5], 3) * pow(input_x[6], 1);
        idvd_poly_feat[4885] = pow(input_x[0], 1) * pow(input_x[2], 3) * pow(input_x[5], 2) * pow(input_x[6], 2);
        idvd_poly_feat[4886] = pow(input_x[0], 1) * pow(input_x[2], 3) * pow(input_x[5], 1) * pow(input_x[6], 3);
        idvd_poly_feat[4887] = pow(input_x[0], 1) * pow(input_x[2], 3) * pow(input_x[6], 4);
        idvd_poly_feat[4888] = pow(input_x[0], 1) * pow(input_x[2], 2) * pow(input_x[3], 5);
        idvd_poly_feat[4889] = pow(input_x[0], 1) * pow(input_x[2], 2) * pow(input_x[3], 4) * pow(input_x[4], 1);
        idvd_poly_feat[4890] = pow(input_x[0], 1) * pow(input_x[2], 2) * pow(input_x[3], 4) * pow(input_x[5], 1);
        idvd_poly_feat[4891] = pow(input_x[0], 1) * pow(input_x[2], 2) * pow(input_x[3], 4) * pow(input_x[6], 1);
        idvd_poly_feat[4892] = pow(input_x[0], 1) * pow(input_x[2], 2) * pow(input_x[3], 3) * pow(input_x[4], 2);
        idvd_poly_feat[4893] = pow(input_x[0], 1) * pow(input_x[2], 2) * pow(input_x[3], 3) * pow(input_x[4], 1) * pow(input_x[5], 1);
        idvd_poly_feat[4894] = pow(input_x[0], 1) * pow(input_x[2], 2) * pow(input_x[3], 3) * pow(input_x[4], 1) * pow(input_x[6], 1);
        idvd_poly_feat[4895] = pow(input_x[0], 1) * pow(input_x[2], 2) * pow(input_x[3], 3) * pow(input_x[5], 2);
        idvd_poly_feat[4896] = pow(input_x[0], 1) * pow(input_x[2], 2) * pow(input_x[3], 3) * pow(input_x[5], 1) * pow(input_x[6], 1);
        idvd_poly_feat[4897] = pow(input_x[0], 1) * pow(input_x[2], 2) * pow(input_x[3], 3) * pow(input_x[6], 2);
        idvd_poly_feat[4898] = pow(input_x[0], 1) * pow(input_x[2], 2) * pow(input_x[3], 2) * pow(input_x[4], 3);
        idvd_poly_feat[4899] = pow(input_x[0], 1) * pow(input_x[2], 2) * pow(input_x[3], 2) * pow(input_x[4], 2) * pow(input_x[5], 1);
        idvd_poly_feat[4900] = pow(input_x[0], 1) * pow(input_x[2], 2) * pow(input_x[3], 2) * pow(input_x[4], 2) * pow(input_x[6], 1);
        idvd_poly_feat[4901] = pow(input_x[0], 1) * pow(input_x[2], 2) * pow(input_x[3], 2) * pow(input_x[4], 1) * pow(input_x[5], 2);
        idvd_poly_feat[4902] = pow(input_x[0], 1) * pow(input_x[2], 2) * pow(input_x[3], 2) * pow(input_x[4], 1) * pow(input_x[5], 1) * pow(input_x[6], 1);
        idvd_poly_feat[4903] = pow(input_x[0], 1) * pow(input_x[2], 2) * pow(input_x[3], 2) * pow(input_x[4], 1) * pow(input_x[6], 2);
        idvd_poly_feat[4904] = pow(input_x[0], 1) * pow(input_x[2], 2) * pow(input_x[3], 2) * pow(input_x[5], 3);
        idvd_poly_feat[4905] = pow(input_x[0], 1) * pow(input_x[2], 2) * pow(input_x[3], 2) * pow(input_x[5], 2) * pow(input_x[6], 1);
        idvd_poly_feat[4906] = pow(input_x[0], 1) * pow(input_x[2], 2) * pow(input_x[3], 2) * pow(input_x[5], 1) * pow(input_x[6], 2);
        idvd_poly_feat[4907] = pow(input_x[0], 1) * pow(input_x[2], 2) * pow(input_x[3], 2) * pow(input_x[6], 3);
        idvd_poly_feat[4908] = pow(input_x[0], 1) * pow(input_x[2], 2) * pow(input_x[3], 1) * pow(input_x[4], 4);
        idvd_poly_feat[4909] = pow(input_x[0], 1) * pow(input_x[2], 2) * pow(input_x[3], 1) * pow(input_x[4], 3) * pow(input_x[5], 1);
        idvd_poly_feat[4910] = pow(input_x[0], 1) * pow(input_x[2], 2) * pow(input_x[3], 1) * pow(input_x[4], 3) * pow(input_x[6], 1);
        idvd_poly_feat[4911] = pow(input_x[0], 1) * pow(input_x[2], 2) * pow(input_x[3], 1) * pow(input_x[4], 2) * pow(input_x[5], 2);
        idvd_poly_feat[4912] = pow(input_x[0], 1) * pow(input_x[2], 2) * pow(input_x[3], 1) * pow(input_x[4], 2) * pow(input_x[5], 1) * pow(input_x[6], 1);
        idvd_poly_feat[4913] = pow(input_x[0], 1) * pow(input_x[2], 2) * pow(input_x[3], 1) * pow(input_x[4], 2) * pow(input_x[6], 2);
        idvd_poly_feat[4914] = pow(input_x[0], 1) * pow(input_x[2], 2) * pow(input_x[3], 1) * pow(input_x[4], 1) * pow(input_x[5], 3);
        idvd_poly_feat[4915] = pow(input_x[0], 1) * pow(input_x[2], 2) * pow(input_x[3], 1) * pow(input_x[4], 1) * pow(input_x[5], 2) * pow(input_x[6], 1);
        idvd_poly_feat[4916] = pow(input_x[0], 1) * pow(input_x[2], 2) * pow(input_x[3], 1) * pow(input_x[4], 1) * pow(input_x[5], 1) * pow(input_x[6], 2);
        idvd_poly_feat[4917] = pow(input_x[0], 1) * pow(input_x[2], 2) * pow(input_x[3], 1) * pow(input_x[4], 1) * pow(input_x[6], 3);
        idvd_poly_feat[4918] = pow(input_x[0], 1) * pow(input_x[2], 2) * pow(input_x[3], 1) * pow(input_x[5], 4);
        idvd_poly_feat[4919] = pow(input_x[0], 1) * pow(input_x[2], 2) * pow(input_x[3], 1) * pow(input_x[5], 3) * pow(input_x[6], 1);
        idvd_poly_feat[4920] = pow(input_x[0], 1) * pow(input_x[2], 2) * pow(input_x[3], 1) * pow(input_x[5], 2) * pow(input_x[6], 2);
        idvd_poly_feat[4921] = pow(input_x[0], 1) * pow(input_x[2], 2) * pow(input_x[3], 1) * pow(input_x[5], 1) * pow(input_x[6], 3);
        idvd_poly_feat[4922] = pow(input_x[0], 1) * pow(input_x[2], 2) * pow(input_x[3], 1) * pow(input_x[6], 4);
        idvd_poly_feat[4923] = pow(input_x[0], 1) * pow(input_x[2], 2) * pow(input_x[4], 5);
        idvd_poly_feat[4924] = pow(input_x[0], 1) * pow(input_x[2], 2) * pow(input_x[4], 4) * pow(input_x[5], 1);
        idvd_poly_feat[4925] = pow(input_x[0], 1) * pow(input_x[2], 2) * pow(input_x[4], 4) * pow(input_x[6], 1);
        idvd_poly_feat[4926] = pow(input_x[0], 1) * pow(input_x[2], 2) * pow(input_x[4], 3) * pow(input_x[5], 2);
        idvd_poly_feat[4927] = pow(input_x[0], 1) * pow(input_x[2], 2) * pow(input_x[4], 3) * pow(input_x[5], 1) * pow(input_x[6], 1);
        idvd_poly_feat[4928] = pow(input_x[0], 1) * pow(input_x[2], 2) * pow(input_x[4], 3) * pow(input_x[6], 2);
        idvd_poly_feat[4929] = pow(input_x[0], 1) * pow(input_x[2], 2) * pow(input_x[4], 2) * pow(input_x[5], 3);
        idvd_poly_feat[4930] = pow(input_x[0], 1) * pow(input_x[2], 2) * pow(input_x[4], 2) * pow(input_x[5], 2) * pow(input_x[6], 1);
        idvd_poly_feat[4931] = pow(input_x[0], 1) * pow(input_x[2], 2) * pow(input_x[4], 2) * pow(input_x[5], 1) * pow(input_x[6], 2);
        idvd_poly_feat[4932] = pow(input_x[0], 1) * pow(input_x[2], 2) * pow(input_x[4], 2) * pow(input_x[6], 3);
        idvd_poly_feat[4933] = pow(input_x[0], 1) * pow(input_x[2], 2) * pow(input_x[4], 1) * pow(input_x[5], 4);
        idvd_poly_feat[4934] = pow(input_x[0], 1) * pow(input_x[2], 2) * pow(input_x[4], 1) * pow(input_x[5], 3) * pow(input_x[6], 1);
        idvd_poly_feat[4935] = pow(input_x[0], 1) * pow(input_x[2], 2) * pow(input_x[4], 1) * pow(input_x[5], 2) * pow(input_x[6], 2);
        idvd_poly_feat[4936] = pow(input_x[0], 1) * pow(input_x[2], 2) * pow(input_x[4], 1) * pow(input_x[5], 1) * pow(input_x[6], 3);
        idvd_poly_feat[4937] = pow(input_x[0], 1) * pow(input_x[2], 2) * pow(input_x[4], 1) * pow(input_x[6], 4);
        idvd_poly_feat[4938] = pow(input_x[0], 1) * pow(input_x[2], 2) * pow(input_x[5], 5);
        idvd_poly_feat[4939] = pow(input_x[0], 1) * pow(input_x[2], 2) * pow(input_x[5], 4) * pow(input_x[6], 1);
        idvd_poly_feat[4940] = pow(input_x[0], 1) * pow(input_x[2], 2) * pow(input_x[5], 3) * pow(input_x[6], 2);
        idvd_poly_feat[4941] = pow(input_x[0], 1) * pow(input_x[2], 2) * pow(input_x[5], 2) * pow(input_x[6], 3);
        idvd_poly_feat[4942] = pow(input_x[0], 1) * pow(input_x[2], 2) * pow(input_x[5], 1) * pow(input_x[6], 4);
        idvd_poly_feat[4943] = pow(input_x[0], 1) * pow(input_x[2], 2) * pow(input_x[6], 5);
        idvd_poly_feat[4944] = pow(input_x[0], 1) * pow(input_x[2], 1) * pow(input_x[3], 6);
        idvd_poly_feat[4945] = pow(input_x[0], 1) * pow(input_x[2], 1) * pow(input_x[3], 5) * pow(input_x[4], 1);
        idvd_poly_feat[4946] = pow(input_x[0], 1) * pow(input_x[2], 1) * pow(input_x[3], 5) * pow(input_x[5], 1);
        idvd_poly_feat[4947] = pow(input_x[0], 1) * pow(input_x[2], 1) * pow(input_x[3], 5) * pow(input_x[6], 1);
        idvd_poly_feat[4948] = pow(input_x[0], 1) * pow(input_x[2], 1) * pow(input_x[3], 4) * pow(input_x[4], 2);
        idvd_poly_feat[4949] = pow(input_x[0], 1) * pow(input_x[2], 1) * pow(input_x[3], 4) * pow(input_x[4], 1) * pow(input_x[5], 1);
        idvd_poly_feat[4950] = pow(input_x[0], 1) * pow(input_x[2], 1) * pow(input_x[3], 4) * pow(input_x[4], 1) * pow(input_x[6], 1);
        idvd_poly_feat[4951] = pow(input_x[0], 1) * pow(input_x[2], 1) * pow(input_x[3], 4) * pow(input_x[5], 2);
        idvd_poly_feat[4952] = pow(input_x[0], 1) * pow(input_x[2], 1) * pow(input_x[3], 4) * pow(input_x[5], 1) * pow(input_x[6], 1);
        idvd_poly_feat[4953] = pow(input_x[0], 1) * pow(input_x[2], 1) * pow(input_x[3], 4) * pow(input_x[6], 2);
        idvd_poly_feat[4954] = pow(input_x[0], 1) * pow(input_x[2], 1) * pow(input_x[3], 3) * pow(input_x[4], 3);
        idvd_poly_feat[4955] = pow(input_x[0], 1) * pow(input_x[2], 1) * pow(input_x[3], 3) * pow(input_x[4], 2) * pow(input_x[5], 1);
        idvd_poly_feat[4956] = pow(input_x[0], 1) * pow(input_x[2], 1) * pow(input_x[3], 3) * pow(input_x[4], 2) * pow(input_x[6], 1);
        idvd_poly_feat[4957] = pow(input_x[0], 1) * pow(input_x[2], 1) * pow(input_x[3], 3) * pow(input_x[4], 1) * pow(input_x[5], 2);
        idvd_poly_feat[4958] = pow(input_x[0], 1) * pow(input_x[2], 1) * pow(input_x[3], 3) * pow(input_x[4], 1) * pow(input_x[5], 1) * pow(input_x[6], 1);
        idvd_poly_feat[4959] = pow(input_x[0], 1) * pow(input_x[2], 1) * pow(input_x[3], 3) * pow(input_x[4], 1) * pow(input_x[6], 2);
        idvd_poly_feat[4960] = pow(input_x[0], 1) * pow(input_x[2], 1) * pow(input_x[3], 3) * pow(input_x[5], 3);
        idvd_poly_feat[4961] = pow(input_x[0], 1) * pow(input_x[2], 1) * pow(input_x[3], 3) * pow(input_x[5], 2) * pow(input_x[6], 1);
        idvd_poly_feat[4962] = pow(input_x[0], 1) * pow(input_x[2], 1) * pow(input_x[3], 3) * pow(input_x[5], 1) * pow(input_x[6], 2);
        idvd_poly_feat[4963] = pow(input_x[0], 1) * pow(input_x[2], 1) * pow(input_x[3], 3) * pow(input_x[6], 3);
        idvd_poly_feat[4964] = pow(input_x[0], 1) * pow(input_x[2], 1) * pow(input_x[3], 2) * pow(input_x[4], 4);
        idvd_poly_feat[4965] = pow(input_x[0], 1) * pow(input_x[2], 1) * pow(input_x[3], 2) * pow(input_x[4], 3) * pow(input_x[5], 1);
        idvd_poly_feat[4966] = pow(input_x[0], 1) * pow(input_x[2], 1) * pow(input_x[3], 2) * pow(input_x[4], 3) * pow(input_x[6], 1);
        idvd_poly_feat[4967] = pow(input_x[0], 1) * pow(input_x[2], 1) * pow(input_x[3], 2) * pow(input_x[4], 2) * pow(input_x[5], 2);
        idvd_poly_feat[4968] = pow(input_x[0], 1) * pow(input_x[2], 1) * pow(input_x[3], 2) * pow(input_x[4], 2) * pow(input_x[5], 1) * pow(input_x[6], 1);
        idvd_poly_feat[4969] = pow(input_x[0], 1) * pow(input_x[2], 1) * pow(input_x[3], 2) * pow(input_x[4], 2) * pow(input_x[6], 2);
        idvd_poly_feat[4970] = pow(input_x[0], 1) * pow(input_x[2], 1) * pow(input_x[3], 2) * pow(input_x[4], 1) * pow(input_x[5], 3);
        idvd_poly_feat[4971] = pow(input_x[0], 1) * pow(input_x[2], 1) * pow(input_x[3], 2) * pow(input_x[4], 1) * pow(input_x[5], 2) * pow(input_x[6], 1);
        idvd_poly_feat[4972] = pow(input_x[0], 1) * pow(input_x[2], 1) * pow(input_x[3], 2) * pow(input_x[4], 1) * pow(input_x[5], 1) * pow(input_x[6], 2);
        idvd_poly_feat[4973] = pow(input_x[0], 1) * pow(input_x[2], 1) * pow(input_x[3], 2) * pow(input_x[4], 1) * pow(input_x[6], 3);
        idvd_poly_feat[4974] = pow(input_x[0], 1) * pow(input_x[2], 1) * pow(input_x[3], 2) * pow(input_x[5], 4);
        idvd_poly_feat[4975] = pow(input_x[0], 1) * pow(input_x[2], 1) * pow(input_x[3], 2) * pow(input_x[5], 3) * pow(input_x[6], 1);
        idvd_poly_feat[4976] = pow(input_x[0], 1) * pow(input_x[2], 1) * pow(input_x[3], 2) * pow(input_x[5], 2) * pow(input_x[6], 2);
        idvd_poly_feat[4977] = pow(input_x[0], 1) * pow(input_x[2], 1) * pow(input_x[3], 2) * pow(input_x[5], 1) * pow(input_x[6], 3);
        idvd_poly_feat[4978] = pow(input_x[0], 1) * pow(input_x[2], 1) * pow(input_x[3], 2) * pow(input_x[6], 4);
        idvd_poly_feat[4979] = pow(input_x[0], 1) * pow(input_x[2], 1) * pow(input_x[3], 1) * pow(input_x[4], 5);
        idvd_poly_feat[4980] = pow(input_x[0], 1) * pow(input_x[2], 1) * pow(input_x[3], 1) * pow(input_x[4], 4) * pow(input_x[5], 1);
        idvd_poly_feat[4981] = pow(input_x[0], 1) * pow(input_x[2], 1) * pow(input_x[3], 1) * pow(input_x[4], 4) * pow(input_x[6], 1);
        idvd_poly_feat[4982] = pow(input_x[0], 1) * pow(input_x[2], 1) * pow(input_x[3], 1) * pow(input_x[4], 3) * pow(input_x[5], 2);
        idvd_poly_feat[4983] = pow(input_x[0], 1) * pow(input_x[2], 1) * pow(input_x[3], 1) * pow(input_x[4], 3) * pow(input_x[5], 1) * pow(input_x[6], 1);
        idvd_poly_feat[4984] = pow(input_x[0], 1) * pow(input_x[2], 1) * pow(input_x[3], 1) * pow(input_x[4], 3) * pow(input_x[6], 2);
        idvd_poly_feat[4985] = pow(input_x[0], 1) * pow(input_x[2], 1) * pow(input_x[3], 1) * pow(input_x[4], 2) * pow(input_x[5], 3);
        idvd_poly_feat[4986] = pow(input_x[0], 1) * pow(input_x[2], 1) * pow(input_x[3], 1) * pow(input_x[4], 2) * pow(input_x[5], 2) * pow(input_x[6], 1);
        idvd_poly_feat[4987] = pow(input_x[0], 1) * pow(input_x[2], 1) * pow(input_x[3], 1) * pow(input_x[4], 2) * pow(input_x[5], 1) * pow(input_x[6], 2);
        idvd_poly_feat[4988] = pow(input_x[0], 1) * pow(input_x[2], 1) * pow(input_x[3], 1) * pow(input_x[4], 2) * pow(input_x[6], 3);
        idvd_poly_feat[4989] = pow(input_x[0], 1) * pow(input_x[2], 1) * pow(input_x[3], 1) * pow(input_x[4], 1) * pow(input_x[5], 4);
        idvd_poly_feat[4990] = pow(input_x[0], 1) * pow(input_x[2], 1) * pow(input_x[3], 1) * pow(input_x[4], 1) * pow(input_x[5], 3) * pow(input_x[6], 1);
        idvd_poly_feat[4991] = pow(input_x[0], 1) * pow(input_x[2], 1) * pow(input_x[3], 1) * pow(input_x[4], 1) * pow(input_x[5], 2) * pow(input_x[6], 2);
        idvd_poly_feat[4992] = pow(input_x[0], 1) * pow(input_x[2], 1) * pow(input_x[3], 1) * pow(input_x[4], 1) * pow(input_x[5], 1) * pow(input_x[6], 3);
        idvd_poly_feat[4993] = pow(input_x[0], 1) * pow(input_x[2], 1) * pow(input_x[3], 1) * pow(input_x[4], 1) * pow(input_x[6], 4);
        idvd_poly_feat[4994] = pow(input_x[0], 1) * pow(input_x[2], 1) * pow(input_x[3], 1) * pow(input_x[5], 5);
        idvd_poly_feat[4995] = pow(input_x[0], 1) * pow(input_x[2], 1) * pow(input_x[3], 1) * pow(input_x[5], 4) * pow(input_x[6], 1);
        idvd_poly_feat[4996] = pow(input_x[0], 1) * pow(input_x[2], 1) * pow(input_x[3], 1) * pow(input_x[5], 3) * pow(input_x[6], 2);
        idvd_poly_feat[4997] = pow(input_x[0], 1) * pow(input_x[2], 1) * pow(input_x[3], 1) * pow(input_x[5], 2) * pow(input_x[6], 3);
        idvd_poly_feat[4998] = pow(input_x[0], 1) * pow(input_x[2], 1) * pow(input_x[3], 1) * pow(input_x[5], 1) * pow(input_x[6], 4);
        idvd_poly_feat[4999] = pow(input_x[0], 1) * pow(input_x[2], 1) * pow(input_x[3], 1) * pow(input_x[6], 5);
        idvd_poly_feat[5000] = pow(input_x[0], 1) * pow(input_x[2], 1) * pow(input_x[4], 6);
        idvd_poly_feat[5001] = pow(input_x[0], 1) * pow(input_x[2], 1) * pow(input_x[4], 5) * pow(input_x[5], 1);
        idvd_poly_feat[5002] = pow(input_x[0], 1) * pow(input_x[2], 1) * pow(input_x[4], 5) * pow(input_x[6], 1);
        idvd_poly_feat[5003] = pow(input_x[0], 1) * pow(input_x[2], 1) * pow(input_x[4], 4) * pow(input_x[5], 2);
        idvd_poly_feat[5004] = pow(input_x[0], 1) * pow(input_x[2], 1) * pow(input_x[4], 4) * pow(input_x[5], 1) * pow(input_x[6], 1);
        idvd_poly_feat[5005] = pow(input_x[0], 1) * pow(input_x[2], 1) * pow(input_x[4], 4) * pow(input_x[6], 2);
        idvd_poly_feat[5006] = pow(input_x[0], 1) * pow(input_x[2], 1) * pow(input_x[4], 3) * pow(input_x[5], 3);
        idvd_poly_feat[5007] = pow(input_x[0], 1) * pow(input_x[2], 1) * pow(input_x[4], 3) * pow(input_x[5], 2) * pow(input_x[6], 1);
        idvd_poly_feat[5008] = pow(input_x[0], 1) * pow(input_x[2], 1) * pow(input_x[4], 3) * pow(input_x[5], 1) * pow(input_x[6], 2);
        idvd_poly_feat[5009] = pow(input_x[0], 1) * pow(input_x[2], 1) * pow(input_x[4], 3) * pow(input_x[6], 3);
        idvd_poly_feat[5010] = pow(input_x[0], 1) * pow(input_x[2], 1) * pow(input_x[4], 2) * pow(input_x[5], 4);
        idvd_poly_feat[5011] = pow(input_x[0], 1) * pow(input_x[2], 1) * pow(input_x[4], 2) * pow(input_x[5], 3) * pow(input_x[6], 1);
        idvd_poly_feat[5012] = pow(input_x[0], 1) * pow(input_x[2], 1) * pow(input_x[4], 2) * pow(input_x[5], 2) * pow(input_x[6], 2);
        idvd_poly_feat[5013] = pow(input_x[0], 1) * pow(input_x[2], 1) * pow(input_x[4], 2) * pow(input_x[5], 1) * pow(input_x[6], 3);
        idvd_poly_feat[5014] = pow(input_x[0], 1) * pow(input_x[2], 1) * pow(input_x[4], 2) * pow(input_x[6], 4);
        idvd_poly_feat[5015] = pow(input_x[0], 1) * pow(input_x[2], 1) * pow(input_x[4], 1) * pow(input_x[5], 5);
        idvd_poly_feat[5016] = pow(input_x[0], 1) * pow(input_x[2], 1) * pow(input_x[4], 1) * pow(input_x[5], 4) * pow(input_x[6], 1);
        idvd_poly_feat[5017] = pow(input_x[0], 1) * pow(input_x[2], 1) * pow(input_x[4], 1) * pow(input_x[5], 3) * pow(input_x[6], 2);
        idvd_poly_feat[5018] = pow(input_x[0], 1) * pow(input_x[2], 1) * pow(input_x[4], 1) * pow(input_x[5], 2) * pow(input_x[6], 3);
        idvd_poly_feat[5019] = pow(input_x[0], 1) * pow(input_x[2], 1) * pow(input_x[4], 1) * pow(input_x[5], 1) * pow(input_x[6], 4);
        idvd_poly_feat[5020] = pow(input_x[0], 1) * pow(input_x[2], 1) * pow(input_x[4], 1) * pow(input_x[6], 5);
        idvd_poly_feat[5021] = pow(input_x[0], 1) * pow(input_x[2], 1) * pow(input_x[5], 6);
        idvd_poly_feat[5022] = pow(input_x[0], 1) * pow(input_x[2], 1) * pow(input_x[5], 5) * pow(input_x[6], 1);
        idvd_poly_feat[5023] = pow(input_x[0], 1) * pow(input_x[2], 1) * pow(input_x[5], 4) * pow(input_x[6], 2);
        idvd_poly_feat[5024] = pow(input_x[0], 1) * pow(input_x[2], 1) * pow(input_x[5], 3) * pow(input_x[6], 3);
        idvd_poly_feat[5025] = pow(input_x[0], 1) * pow(input_x[2], 1) * pow(input_x[5], 2) * pow(input_x[6], 4);
        idvd_poly_feat[5026] = pow(input_x[0], 1) * pow(input_x[2], 1) * pow(input_x[5], 1) * pow(input_x[6], 5);
        idvd_poly_feat[5027] = pow(input_x[0], 1) * pow(input_x[2], 1) * pow(input_x[6], 6);
        idvd_poly_feat[5028] = pow(input_x[0], 1) * pow(input_x[3], 7);
        idvd_poly_feat[5029] = pow(input_x[0], 1) * pow(input_x[3], 6) * pow(input_x[4], 1);
        idvd_poly_feat[5030] = pow(input_x[0], 1) * pow(input_x[3], 6) * pow(input_x[5], 1);
        idvd_poly_feat[5031] = pow(input_x[0], 1) * pow(input_x[3], 6) * pow(input_x[6], 1);
        idvd_poly_feat[5032] = pow(input_x[0], 1) * pow(input_x[3], 5) * pow(input_x[4], 2);
        idvd_poly_feat[5033] = pow(input_x[0], 1) * pow(input_x[3], 5) * pow(input_x[4], 1) * pow(input_x[5], 1);
        idvd_poly_feat[5034] = pow(input_x[0], 1) * pow(input_x[3], 5) * pow(input_x[4], 1) * pow(input_x[6], 1);
        idvd_poly_feat[5035] = pow(input_x[0], 1) * pow(input_x[3], 5) * pow(input_x[5], 2);
        idvd_poly_feat[5036] = pow(input_x[0], 1) * pow(input_x[3], 5) * pow(input_x[5], 1) * pow(input_x[6], 1);
        idvd_poly_feat[5037] = pow(input_x[0], 1) * pow(input_x[3], 5) * pow(input_x[6], 2);
        idvd_poly_feat[5038] = pow(input_x[0], 1) * pow(input_x[3], 4) * pow(input_x[4], 3);
        idvd_poly_feat[5039] = pow(input_x[0], 1) * pow(input_x[3], 4) * pow(input_x[4], 2) * pow(input_x[5], 1);
        idvd_poly_feat[5040] = pow(input_x[0], 1) * pow(input_x[3], 4) * pow(input_x[4], 2) * pow(input_x[6], 1);
        idvd_poly_feat[5041] = pow(input_x[0], 1) * pow(input_x[3], 4) * pow(input_x[4], 1) * pow(input_x[5], 2);
        idvd_poly_feat[5042] = pow(input_x[0], 1) * pow(input_x[3], 4) * pow(input_x[4], 1) * pow(input_x[5], 1) * pow(input_x[6], 1);
        idvd_poly_feat[5043] = pow(input_x[0], 1) * pow(input_x[3], 4) * pow(input_x[4], 1) * pow(input_x[6], 2);
        idvd_poly_feat[5044] = pow(input_x[0], 1) * pow(input_x[3], 4) * pow(input_x[5], 3);
        idvd_poly_feat[5045] = pow(input_x[0], 1) * pow(input_x[3], 4) * pow(input_x[5], 2) * pow(input_x[6], 1);
        idvd_poly_feat[5046] = pow(input_x[0], 1) * pow(input_x[3], 4) * pow(input_x[5], 1) * pow(input_x[6], 2);
        idvd_poly_feat[5047] = pow(input_x[0], 1) * pow(input_x[3], 4) * pow(input_x[6], 3);
        idvd_poly_feat[5048] = pow(input_x[0], 1) * pow(input_x[3], 3) * pow(input_x[4], 4);
        idvd_poly_feat[5049] = pow(input_x[0], 1) * pow(input_x[3], 3) * pow(input_x[4], 3) * pow(input_x[5], 1);
        idvd_poly_feat[5050] = pow(input_x[0], 1) * pow(input_x[3], 3) * pow(input_x[4], 3) * pow(input_x[6], 1);
        idvd_poly_feat[5051] = pow(input_x[0], 1) * pow(input_x[3], 3) * pow(input_x[4], 2) * pow(input_x[5], 2);
        idvd_poly_feat[5052] = pow(input_x[0], 1) * pow(input_x[3], 3) * pow(input_x[4], 2) * pow(input_x[5], 1) * pow(input_x[6], 1);
        idvd_poly_feat[5053] = pow(input_x[0], 1) * pow(input_x[3], 3) * pow(input_x[4], 2) * pow(input_x[6], 2);
        idvd_poly_feat[5054] = pow(input_x[0], 1) * pow(input_x[3], 3) * pow(input_x[4], 1) * pow(input_x[5], 3);
        idvd_poly_feat[5055] = pow(input_x[0], 1) * pow(input_x[3], 3) * pow(input_x[4], 1) * pow(input_x[5], 2) * pow(input_x[6], 1);
        idvd_poly_feat[5056] = pow(input_x[0], 1) * pow(input_x[3], 3) * pow(input_x[4], 1) * pow(input_x[5], 1) * pow(input_x[6], 2);
        idvd_poly_feat[5057] = pow(input_x[0], 1) * pow(input_x[3], 3) * pow(input_x[4], 1) * pow(input_x[6], 3);
        idvd_poly_feat[5058] = pow(input_x[0], 1) * pow(input_x[3], 3) * pow(input_x[5], 4);
        idvd_poly_feat[5059] = pow(input_x[0], 1) * pow(input_x[3], 3) * pow(input_x[5], 3) * pow(input_x[6], 1);
        idvd_poly_feat[5060] = pow(input_x[0], 1) * pow(input_x[3], 3) * pow(input_x[5], 2) * pow(input_x[6], 2);
        idvd_poly_feat[5061] = pow(input_x[0], 1) * pow(input_x[3], 3) * pow(input_x[5], 1) * pow(input_x[6], 3);
        idvd_poly_feat[5062] = pow(input_x[0], 1) * pow(input_x[3], 3) * pow(input_x[6], 4);
        idvd_poly_feat[5063] = pow(input_x[0], 1) * pow(input_x[3], 2) * pow(input_x[4], 5);
        idvd_poly_feat[5064] = pow(input_x[0], 1) * pow(input_x[3], 2) * pow(input_x[4], 4) * pow(input_x[5], 1);
        idvd_poly_feat[5065] = pow(input_x[0], 1) * pow(input_x[3], 2) * pow(input_x[4], 4) * pow(input_x[6], 1);
        idvd_poly_feat[5066] = pow(input_x[0], 1) * pow(input_x[3], 2) * pow(input_x[4], 3) * pow(input_x[5], 2);
        idvd_poly_feat[5067] = pow(input_x[0], 1) * pow(input_x[3], 2) * pow(input_x[4], 3) * pow(input_x[5], 1) * pow(input_x[6], 1);
        idvd_poly_feat[5068] = pow(input_x[0], 1) * pow(input_x[3], 2) * pow(input_x[4], 3) * pow(input_x[6], 2);
        idvd_poly_feat[5069] = pow(input_x[0], 1) * pow(input_x[3], 2) * pow(input_x[4], 2) * pow(input_x[5], 3);
        idvd_poly_feat[5070] = pow(input_x[0], 1) * pow(input_x[3], 2) * pow(input_x[4], 2) * pow(input_x[5], 2) * pow(input_x[6], 1);
        idvd_poly_feat[5071] = pow(input_x[0], 1) * pow(input_x[3], 2) * pow(input_x[4], 2) * pow(input_x[5], 1) * pow(input_x[6], 2);
        idvd_poly_feat[5072] = pow(input_x[0], 1) * pow(input_x[3], 2) * pow(input_x[4], 2) * pow(input_x[6], 3);
        idvd_poly_feat[5073] = pow(input_x[0], 1) * pow(input_x[3], 2) * pow(input_x[4], 1) * pow(input_x[5], 4);
        idvd_poly_feat[5074] = pow(input_x[0], 1) * pow(input_x[3], 2) * pow(input_x[4], 1) * pow(input_x[5], 3) * pow(input_x[6], 1);
        idvd_poly_feat[5075] = pow(input_x[0], 1) * pow(input_x[3], 2) * pow(input_x[4], 1) * pow(input_x[5], 2) * pow(input_x[6], 2);
        idvd_poly_feat[5076] = pow(input_x[0], 1) * pow(input_x[3], 2) * pow(input_x[4], 1) * pow(input_x[5], 1) * pow(input_x[6], 3);
        idvd_poly_feat[5077] = pow(input_x[0], 1) * pow(input_x[3], 2) * pow(input_x[4], 1) * pow(input_x[6], 4);
        idvd_poly_feat[5078] = pow(input_x[0], 1) * pow(input_x[3], 2) * pow(input_x[5], 5);
        idvd_poly_feat[5079] = pow(input_x[0], 1) * pow(input_x[3], 2) * pow(input_x[5], 4) * pow(input_x[6], 1);
        idvd_poly_feat[5080] = pow(input_x[0], 1) * pow(input_x[3], 2) * pow(input_x[5], 3) * pow(input_x[6], 2);
        idvd_poly_feat[5081] = pow(input_x[0], 1) * pow(input_x[3], 2) * pow(input_x[5], 2) * pow(input_x[6], 3);
        idvd_poly_feat[5082] = pow(input_x[0], 1) * pow(input_x[3], 2) * pow(input_x[5], 1) * pow(input_x[6], 4);
        idvd_poly_feat[5083] = pow(input_x[0], 1) * pow(input_x[3], 2) * pow(input_x[6], 5);
        idvd_poly_feat[5084] = pow(input_x[0], 1) * pow(input_x[3], 1) * pow(input_x[4], 6);
        idvd_poly_feat[5085] = pow(input_x[0], 1) * pow(input_x[3], 1) * pow(input_x[4], 5) * pow(input_x[5], 1);
        idvd_poly_feat[5086] = pow(input_x[0], 1) * pow(input_x[3], 1) * pow(input_x[4], 5) * pow(input_x[6], 1);
        idvd_poly_feat[5087] = pow(input_x[0], 1) * pow(input_x[3], 1) * pow(input_x[4], 4) * pow(input_x[5], 2);
        idvd_poly_feat[5088] = pow(input_x[0], 1) * pow(input_x[3], 1) * pow(input_x[4], 4) * pow(input_x[5], 1) * pow(input_x[6], 1);
        idvd_poly_feat[5089] = pow(input_x[0], 1) * pow(input_x[3], 1) * pow(input_x[4], 4) * pow(input_x[6], 2);
        idvd_poly_feat[5090] = pow(input_x[0], 1) * pow(input_x[3], 1) * pow(input_x[4], 3) * pow(input_x[5], 3);
        idvd_poly_feat[5091] = pow(input_x[0], 1) * pow(input_x[3], 1) * pow(input_x[4], 3) * pow(input_x[5], 2) * pow(input_x[6], 1);
        idvd_poly_feat[5092] = pow(input_x[0], 1) * pow(input_x[3], 1) * pow(input_x[4], 3) * pow(input_x[5], 1) * pow(input_x[6], 2);
        idvd_poly_feat[5093] = pow(input_x[0], 1) * pow(input_x[3], 1) * pow(input_x[4], 3) * pow(input_x[6], 3);
        idvd_poly_feat[5094] = pow(input_x[0], 1) * pow(input_x[3], 1) * pow(input_x[4], 2) * pow(input_x[5], 4);
        idvd_poly_feat[5095] = pow(input_x[0], 1) * pow(input_x[3], 1) * pow(input_x[4], 2) * pow(input_x[5], 3) * pow(input_x[6], 1);
        idvd_poly_feat[5096] = pow(input_x[0], 1) * pow(input_x[3], 1) * pow(input_x[4], 2) * pow(input_x[5], 2) * pow(input_x[6], 2);
        idvd_poly_feat[5097] = pow(input_x[0], 1) * pow(input_x[3], 1) * pow(input_x[4], 2) * pow(input_x[5], 1) * pow(input_x[6], 3);
        idvd_poly_feat[5098] = pow(input_x[0], 1) * pow(input_x[3], 1) * pow(input_x[4], 2) * pow(input_x[6], 4);
        idvd_poly_feat[5099] = pow(input_x[0], 1) * pow(input_x[3], 1) * pow(input_x[4], 1) * pow(input_x[5], 5);
        idvd_poly_feat[5100] = pow(input_x[0], 1) * pow(input_x[3], 1) * pow(input_x[4], 1) * pow(input_x[5], 4) * pow(input_x[6], 1);
        idvd_poly_feat[5101] = pow(input_x[0], 1) * pow(input_x[3], 1) * pow(input_x[4], 1) * pow(input_x[5], 3) * pow(input_x[6], 2);
        idvd_poly_feat[5102] = pow(input_x[0], 1) * pow(input_x[3], 1) * pow(input_x[4], 1) * pow(input_x[5], 2) * pow(input_x[6], 3);
        idvd_poly_feat[5103] = pow(input_x[0], 1) * pow(input_x[3], 1) * pow(input_x[4], 1) * pow(input_x[5], 1) * pow(input_x[6], 4);
        idvd_poly_feat[5104] = pow(input_x[0], 1) * pow(input_x[3], 1) * pow(input_x[4], 1) * pow(input_x[6], 5);
        idvd_poly_feat[5105] = pow(input_x[0], 1) * pow(input_x[3], 1) * pow(input_x[5], 6);
        idvd_poly_feat[5106] = pow(input_x[0], 1) * pow(input_x[3], 1) * pow(input_x[5], 5) * pow(input_x[6], 1);
        idvd_poly_feat[5107] = pow(input_x[0], 1) * pow(input_x[3], 1) * pow(input_x[5], 4) * pow(input_x[6], 2);
        idvd_poly_feat[5108] = pow(input_x[0], 1) * pow(input_x[3], 1) * pow(input_x[5], 3) * pow(input_x[6], 3);
        idvd_poly_feat[5109] = pow(input_x[0], 1) * pow(input_x[3], 1) * pow(input_x[5], 2) * pow(input_x[6], 4);
        idvd_poly_feat[5110] = pow(input_x[0], 1) * pow(input_x[3], 1) * pow(input_x[5], 1) * pow(input_x[6], 5);
        idvd_poly_feat[5111] = pow(input_x[0], 1) * pow(input_x[3], 1) * pow(input_x[6], 6);
        idvd_poly_feat[5112] = pow(input_x[0], 1) * pow(input_x[4], 7);
        idvd_poly_feat[5113] = pow(input_x[0], 1) * pow(input_x[4], 6) * pow(input_x[5], 1);
        idvd_poly_feat[5114] = pow(input_x[0], 1) * pow(input_x[4], 6) * pow(input_x[6], 1);
        idvd_poly_feat[5115] = pow(input_x[0], 1) * pow(input_x[4], 5) * pow(input_x[5], 2);
        idvd_poly_feat[5116] = pow(input_x[0], 1) * pow(input_x[4], 5) * pow(input_x[5], 1) * pow(input_x[6], 1);
        idvd_poly_feat[5117] = pow(input_x[0], 1) * pow(input_x[4], 5) * pow(input_x[6], 2);
        idvd_poly_feat[5118] = pow(input_x[0], 1) * pow(input_x[4], 4) * pow(input_x[5], 3);
        idvd_poly_feat[5119] = pow(input_x[0], 1) * pow(input_x[4], 4) * pow(input_x[5], 2) * pow(input_x[6], 1);
        idvd_poly_feat[5120] = pow(input_x[0], 1) * pow(input_x[4], 4) * pow(input_x[5], 1) * pow(input_x[6], 2);
        idvd_poly_feat[5121] = pow(input_x[0], 1) * pow(input_x[4], 4) * pow(input_x[6], 3);
        idvd_poly_feat[5122] = pow(input_x[0], 1) * pow(input_x[4], 3) * pow(input_x[5], 4);
        idvd_poly_feat[5123] = pow(input_x[0], 1) * pow(input_x[4], 3) * pow(input_x[5], 3) * pow(input_x[6], 1);
        idvd_poly_feat[5124] = pow(input_x[0], 1) * pow(input_x[4], 3) * pow(input_x[5], 2) * pow(input_x[6], 2);
        idvd_poly_feat[5125] = pow(input_x[0], 1) * pow(input_x[4], 3) * pow(input_x[5], 1) * pow(input_x[6], 3);
        idvd_poly_feat[5126] = pow(input_x[0], 1) * pow(input_x[4], 3) * pow(input_x[6], 4);
        idvd_poly_feat[5127] = pow(input_x[0], 1) * pow(input_x[4], 2) * pow(input_x[5], 5);
        idvd_poly_feat[5128] = pow(input_x[0], 1) * pow(input_x[4], 2) * pow(input_x[5], 4) * pow(input_x[6], 1);
        idvd_poly_feat[5129] = pow(input_x[0], 1) * pow(input_x[4], 2) * pow(input_x[5], 3) * pow(input_x[6], 2);
        idvd_poly_feat[5130] = pow(input_x[0], 1) * pow(input_x[4], 2) * pow(input_x[5], 2) * pow(input_x[6], 3);
        idvd_poly_feat[5131] = pow(input_x[0], 1) * pow(input_x[4], 2) * pow(input_x[5], 1) * pow(input_x[6], 4);
        idvd_poly_feat[5132] = pow(input_x[0], 1) * pow(input_x[4], 2) * pow(input_x[6], 5);
        idvd_poly_feat[5133] = pow(input_x[0], 1) * pow(input_x[4], 1) * pow(input_x[5], 6);
        idvd_poly_feat[5134] = pow(input_x[0], 1) * pow(input_x[4], 1) * pow(input_x[5], 5) * pow(input_x[6], 1);
        idvd_poly_feat[5135] = pow(input_x[0], 1) * pow(input_x[4], 1) * pow(input_x[5], 4) * pow(input_x[6], 2);
        idvd_poly_feat[5136] = pow(input_x[0], 1) * pow(input_x[4], 1) * pow(input_x[5], 3) * pow(input_x[6], 3);
        idvd_poly_feat[5137] = pow(input_x[0], 1) * pow(input_x[4], 1) * pow(input_x[5], 2) * pow(input_x[6], 4);
        idvd_poly_feat[5138] = pow(input_x[0], 1) * pow(input_x[4], 1) * pow(input_x[5], 1) * pow(input_x[6], 5);
        idvd_poly_feat[5139] = pow(input_x[0], 1) * pow(input_x[4], 1) * pow(input_x[6], 6);
        idvd_poly_feat[5140] = pow(input_x[0], 1) * pow(input_x[5], 7);
        idvd_poly_feat[5141] = pow(input_x[0], 1) * pow(input_x[5], 6) * pow(input_x[6], 1);
        idvd_poly_feat[5142] = pow(input_x[0], 1) * pow(input_x[5], 5) * pow(input_x[6], 2);
        idvd_poly_feat[5143] = pow(input_x[0], 1) * pow(input_x[5], 4) * pow(input_x[6], 3);
        idvd_poly_feat[5144] = pow(input_x[0], 1) * pow(input_x[5], 3) * pow(input_x[6], 4);
        idvd_poly_feat[5145] = pow(input_x[0], 1) * pow(input_x[5], 2) * pow(input_x[6], 5);
        idvd_poly_feat[5146] = pow(input_x[0], 1) * pow(input_x[5], 1) * pow(input_x[6], 6);
        idvd_poly_feat[5147] = pow(input_x[0], 1) * pow(input_x[6], 7);
        idvd_poly_feat[5148] = pow(input_x[1], 8);
        idvd_poly_feat[5149] = pow(input_x[1], 7) * pow(input_x[2], 1);
        idvd_poly_feat[5150] = pow(input_x[1], 7) * pow(input_x[3], 1);
        idvd_poly_feat[5151] = pow(input_x[1], 7) * pow(input_x[4], 1);
        idvd_poly_feat[5152] = pow(input_x[1], 7) * pow(input_x[5], 1);
        idvd_poly_feat[5153] = pow(input_x[1], 7) * pow(input_x[6], 1);
        idvd_poly_feat[5154] = pow(input_x[1], 6) * pow(input_x[2], 2);
        idvd_poly_feat[5155] = pow(input_x[1], 6) * pow(input_x[2], 1) * pow(input_x[3], 1);
        idvd_poly_feat[5156] = pow(input_x[1], 6) * pow(input_x[2], 1) * pow(input_x[4], 1);
        idvd_poly_feat[5157] = pow(input_x[1], 6) * pow(input_x[2], 1) * pow(input_x[5], 1);
        idvd_poly_feat[5158] = pow(input_x[1], 6) * pow(input_x[2], 1) * pow(input_x[6], 1);
        idvd_poly_feat[5159] = pow(input_x[1], 6) * pow(input_x[3], 2);
        idvd_poly_feat[5160] = pow(input_x[1], 6) * pow(input_x[3], 1) * pow(input_x[4], 1);
        idvd_poly_feat[5161] = pow(input_x[1], 6) * pow(input_x[3], 1) * pow(input_x[5], 1);
        idvd_poly_feat[5162] = pow(input_x[1], 6) * pow(input_x[3], 1) * pow(input_x[6], 1);
        idvd_poly_feat[5163] = pow(input_x[1], 6) * pow(input_x[4], 2);
        idvd_poly_feat[5164] = pow(input_x[1], 6) * pow(input_x[4], 1) * pow(input_x[5], 1);
        idvd_poly_feat[5165] = pow(input_x[1], 6) * pow(input_x[4], 1) * pow(input_x[6], 1);
        idvd_poly_feat[5166] = pow(input_x[1], 6) * pow(input_x[5], 2);
        idvd_poly_feat[5167] = pow(input_x[1], 6) * pow(input_x[5], 1) * pow(input_x[6], 1);
        idvd_poly_feat[5168] = pow(input_x[1], 6) * pow(input_x[6], 2);
        idvd_poly_feat[5169] = pow(input_x[1], 5) * pow(input_x[2], 3);
        idvd_poly_feat[5170] = pow(input_x[1], 5) * pow(input_x[2], 2) * pow(input_x[3], 1);
        idvd_poly_feat[5171] = pow(input_x[1], 5) * pow(input_x[2], 2) * pow(input_x[4], 1);
        idvd_poly_feat[5172] = pow(input_x[1], 5) * pow(input_x[2], 2) * pow(input_x[5], 1);
        idvd_poly_feat[5173] = pow(input_x[1], 5) * pow(input_x[2], 2) * pow(input_x[6], 1);
        idvd_poly_feat[5174] = pow(input_x[1], 5) * pow(input_x[2], 1) * pow(input_x[3], 2);
        idvd_poly_feat[5175] = pow(input_x[1], 5) * pow(input_x[2], 1) * pow(input_x[3], 1) * pow(input_x[4], 1);
        idvd_poly_feat[5176] = pow(input_x[1], 5) * pow(input_x[2], 1) * pow(input_x[3], 1) * pow(input_x[5], 1);
        idvd_poly_feat[5177] = pow(input_x[1], 5) * pow(input_x[2], 1) * pow(input_x[3], 1) * pow(input_x[6], 1);
        idvd_poly_feat[5178] = pow(input_x[1], 5) * pow(input_x[2], 1) * pow(input_x[4], 2);
        idvd_poly_feat[5179] = pow(input_x[1], 5) * pow(input_x[2], 1) * pow(input_x[4], 1) * pow(input_x[5], 1);
        idvd_poly_feat[5180] = pow(input_x[1], 5) * pow(input_x[2], 1) * pow(input_x[4], 1) * pow(input_x[6], 1);
        idvd_poly_feat[5181] = pow(input_x[1], 5) * pow(input_x[2], 1) * pow(input_x[5], 2);
        idvd_poly_feat[5182] = pow(input_x[1], 5) * pow(input_x[2], 1) * pow(input_x[5], 1) * pow(input_x[6], 1);
        idvd_poly_feat[5183] = pow(input_x[1], 5) * pow(input_x[2], 1) * pow(input_x[6], 2);
        idvd_poly_feat[5184] = pow(input_x[1], 5) * pow(input_x[3], 3);
        idvd_poly_feat[5185] = pow(input_x[1], 5) * pow(input_x[3], 2) * pow(input_x[4], 1);
        idvd_poly_feat[5186] = pow(input_x[1], 5) * pow(input_x[3], 2) * pow(input_x[5], 1);
        idvd_poly_feat[5187] = pow(input_x[1], 5) * pow(input_x[3], 2) * pow(input_x[6], 1);
        idvd_poly_feat[5188] = pow(input_x[1], 5) * pow(input_x[3], 1) * pow(input_x[4], 2);
        idvd_poly_feat[5189] = pow(input_x[1], 5) * pow(input_x[3], 1) * pow(input_x[4], 1) * pow(input_x[5], 1);
        idvd_poly_feat[5190] = pow(input_x[1], 5) * pow(input_x[3], 1) * pow(input_x[4], 1) * pow(input_x[6], 1);
        idvd_poly_feat[5191] = pow(input_x[1], 5) * pow(input_x[3], 1) * pow(input_x[5], 2);
        idvd_poly_feat[5192] = pow(input_x[1], 5) * pow(input_x[3], 1) * pow(input_x[5], 1) * pow(input_x[6], 1);
        idvd_poly_feat[5193] = pow(input_x[1], 5) * pow(input_x[3], 1) * pow(input_x[6], 2);
        idvd_poly_feat[5194] = pow(input_x[1], 5) * pow(input_x[4], 3);
        idvd_poly_feat[5195] = pow(input_x[1], 5) * pow(input_x[4], 2) * pow(input_x[5], 1);
        idvd_poly_feat[5196] = pow(input_x[1], 5) * pow(input_x[4], 2) * pow(input_x[6], 1);
        idvd_poly_feat[5197] = pow(input_x[1], 5) * pow(input_x[4], 1) * pow(input_x[5], 2);
        idvd_poly_feat[5198] = pow(input_x[1], 5) * pow(input_x[4], 1) * pow(input_x[5], 1) * pow(input_x[6], 1);
        idvd_poly_feat[5199] = pow(input_x[1], 5) * pow(input_x[4], 1) * pow(input_x[6], 2);
        idvd_poly_feat[5200] = pow(input_x[1], 5) * pow(input_x[5], 3);
        idvd_poly_feat[5201] = pow(input_x[1], 5) * pow(input_x[5], 2) * pow(input_x[6], 1);
        idvd_poly_feat[5202] = pow(input_x[1], 5) * pow(input_x[5], 1) * pow(input_x[6], 2);
        idvd_poly_feat[5203] = pow(input_x[1], 5) * pow(input_x[6], 3);
        idvd_poly_feat[5204] = pow(input_x[1], 4) * pow(input_x[2], 4);
        idvd_poly_feat[5205] = pow(input_x[1], 4) * pow(input_x[2], 3) * pow(input_x[3], 1);
        idvd_poly_feat[5206] = pow(input_x[1], 4) * pow(input_x[2], 3) * pow(input_x[4], 1);
        idvd_poly_feat[5207] = pow(input_x[1], 4) * pow(input_x[2], 3) * pow(input_x[5], 1);
        idvd_poly_feat[5208] = pow(input_x[1], 4) * pow(input_x[2], 3) * pow(input_x[6], 1);
        idvd_poly_feat[5209] = pow(input_x[1], 4) * pow(input_x[2], 2) * pow(input_x[3], 2);
        idvd_poly_feat[5210] = pow(input_x[1], 4) * pow(input_x[2], 2) * pow(input_x[3], 1) * pow(input_x[4], 1);
        idvd_poly_feat[5211] = pow(input_x[1], 4) * pow(input_x[2], 2) * pow(input_x[3], 1) * pow(input_x[5], 1);
        idvd_poly_feat[5212] = pow(input_x[1], 4) * pow(input_x[2], 2) * pow(input_x[3], 1) * pow(input_x[6], 1);
        idvd_poly_feat[5213] = pow(input_x[1], 4) * pow(input_x[2], 2) * pow(input_x[4], 2);
        idvd_poly_feat[5214] = pow(input_x[1], 4) * pow(input_x[2], 2) * pow(input_x[4], 1) * pow(input_x[5], 1);
        idvd_poly_feat[5215] = pow(input_x[1], 4) * pow(input_x[2], 2) * pow(input_x[4], 1) * pow(input_x[6], 1);
        idvd_poly_feat[5216] = pow(input_x[1], 4) * pow(input_x[2], 2) * pow(input_x[5], 2);
        idvd_poly_feat[5217] = pow(input_x[1], 4) * pow(input_x[2], 2) * pow(input_x[5], 1) * pow(input_x[6], 1);
        idvd_poly_feat[5218] = pow(input_x[1], 4) * pow(input_x[2], 2) * pow(input_x[6], 2);
        idvd_poly_feat[5219] = pow(input_x[1], 4) * pow(input_x[2], 1) * pow(input_x[3], 3);
        idvd_poly_feat[5220] = pow(input_x[1], 4) * pow(input_x[2], 1) * pow(input_x[3], 2) * pow(input_x[4], 1);
        idvd_poly_feat[5221] = pow(input_x[1], 4) * pow(input_x[2], 1) * pow(input_x[3], 2) * pow(input_x[5], 1);
        idvd_poly_feat[5222] = pow(input_x[1], 4) * pow(input_x[2], 1) * pow(input_x[3], 2) * pow(input_x[6], 1);
        idvd_poly_feat[5223] = pow(input_x[1], 4) * pow(input_x[2], 1) * pow(input_x[3], 1) * pow(input_x[4], 2);
        idvd_poly_feat[5224] = pow(input_x[1], 4) * pow(input_x[2], 1) * pow(input_x[3], 1) * pow(input_x[4], 1) * pow(input_x[5], 1);
        idvd_poly_feat[5225] = pow(input_x[1], 4) * pow(input_x[2], 1) * pow(input_x[3], 1) * pow(input_x[4], 1) * pow(input_x[6], 1);
        idvd_poly_feat[5226] = pow(input_x[1], 4) * pow(input_x[2], 1) * pow(input_x[3], 1) * pow(input_x[5], 2);
        idvd_poly_feat[5227] = pow(input_x[1], 4) * pow(input_x[2], 1) * pow(input_x[3], 1) * pow(input_x[5], 1) * pow(input_x[6], 1);
        idvd_poly_feat[5228] = pow(input_x[1], 4) * pow(input_x[2], 1) * pow(input_x[3], 1) * pow(input_x[6], 2);
        idvd_poly_feat[5229] = pow(input_x[1], 4) * pow(input_x[2], 1) * pow(input_x[4], 3);
        idvd_poly_feat[5230] = pow(input_x[1], 4) * pow(input_x[2], 1) * pow(input_x[4], 2) * pow(input_x[5], 1);
        idvd_poly_feat[5231] = pow(input_x[1], 4) * pow(input_x[2], 1) * pow(input_x[4], 2) * pow(input_x[6], 1);
        idvd_poly_feat[5232] = pow(input_x[1], 4) * pow(input_x[2], 1) * pow(input_x[4], 1) * pow(input_x[5], 2);
        idvd_poly_feat[5233] = pow(input_x[1], 4) * pow(input_x[2], 1) * pow(input_x[4], 1) * pow(input_x[5], 1) * pow(input_x[6], 1);
        idvd_poly_feat[5234] = pow(input_x[1], 4) * pow(input_x[2], 1) * pow(input_x[4], 1) * pow(input_x[6], 2);
        idvd_poly_feat[5235] = pow(input_x[1], 4) * pow(input_x[2], 1) * pow(input_x[5], 3);
        idvd_poly_feat[5236] = pow(input_x[1], 4) * pow(input_x[2], 1) * pow(input_x[5], 2) * pow(input_x[6], 1);
        idvd_poly_feat[5237] = pow(input_x[1], 4) * pow(input_x[2], 1) * pow(input_x[5], 1) * pow(input_x[6], 2);
        idvd_poly_feat[5238] = pow(input_x[1], 4) * pow(input_x[2], 1) * pow(input_x[6], 3);
        idvd_poly_feat[5239] = pow(input_x[1], 4) * pow(input_x[3], 4);
        idvd_poly_feat[5240] = pow(input_x[1], 4) * pow(input_x[3], 3) * pow(input_x[4], 1);
        idvd_poly_feat[5241] = pow(input_x[1], 4) * pow(input_x[3], 3) * pow(input_x[5], 1);
        idvd_poly_feat[5242] = pow(input_x[1], 4) * pow(input_x[3], 3) * pow(input_x[6], 1);
        idvd_poly_feat[5243] = pow(input_x[1], 4) * pow(input_x[3], 2) * pow(input_x[4], 2);
        idvd_poly_feat[5244] = pow(input_x[1], 4) * pow(input_x[3], 2) * pow(input_x[4], 1) * pow(input_x[5], 1);
        idvd_poly_feat[5245] = pow(input_x[1], 4) * pow(input_x[3], 2) * pow(input_x[4], 1) * pow(input_x[6], 1);
        idvd_poly_feat[5246] = pow(input_x[1], 4) * pow(input_x[3], 2) * pow(input_x[5], 2);
        idvd_poly_feat[5247] = pow(input_x[1], 4) * pow(input_x[3], 2) * pow(input_x[5], 1) * pow(input_x[6], 1);
        idvd_poly_feat[5248] = pow(input_x[1], 4) * pow(input_x[3], 2) * pow(input_x[6], 2);
        idvd_poly_feat[5249] = pow(input_x[1], 4) * pow(input_x[3], 1) * pow(input_x[4], 3);
        idvd_poly_feat[5250] = pow(input_x[1], 4) * pow(input_x[3], 1) * pow(input_x[4], 2) * pow(input_x[5], 1);
        idvd_poly_feat[5251] = pow(input_x[1], 4) * pow(input_x[3], 1) * pow(input_x[4], 2) * pow(input_x[6], 1);
        idvd_poly_feat[5252] = pow(input_x[1], 4) * pow(input_x[3], 1) * pow(input_x[4], 1) * pow(input_x[5], 2);
        idvd_poly_feat[5253] = pow(input_x[1], 4) * pow(input_x[3], 1) * pow(input_x[4], 1) * pow(input_x[5], 1) * pow(input_x[6], 1);
        idvd_poly_feat[5254] = pow(input_x[1], 4) * pow(input_x[3], 1) * pow(input_x[4], 1) * pow(input_x[6], 2);
        idvd_poly_feat[5255] = pow(input_x[1], 4) * pow(input_x[3], 1) * pow(input_x[5], 3);
        idvd_poly_feat[5256] = pow(input_x[1], 4) * pow(input_x[3], 1) * pow(input_x[5], 2) * pow(input_x[6], 1);
        idvd_poly_feat[5257] = pow(input_x[1], 4) * pow(input_x[3], 1) * pow(input_x[5], 1) * pow(input_x[6], 2);
        idvd_poly_feat[5258] = pow(input_x[1], 4) * pow(input_x[3], 1) * pow(input_x[6], 3);
        idvd_poly_feat[5259] = pow(input_x[1], 4) * pow(input_x[4], 4);
        idvd_poly_feat[5260] = pow(input_x[1], 4) * pow(input_x[4], 3) * pow(input_x[5], 1);
        idvd_poly_feat[5261] = pow(input_x[1], 4) * pow(input_x[4], 3) * pow(input_x[6], 1);
        idvd_poly_feat[5262] = pow(input_x[1], 4) * pow(input_x[4], 2) * pow(input_x[5], 2);
        idvd_poly_feat[5263] = pow(input_x[1], 4) * pow(input_x[4], 2) * pow(input_x[5], 1) * pow(input_x[6], 1);
        idvd_poly_feat[5264] = pow(input_x[1], 4) * pow(input_x[4], 2) * pow(input_x[6], 2);
        idvd_poly_feat[5265] = pow(input_x[1], 4) * pow(input_x[4], 1) * pow(input_x[5], 3);
        idvd_poly_feat[5266] = pow(input_x[1], 4) * pow(input_x[4], 1) * pow(input_x[5], 2) * pow(input_x[6], 1);
        idvd_poly_feat[5267] = pow(input_x[1], 4) * pow(input_x[4], 1) * pow(input_x[5], 1) * pow(input_x[6], 2);
        idvd_poly_feat[5268] = pow(input_x[1], 4) * pow(input_x[4], 1) * pow(input_x[6], 3);
        idvd_poly_feat[5269] = pow(input_x[1], 4) * pow(input_x[5], 4);
        idvd_poly_feat[5270] = pow(input_x[1], 4) * pow(input_x[5], 3) * pow(input_x[6], 1);
        idvd_poly_feat[5271] = pow(input_x[1], 4) * pow(input_x[5], 2) * pow(input_x[6], 2);
        idvd_poly_feat[5272] = pow(input_x[1], 4) * pow(input_x[5], 1) * pow(input_x[6], 3);
        idvd_poly_feat[5273] = pow(input_x[1], 4) * pow(input_x[6], 4);
        idvd_poly_feat[5274] = pow(input_x[1], 3) * pow(input_x[2], 5);
        idvd_poly_feat[5275] = pow(input_x[1], 3) * pow(input_x[2], 4) * pow(input_x[3], 1);
        idvd_poly_feat[5276] = pow(input_x[1], 3) * pow(input_x[2], 4) * pow(input_x[4], 1);
        idvd_poly_feat[5277] = pow(input_x[1], 3) * pow(input_x[2], 4) * pow(input_x[5], 1);
        idvd_poly_feat[5278] = pow(input_x[1], 3) * pow(input_x[2], 4) * pow(input_x[6], 1);
        idvd_poly_feat[5279] = pow(input_x[1], 3) * pow(input_x[2], 3) * pow(input_x[3], 2);
        idvd_poly_feat[5280] = pow(input_x[1], 3) * pow(input_x[2], 3) * pow(input_x[3], 1) * pow(input_x[4], 1);
        idvd_poly_feat[5281] = pow(input_x[1], 3) * pow(input_x[2], 3) * pow(input_x[3], 1) * pow(input_x[5], 1);
        idvd_poly_feat[5282] = pow(input_x[1], 3) * pow(input_x[2], 3) * pow(input_x[3], 1) * pow(input_x[6], 1);
        idvd_poly_feat[5283] = pow(input_x[1], 3) * pow(input_x[2], 3) * pow(input_x[4], 2);
        idvd_poly_feat[5284] = pow(input_x[1], 3) * pow(input_x[2], 3) * pow(input_x[4], 1) * pow(input_x[5], 1);
        idvd_poly_feat[5285] = pow(input_x[1], 3) * pow(input_x[2], 3) * pow(input_x[4], 1) * pow(input_x[6], 1);
        idvd_poly_feat[5286] = pow(input_x[1], 3) * pow(input_x[2], 3) * pow(input_x[5], 2);
        idvd_poly_feat[5287] = pow(input_x[1], 3) * pow(input_x[2], 3) * pow(input_x[5], 1) * pow(input_x[6], 1);
        idvd_poly_feat[5288] = pow(input_x[1], 3) * pow(input_x[2], 3) * pow(input_x[6], 2);
        idvd_poly_feat[5289] = pow(input_x[1], 3) * pow(input_x[2], 2) * pow(input_x[3], 3);
        idvd_poly_feat[5290] = pow(input_x[1], 3) * pow(input_x[2], 2) * pow(input_x[3], 2) * pow(input_x[4], 1);
        idvd_poly_feat[5291] = pow(input_x[1], 3) * pow(input_x[2], 2) * pow(input_x[3], 2) * pow(input_x[5], 1);
        idvd_poly_feat[5292] = pow(input_x[1], 3) * pow(input_x[2], 2) * pow(input_x[3], 2) * pow(input_x[6], 1);
        idvd_poly_feat[5293] = pow(input_x[1], 3) * pow(input_x[2], 2) * pow(input_x[3], 1) * pow(input_x[4], 2);
        idvd_poly_feat[5294] = pow(input_x[1], 3) * pow(input_x[2], 2) * pow(input_x[3], 1) * pow(input_x[4], 1) * pow(input_x[5], 1);
        idvd_poly_feat[5295] = pow(input_x[1], 3) * pow(input_x[2], 2) * pow(input_x[3], 1) * pow(input_x[4], 1) * pow(input_x[6], 1);
        idvd_poly_feat[5296] = pow(input_x[1], 3) * pow(input_x[2], 2) * pow(input_x[3], 1) * pow(input_x[5], 2);
        idvd_poly_feat[5297] = pow(input_x[1], 3) * pow(input_x[2], 2) * pow(input_x[3], 1) * pow(input_x[5], 1) * pow(input_x[6], 1);
        idvd_poly_feat[5298] = pow(input_x[1], 3) * pow(input_x[2], 2) * pow(input_x[3], 1) * pow(input_x[6], 2);
        idvd_poly_feat[5299] = pow(input_x[1], 3) * pow(input_x[2], 2) * pow(input_x[4], 3);
        idvd_poly_feat[5300] = pow(input_x[1], 3) * pow(input_x[2], 2) * pow(input_x[4], 2) * pow(input_x[5], 1);
        idvd_poly_feat[5301] = pow(input_x[1], 3) * pow(input_x[2], 2) * pow(input_x[4], 2) * pow(input_x[6], 1);
        idvd_poly_feat[5302] = pow(input_x[1], 3) * pow(input_x[2], 2) * pow(input_x[4], 1) * pow(input_x[5], 2);
        idvd_poly_feat[5303] = pow(input_x[1], 3) * pow(input_x[2], 2) * pow(input_x[4], 1) * pow(input_x[5], 1) * pow(input_x[6], 1);
        idvd_poly_feat[5304] = pow(input_x[1], 3) * pow(input_x[2], 2) * pow(input_x[4], 1) * pow(input_x[6], 2);
        idvd_poly_feat[5305] = pow(input_x[1], 3) * pow(input_x[2], 2) * pow(input_x[5], 3);
        idvd_poly_feat[5306] = pow(input_x[1], 3) * pow(input_x[2], 2) * pow(input_x[5], 2) * pow(input_x[6], 1);
        idvd_poly_feat[5307] = pow(input_x[1], 3) * pow(input_x[2], 2) * pow(input_x[5], 1) * pow(input_x[6], 2);
        idvd_poly_feat[5308] = pow(input_x[1], 3) * pow(input_x[2], 2) * pow(input_x[6], 3);
        idvd_poly_feat[5309] = pow(input_x[1], 3) * pow(input_x[2], 1) * pow(input_x[3], 4);
        idvd_poly_feat[5310] = pow(input_x[1], 3) * pow(input_x[2], 1) * pow(input_x[3], 3) * pow(input_x[4], 1);
        idvd_poly_feat[5311] = pow(input_x[1], 3) * pow(input_x[2], 1) * pow(input_x[3], 3) * pow(input_x[5], 1);
        idvd_poly_feat[5312] = pow(input_x[1], 3) * pow(input_x[2], 1) * pow(input_x[3], 3) * pow(input_x[6], 1);
        idvd_poly_feat[5313] = pow(input_x[1], 3) * pow(input_x[2], 1) * pow(input_x[3], 2) * pow(input_x[4], 2);
        idvd_poly_feat[5314] = pow(input_x[1], 3) * pow(input_x[2], 1) * pow(input_x[3], 2) * pow(input_x[4], 1) * pow(input_x[5], 1);
        idvd_poly_feat[5315] = pow(input_x[1], 3) * pow(input_x[2], 1) * pow(input_x[3], 2) * pow(input_x[4], 1) * pow(input_x[6], 1);
        idvd_poly_feat[5316] = pow(input_x[1], 3) * pow(input_x[2], 1) * pow(input_x[3], 2) * pow(input_x[5], 2);
        idvd_poly_feat[5317] = pow(input_x[1], 3) * pow(input_x[2], 1) * pow(input_x[3], 2) * pow(input_x[5], 1) * pow(input_x[6], 1);
        idvd_poly_feat[5318] = pow(input_x[1], 3) * pow(input_x[2], 1) * pow(input_x[3], 2) * pow(input_x[6], 2);
        idvd_poly_feat[5319] = pow(input_x[1], 3) * pow(input_x[2], 1) * pow(input_x[3], 1) * pow(input_x[4], 3);
        idvd_poly_feat[5320] = pow(input_x[1], 3) * pow(input_x[2], 1) * pow(input_x[3], 1) * pow(input_x[4], 2) * pow(input_x[5], 1);
        idvd_poly_feat[5321] = pow(input_x[1], 3) * pow(input_x[2], 1) * pow(input_x[3], 1) * pow(input_x[4], 2) * pow(input_x[6], 1);
        idvd_poly_feat[5322] = pow(input_x[1], 3) * pow(input_x[2], 1) * pow(input_x[3], 1) * pow(input_x[4], 1) * pow(input_x[5], 2);
        idvd_poly_feat[5323] = pow(input_x[1], 3) * pow(input_x[2], 1) * pow(input_x[3], 1) * pow(input_x[4], 1) * pow(input_x[5], 1) * pow(input_x[6], 1);
        idvd_poly_feat[5324] = pow(input_x[1], 3) * pow(input_x[2], 1) * pow(input_x[3], 1) * pow(input_x[4], 1) * pow(input_x[6], 2);
        idvd_poly_feat[5325] = pow(input_x[1], 3) * pow(input_x[2], 1) * pow(input_x[3], 1) * pow(input_x[5], 3);
        idvd_poly_feat[5326] = pow(input_x[1], 3) * pow(input_x[2], 1) * pow(input_x[3], 1) * pow(input_x[5], 2) * pow(input_x[6], 1);
        idvd_poly_feat[5327] = pow(input_x[1], 3) * pow(input_x[2], 1) * pow(input_x[3], 1) * pow(input_x[5], 1) * pow(input_x[6], 2);
        idvd_poly_feat[5328] = pow(input_x[1], 3) * pow(input_x[2], 1) * pow(input_x[3], 1) * pow(input_x[6], 3);
        idvd_poly_feat[5329] = pow(input_x[1], 3) * pow(input_x[2], 1) * pow(input_x[4], 4);
        idvd_poly_feat[5330] = pow(input_x[1], 3) * pow(input_x[2], 1) * pow(input_x[4], 3) * pow(input_x[5], 1);
        idvd_poly_feat[5331] = pow(input_x[1], 3) * pow(input_x[2], 1) * pow(input_x[4], 3) * pow(input_x[6], 1);
        idvd_poly_feat[5332] = pow(input_x[1], 3) * pow(input_x[2], 1) * pow(input_x[4], 2) * pow(input_x[5], 2);
        idvd_poly_feat[5333] = pow(input_x[1], 3) * pow(input_x[2], 1) * pow(input_x[4], 2) * pow(input_x[5], 1) * pow(input_x[6], 1);
        idvd_poly_feat[5334] = pow(input_x[1], 3) * pow(input_x[2], 1) * pow(input_x[4], 2) * pow(input_x[6], 2);
        idvd_poly_feat[5335] = pow(input_x[1], 3) * pow(input_x[2], 1) * pow(input_x[4], 1) * pow(input_x[5], 3);
        idvd_poly_feat[5336] = pow(input_x[1], 3) * pow(input_x[2], 1) * pow(input_x[4], 1) * pow(input_x[5], 2) * pow(input_x[6], 1);
        idvd_poly_feat[5337] = pow(input_x[1], 3) * pow(input_x[2], 1) * pow(input_x[4], 1) * pow(input_x[5], 1) * pow(input_x[6], 2);
        idvd_poly_feat[5338] = pow(input_x[1], 3) * pow(input_x[2], 1) * pow(input_x[4], 1) * pow(input_x[6], 3);
        idvd_poly_feat[5339] = pow(input_x[1], 3) * pow(input_x[2], 1) * pow(input_x[5], 4);
        idvd_poly_feat[5340] = pow(input_x[1], 3) * pow(input_x[2], 1) * pow(input_x[5], 3) * pow(input_x[6], 1);
        idvd_poly_feat[5341] = pow(input_x[1], 3) * pow(input_x[2], 1) * pow(input_x[5], 2) * pow(input_x[6], 2);
        idvd_poly_feat[5342] = pow(input_x[1], 3) * pow(input_x[2], 1) * pow(input_x[5], 1) * pow(input_x[6], 3);
        idvd_poly_feat[5343] = pow(input_x[1], 3) * pow(input_x[2], 1) * pow(input_x[6], 4);
        idvd_poly_feat[5344] = pow(input_x[1], 3) * pow(input_x[3], 5);
        idvd_poly_feat[5345] = pow(input_x[1], 3) * pow(input_x[3], 4) * pow(input_x[4], 1);
        idvd_poly_feat[5346] = pow(input_x[1], 3) * pow(input_x[3], 4) * pow(input_x[5], 1);
        idvd_poly_feat[5347] = pow(input_x[1], 3) * pow(input_x[3], 4) * pow(input_x[6], 1);
        idvd_poly_feat[5348] = pow(input_x[1], 3) * pow(input_x[3], 3) * pow(input_x[4], 2);
        idvd_poly_feat[5349] = pow(input_x[1], 3) * pow(input_x[3], 3) * pow(input_x[4], 1) * pow(input_x[5], 1);
        idvd_poly_feat[5350] = pow(input_x[1], 3) * pow(input_x[3], 3) * pow(input_x[4], 1) * pow(input_x[6], 1);
        idvd_poly_feat[5351] = pow(input_x[1], 3) * pow(input_x[3], 3) * pow(input_x[5], 2);
        idvd_poly_feat[5352] = pow(input_x[1], 3) * pow(input_x[3], 3) * pow(input_x[5], 1) * pow(input_x[6], 1);
        idvd_poly_feat[5353] = pow(input_x[1], 3) * pow(input_x[3], 3) * pow(input_x[6], 2);
        idvd_poly_feat[5354] = pow(input_x[1], 3) * pow(input_x[3], 2) * pow(input_x[4], 3);
        idvd_poly_feat[5355] = pow(input_x[1], 3) * pow(input_x[3], 2) * pow(input_x[4], 2) * pow(input_x[5], 1);
        idvd_poly_feat[5356] = pow(input_x[1], 3) * pow(input_x[3], 2) * pow(input_x[4], 2) * pow(input_x[6], 1);
        idvd_poly_feat[5357] = pow(input_x[1], 3) * pow(input_x[3], 2) * pow(input_x[4], 1) * pow(input_x[5], 2);
        idvd_poly_feat[5358] = pow(input_x[1], 3) * pow(input_x[3], 2) * pow(input_x[4], 1) * pow(input_x[5], 1) * pow(input_x[6], 1);
        idvd_poly_feat[5359] = pow(input_x[1], 3) * pow(input_x[3], 2) * pow(input_x[4], 1) * pow(input_x[6], 2);
        idvd_poly_feat[5360] = pow(input_x[1], 3) * pow(input_x[3], 2) * pow(input_x[5], 3);
        idvd_poly_feat[5361] = pow(input_x[1], 3) * pow(input_x[3], 2) * pow(input_x[5], 2) * pow(input_x[6], 1);
        idvd_poly_feat[5362] = pow(input_x[1], 3) * pow(input_x[3], 2) * pow(input_x[5], 1) * pow(input_x[6], 2);
        idvd_poly_feat[5363] = pow(input_x[1], 3) * pow(input_x[3], 2) * pow(input_x[6], 3);
        idvd_poly_feat[5364] = pow(input_x[1], 3) * pow(input_x[3], 1) * pow(input_x[4], 4);
        idvd_poly_feat[5365] = pow(input_x[1], 3) * pow(input_x[3], 1) * pow(input_x[4], 3) * pow(input_x[5], 1);
        idvd_poly_feat[5366] = pow(input_x[1], 3) * pow(input_x[3], 1) * pow(input_x[4], 3) * pow(input_x[6], 1);
        idvd_poly_feat[5367] = pow(input_x[1], 3) * pow(input_x[3], 1) * pow(input_x[4], 2) * pow(input_x[5], 2);
        idvd_poly_feat[5368] = pow(input_x[1], 3) * pow(input_x[3], 1) * pow(input_x[4], 2) * pow(input_x[5], 1) * pow(input_x[6], 1);
        idvd_poly_feat[5369] = pow(input_x[1], 3) * pow(input_x[3], 1) * pow(input_x[4], 2) * pow(input_x[6], 2);
        idvd_poly_feat[5370] = pow(input_x[1], 3) * pow(input_x[3], 1) * pow(input_x[4], 1) * pow(input_x[5], 3);
        idvd_poly_feat[5371] = pow(input_x[1], 3) * pow(input_x[3], 1) * pow(input_x[4], 1) * pow(input_x[5], 2) * pow(input_x[6], 1);
        idvd_poly_feat[5372] = pow(input_x[1], 3) * pow(input_x[3], 1) * pow(input_x[4], 1) * pow(input_x[5], 1) * pow(input_x[6], 2);
        idvd_poly_feat[5373] = pow(input_x[1], 3) * pow(input_x[3], 1) * pow(input_x[4], 1) * pow(input_x[6], 3);
        idvd_poly_feat[5374] = pow(input_x[1], 3) * pow(input_x[3], 1) * pow(input_x[5], 4);
        idvd_poly_feat[5375] = pow(input_x[1], 3) * pow(input_x[3], 1) * pow(input_x[5], 3) * pow(input_x[6], 1);
        idvd_poly_feat[5376] = pow(input_x[1], 3) * pow(input_x[3], 1) * pow(input_x[5], 2) * pow(input_x[6], 2);
        idvd_poly_feat[5377] = pow(input_x[1], 3) * pow(input_x[3], 1) * pow(input_x[5], 1) * pow(input_x[6], 3);
        idvd_poly_feat[5378] = pow(input_x[1], 3) * pow(input_x[3], 1) * pow(input_x[6], 4);
        idvd_poly_feat[5379] = pow(input_x[1], 3) * pow(input_x[4], 5);
        idvd_poly_feat[5380] = pow(input_x[1], 3) * pow(input_x[4], 4) * pow(input_x[5], 1);
        idvd_poly_feat[5381] = pow(input_x[1], 3) * pow(input_x[4], 4) * pow(input_x[6], 1);
        idvd_poly_feat[5382] = pow(input_x[1], 3) * pow(input_x[4], 3) * pow(input_x[5], 2);
        idvd_poly_feat[5383] = pow(input_x[1], 3) * pow(input_x[4], 3) * pow(input_x[5], 1) * pow(input_x[6], 1);
        idvd_poly_feat[5384] = pow(input_x[1], 3) * pow(input_x[4], 3) * pow(input_x[6], 2);
        idvd_poly_feat[5385] = pow(input_x[1], 3) * pow(input_x[4], 2) * pow(input_x[5], 3);
        idvd_poly_feat[5386] = pow(input_x[1], 3) * pow(input_x[4], 2) * pow(input_x[5], 2) * pow(input_x[6], 1);
        idvd_poly_feat[5387] = pow(input_x[1], 3) * pow(input_x[4], 2) * pow(input_x[5], 1) * pow(input_x[6], 2);
        idvd_poly_feat[5388] = pow(input_x[1], 3) * pow(input_x[4], 2) * pow(input_x[6], 3);
        idvd_poly_feat[5389] = pow(input_x[1], 3) * pow(input_x[4], 1) * pow(input_x[5], 4);
        idvd_poly_feat[5390] = pow(input_x[1], 3) * pow(input_x[4], 1) * pow(input_x[5], 3) * pow(input_x[6], 1);
        idvd_poly_feat[5391] = pow(input_x[1], 3) * pow(input_x[4], 1) * pow(input_x[5], 2) * pow(input_x[6], 2);
        idvd_poly_feat[5392] = pow(input_x[1], 3) * pow(input_x[4], 1) * pow(input_x[5], 1) * pow(input_x[6], 3);
        idvd_poly_feat[5393] = pow(input_x[1], 3) * pow(input_x[4], 1) * pow(input_x[6], 4);
        idvd_poly_feat[5394] = pow(input_x[1], 3) * pow(input_x[5], 5);
        idvd_poly_feat[5395] = pow(input_x[1], 3) * pow(input_x[5], 4) * pow(input_x[6], 1);
        idvd_poly_feat[5396] = pow(input_x[1], 3) * pow(input_x[5], 3) * pow(input_x[6], 2);
        idvd_poly_feat[5397] = pow(input_x[1], 3) * pow(input_x[5], 2) * pow(input_x[6], 3);
        idvd_poly_feat[5398] = pow(input_x[1], 3) * pow(input_x[5], 1) * pow(input_x[6], 4);
        idvd_poly_feat[5399] = pow(input_x[1], 3) * pow(input_x[6], 5);
        idvd_poly_feat[5400] = pow(input_x[1], 2) * pow(input_x[2], 6);
        idvd_poly_feat[5401] = pow(input_x[1], 2) * pow(input_x[2], 5) * pow(input_x[3], 1);
        idvd_poly_feat[5402] = pow(input_x[1], 2) * pow(input_x[2], 5) * pow(input_x[4], 1);
        idvd_poly_feat[5403] = pow(input_x[1], 2) * pow(input_x[2], 5) * pow(input_x[5], 1);
        idvd_poly_feat[5404] = pow(input_x[1], 2) * pow(input_x[2], 5) * pow(input_x[6], 1);
        idvd_poly_feat[5405] = pow(input_x[1], 2) * pow(input_x[2], 4) * pow(input_x[3], 2);
        idvd_poly_feat[5406] = pow(input_x[1], 2) * pow(input_x[2], 4) * pow(input_x[3], 1) * pow(input_x[4], 1);
        idvd_poly_feat[5407] = pow(input_x[1], 2) * pow(input_x[2], 4) * pow(input_x[3], 1) * pow(input_x[5], 1);
        idvd_poly_feat[5408] = pow(input_x[1], 2) * pow(input_x[2], 4) * pow(input_x[3], 1) * pow(input_x[6], 1);
        idvd_poly_feat[5409] = pow(input_x[1], 2) * pow(input_x[2], 4) * pow(input_x[4], 2);
        idvd_poly_feat[5410] = pow(input_x[1], 2) * pow(input_x[2], 4) * pow(input_x[4], 1) * pow(input_x[5], 1);
        idvd_poly_feat[5411] = pow(input_x[1], 2) * pow(input_x[2], 4) * pow(input_x[4], 1) * pow(input_x[6], 1);
        idvd_poly_feat[5412] = pow(input_x[1], 2) * pow(input_x[2], 4) * pow(input_x[5], 2);
        idvd_poly_feat[5413] = pow(input_x[1], 2) * pow(input_x[2], 4) * pow(input_x[5], 1) * pow(input_x[6], 1);
        idvd_poly_feat[5414] = pow(input_x[1], 2) * pow(input_x[2], 4) * pow(input_x[6], 2);
        idvd_poly_feat[5415] = pow(input_x[1], 2) * pow(input_x[2], 3) * pow(input_x[3], 3);
        idvd_poly_feat[5416] = pow(input_x[1], 2) * pow(input_x[2], 3) * pow(input_x[3], 2) * pow(input_x[4], 1);
        idvd_poly_feat[5417] = pow(input_x[1], 2) * pow(input_x[2], 3) * pow(input_x[3], 2) * pow(input_x[5], 1);
        idvd_poly_feat[5418] = pow(input_x[1], 2) * pow(input_x[2], 3) * pow(input_x[3], 2) * pow(input_x[6], 1);
        idvd_poly_feat[5419] = pow(input_x[1], 2) * pow(input_x[2], 3) * pow(input_x[3], 1) * pow(input_x[4], 2);
        idvd_poly_feat[5420] = pow(input_x[1], 2) * pow(input_x[2], 3) * pow(input_x[3], 1) * pow(input_x[4], 1) * pow(input_x[5], 1);
        idvd_poly_feat[5421] = pow(input_x[1], 2) * pow(input_x[2], 3) * pow(input_x[3], 1) * pow(input_x[4], 1) * pow(input_x[6], 1);
        idvd_poly_feat[5422] = pow(input_x[1], 2) * pow(input_x[2], 3) * pow(input_x[3], 1) * pow(input_x[5], 2);
        idvd_poly_feat[5423] = pow(input_x[1], 2) * pow(input_x[2], 3) * pow(input_x[3], 1) * pow(input_x[5], 1) * pow(input_x[6], 1);
        idvd_poly_feat[5424] = pow(input_x[1], 2) * pow(input_x[2], 3) * pow(input_x[3], 1) * pow(input_x[6], 2);
        idvd_poly_feat[5425] = pow(input_x[1], 2) * pow(input_x[2], 3) * pow(input_x[4], 3);
        idvd_poly_feat[5426] = pow(input_x[1], 2) * pow(input_x[2], 3) * pow(input_x[4], 2) * pow(input_x[5], 1);
        idvd_poly_feat[5427] = pow(input_x[1], 2) * pow(input_x[2], 3) * pow(input_x[4], 2) * pow(input_x[6], 1);
        idvd_poly_feat[5428] = pow(input_x[1], 2) * pow(input_x[2], 3) * pow(input_x[4], 1) * pow(input_x[5], 2);
        idvd_poly_feat[5429] = pow(input_x[1], 2) * pow(input_x[2], 3) * pow(input_x[4], 1) * pow(input_x[5], 1) * pow(input_x[6], 1);
        idvd_poly_feat[5430] = pow(input_x[1], 2) * pow(input_x[2], 3) * pow(input_x[4], 1) * pow(input_x[6], 2);
        idvd_poly_feat[5431] = pow(input_x[1], 2) * pow(input_x[2], 3) * pow(input_x[5], 3);
        idvd_poly_feat[5432] = pow(input_x[1], 2) * pow(input_x[2], 3) * pow(input_x[5], 2) * pow(input_x[6], 1);
        idvd_poly_feat[5433] = pow(input_x[1], 2) * pow(input_x[2], 3) * pow(input_x[5], 1) * pow(input_x[6], 2);
        idvd_poly_feat[5434] = pow(input_x[1], 2) * pow(input_x[2], 3) * pow(input_x[6], 3);
        idvd_poly_feat[5435] = pow(input_x[1], 2) * pow(input_x[2], 2) * pow(input_x[3], 4);
        idvd_poly_feat[5436] = pow(input_x[1], 2) * pow(input_x[2], 2) * pow(input_x[3], 3) * pow(input_x[4], 1);
        idvd_poly_feat[5437] = pow(input_x[1], 2) * pow(input_x[2], 2) * pow(input_x[3], 3) * pow(input_x[5], 1);
        idvd_poly_feat[5438] = pow(input_x[1], 2) * pow(input_x[2], 2) * pow(input_x[3], 3) * pow(input_x[6], 1);
        idvd_poly_feat[5439] = pow(input_x[1], 2) * pow(input_x[2], 2) * pow(input_x[3], 2) * pow(input_x[4], 2);
        idvd_poly_feat[5440] = pow(input_x[1], 2) * pow(input_x[2], 2) * pow(input_x[3], 2) * pow(input_x[4], 1) * pow(input_x[5], 1);
        idvd_poly_feat[5441] = pow(input_x[1], 2) * pow(input_x[2], 2) * pow(input_x[3], 2) * pow(input_x[4], 1) * pow(input_x[6], 1);
        idvd_poly_feat[5442] = pow(input_x[1], 2) * pow(input_x[2], 2) * pow(input_x[3], 2) * pow(input_x[5], 2);
        idvd_poly_feat[5443] = pow(input_x[1], 2) * pow(input_x[2], 2) * pow(input_x[3], 2) * pow(input_x[5], 1) * pow(input_x[6], 1);
        idvd_poly_feat[5444] = pow(input_x[1], 2) * pow(input_x[2], 2) * pow(input_x[3], 2) * pow(input_x[6], 2);
        idvd_poly_feat[5445] = pow(input_x[1], 2) * pow(input_x[2], 2) * pow(input_x[3], 1) * pow(input_x[4], 3);
        idvd_poly_feat[5446] = pow(input_x[1], 2) * pow(input_x[2], 2) * pow(input_x[3], 1) * pow(input_x[4], 2) * pow(input_x[5], 1);
        idvd_poly_feat[5447] = pow(input_x[1], 2) * pow(input_x[2], 2) * pow(input_x[3], 1) * pow(input_x[4], 2) * pow(input_x[6], 1);
        idvd_poly_feat[5448] = pow(input_x[1], 2) * pow(input_x[2], 2) * pow(input_x[3], 1) * pow(input_x[4], 1) * pow(input_x[5], 2);
        idvd_poly_feat[5449] = pow(input_x[1], 2) * pow(input_x[2], 2) * pow(input_x[3], 1) * pow(input_x[4], 1) * pow(input_x[5], 1) * pow(input_x[6], 1);
        idvd_poly_feat[5450] = pow(input_x[1], 2) * pow(input_x[2], 2) * pow(input_x[3], 1) * pow(input_x[4], 1) * pow(input_x[6], 2);
        idvd_poly_feat[5451] = pow(input_x[1], 2) * pow(input_x[2], 2) * pow(input_x[3], 1) * pow(input_x[5], 3);
        idvd_poly_feat[5452] = pow(input_x[1], 2) * pow(input_x[2], 2) * pow(input_x[3], 1) * pow(input_x[5], 2) * pow(input_x[6], 1);
        idvd_poly_feat[5453] = pow(input_x[1], 2) * pow(input_x[2], 2) * pow(input_x[3], 1) * pow(input_x[5], 1) * pow(input_x[6], 2);
        idvd_poly_feat[5454] = pow(input_x[1], 2) * pow(input_x[2], 2) * pow(input_x[3], 1) * pow(input_x[6], 3);
        idvd_poly_feat[5455] = pow(input_x[1], 2) * pow(input_x[2], 2) * pow(input_x[4], 4);
        idvd_poly_feat[5456] = pow(input_x[1], 2) * pow(input_x[2], 2) * pow(input_x[4], 3) * pow(input_x[5], 1);
        idvd_poly_feat[5457] = pow(input_x[1], 2) * pow(input_x[2], 2) * pow(input_x[4], 3) * pow(input_x[6], 1);
        idvd_poly_feat[5458] = pow(input_x[1], 2) * pow(input_x[2], 2) * pow(input_x[4], 2) * pow(input_x[5], 2);
        idvd_poly_feat[5459] = pow(input_x[1], 2) * pow(input_x[2], 2) * pow(input_x[4], 2) * pow(input_x[5], 1) * pow(input_x[6], 1);
        idvd_poly_feat[5460] = pow(input_x[1], 2) * pow(input_x[2], 2) * pow(input_x[4], 2) * pow(input_x[6], 2);
        idvd_poly_feat[5461] = pow(input_x[1], 2) * pow(input_x[2], 2) * pow(input_x[4], 1) * pow(input_x[5], 3);
        idvd_poly_feat[5462] = pow(input_x[1], 2) * pow(input_x[2], 2) * pow(input_x[4], 1) * pow(input_x[5], 2) * pow(input_x[6], 1);
        idvd_poly_feat[5463] = pow(input_x[1], 2) * pow(input_x[2], 2) * pow(input_x[4], 1) * pow(input_x[5], 1) * pow(input_x[6], 2);
        idvd_poly_feat[5464] = pow(input_x[1], 2) * pow(input_x[2], 2) * pow(input_x[4], 1) * pow(input_x[6], 3);
        idvd_poly_feat[5465] = pow(input_x[1], 2) * pow(input_x[2], 2) * pow(input_x[5], 4);
        idvd_poly_feat[5466] = pow(input_x[1], 2) * pow(input_x[2], 2) * pow(input_x[5], 3) * pow(input_x[6], 1);
        idvd_poly_feat[5467] = pow(input_x[1], 2) * pow(input_x[2], 2) * pow(input_x[5], 2) * pow(input_x[6], 2);
        idvd_poly_feat[5468] = pow(input_x[1], 2) * pow(input_x[2], 2) * pow(input_x[5], 1) * pow(input_x[6], 3);
        idvd_poly_feat[5469] = pow(input_x[1], 2) * pow(input_x[2], 2) * pow(input_x[6], 4);
        idvd_poly_feat[5470] = pow(input_x[1], 2) * pow(input_x[2], 1) * pow(input_x[3], 5);
        idvd_poly_feat[5471] = pow(input_x[1], 2) * pow(input_x[2], 1) * pow(input_x[3], 4) * pow(input_x[4], 1);
        idvd_poly_feat[5472] = pow(input_x[1], 2) * pow(input_x[2], 1) * pow(input_x[3], 4) * pow(input_x[5], 1);
        idvd_poly_feat[5473] = pow(input_x[1], 2) * pow(input_x[2], 1) * pow(input_x[3], 4) * pow(input_x[6], 1);
        idvd_poly_feat[5474] = pow(input_x[1], 2) * pow(input_x[2], 1) * pow(input_x[3], 3) * pow(input_x[4], 2);
        idvd_poly_feat[5475] = pow(input_x[1], 2) * pow(input_x[2], 1) * pow(input_x[3], 3) * pow(input_x[4], 1) * pow(input_x[5], 1);
        idvd_poly_feat[5476] = pow(input_x[1], 2) * pow(input_x[2], 1) * pow(input_x[3], 3) * pow(input_x[4], 1) * pow(input_x[6], 1);
        idvd_poly_feat[5477] = pow(input_x[1], 2) * pow(input_x[2], 1) * pow(input_x[3], 3) * pow(input_x[5], 2);
        idvd_poly_feat[5478] = pow(input_x[1], 2) * pow(input_x[2], 1) * pow(input_x[3], 3) * pow(input_x[5], 1) * pow(input_x[6], 1);
        idvd_poly_feat[5479] = pow(input_x[1], 2) * pow(input_x[2], 1) * pow(input_x[3], 3) * pow(input_x[6], 2);
        idvd_poly_feat[5480] = pow(input_x[1], 2) * pow(input_x[2], 1) * pow(input_x[3], 2) * pow(input_x[4], 3);
        idvd_poly_feat[5481] = pow(input_x[1], 2) * pow(input_x[2], 1) * pow(input_x[3], 2) * pow(input_x[4], 2) * pow(input_x[5], 1);
        idvd_poly_feat[5482] = pow(input_x[1], 2) * pow(input_x[2], 1) * pow(input_x[3], 2) * pow(input_x[4], 2) * pow(input_x[6], 1);
        idvd_poly_feat[5483] = pow(input_x[1], 2) * pow(input_x[2], 1) * pow(input_x[3], 2) * pow(input_x[4], 1) * pow(input_x[5], 2);
        idvd_poly_feat[5484] = pow(input_x[1], 2) * pow(input_x[2], 1) * pow(input_x[3], 2) * pow(input_x[4], 1) * pow(input_x[5], 1) * pow(input_x[6], 1);
        idvd_poly_feat[5485] = pow(input_x[1], 2) * pow(input_x[2], 1) * pow(input_x[3], 2) * pow(input_x[4], 1) * pow(input_x[6], 2);
        idvd_poly_feat[5486] = pow(input_x[1], 2) * pow(input_x[2], 1) * pow(input_x[3], 2) * pow(input_x[5], 3);
        idvd_poly_feat[5487] = pow(input_x[1], 2) * pow(input_x[2], 1) * pow(input_x[3], 2) * pow(input_x[5], 2) * pow(input_x[6], 1);
        idvd_poly_feat[5488] = pow(input_x[1], 2) * pow(input_x[2], 1) * pow(input_x[3], 2) * pow(input_x[5], 1) * pow(input_x[6], 2);
        idvd_poly_feat[5489] = pow(input_x[1], 2) * pow(input_x[2], 1) * pow(input_x[3], 2) * pow(input_x[6], 3);
        idvd_poly_feat[5490] = pow(input_x[1], 2) * pow(input_x[2], 1) * pow(input_x[3], 1) * pow(input_x[4], 4);
        idvd_poly_feat[5491] = pow(input_x[1], 2) * pow(input_x[2], 1) * pow(input_x[3], 1) * pow(input_x[4], 3) * pow(input_x[5], 1);
        idvd_poly_feat[5492] = pow(input_x[1], 2) * pow(input_x[2], 1) * pow(input_x[3], 1) * pow(input_x[4], 3) * pow(input_x[6], 1);
        idvd_poly_feat[5493] = pow(input_x[1], 2) * pow(input_x[2], 1) * pow(input_x[3], 1) * pow(input_x[4], 2) * pow(input_x[5], 2);
        idvd_poly_feat[5494] = pow(input_x[1], 2) * pow(input_x[2], 1) * pow(input_x[3], 1) * pow(input_x[4], 2) * pow(input_x[5], 1) * pow(input_x[6], 1);
        idvd_poly_feat[5495] = pow(input_x[1], 2) * pow(input_x[2], 1) * pow(input_x[3], 1) * pow(input_x[4], 2) * pow(input_x[6], 2);
        idvd_poly_feat[5496] = pow(input_x[1], 2) * pow(input_x[2], 1) * pow(input_x[3], 1) * pow(input_x[4], 1) * pow(input_x[5], 3);
        idvd_poly_feat[5497] = pow(input_x[1], 2) * pow(input_x[2], 1) * pow(input_x[3], 1) * pow(input_x[4], 1) * pow(input_x[5], 2) * pow(input_x[6], 1);
        idvd_poly_feat[5498] = pow(input_x[1], 2) * pow(input_x[2], 1) * pow(input_x[3], 1) * pow(input_x[4], 1) * pow(input_x[5], 1) * pow(input_x[6], 2);
        idvd_poly_feat[5499] = pow(input_x[1], 2) * pow(input_x[2], 1) * pow(input_x[3], 1) * pow(input_x[4], 1) * pow(input_x[6], 3);
        idvd_poly_feat[5500] = pow(input_x[1], 2) * pow(input_x[2], 1) * pow(input_x[3], 1) * pow(input_x[5], 4);
        idvd_poly_feat[5501] = pow(input_x[1], 2) * pow(input_x[2], 1) * pow(input_x[3], 1) * pow(input_x[5], 3) * pow(input_x[6], 1);
        idvd_poly_feat[5502] = pow(input_x[1], 2) * pow(input_x[2], 1) * pow(input_x[3], 1) * pow(input_x[5], 2) * pow(input_x[6], 2);
        idvd_poly_feat[5503] = pow(input_x[1], 2) * pow(input_x[2], 1) * pow(input_x[3], 1) * pow(input_x[5], 1) * pow(input_x[6], 3);
        idvd_poly_feat[5504] = pow(input_x[1], 2) * pow(input_x[2], 1) * pow(input_x[3], 1) * pow(input_x[6], 4);
        idvd_poly_feat[5505] = pow(input_x[1], 2) * pow(input_x[2], 1) * pow(input_x[4], 5);
        idvd_poly_feat[5506] = pow(input_x[1], 2) * pow(input_x[2], 1) * pow(input_x[4], 4) * pow(input_x[5], 1);
        idvd_poly_feat[5507] = pow(input_x[1], 2) * pow(input_x[2], 1) * pow(input_x[4], 4) * pow(input_x[6], 1);
        idvd_poly_feat[5508] = pow(input_x[1], 2) * pow(input_x[2], 1) * pow(input_x[4], 3) * pow(input_x[5], 2);
        idvd_poly_feat[5509] = pow(input_x[1], 2) * pow(input_x[2], 1) * pow(input_x[4], 3) * pow(input_x[5], 1) * pow(input_x[6], 1);
        idvd_poly_feat[5510] = pow(input_x[1], 2) * pow(input_x[2], 1) * pow(input_x[4], 3) * pow(input_x[6], 2);
        idvd_poly_feat[5511] = pow(input_x[1], 2) * pow(input_x[2], 1) * pow(input_x[4], 2) * pow(input_x[5], 3);
        idvd_poly_feat[5512] = pow(input_x[1], 2) * pow(input_x[2], 1) * pow(input_x[4], 2) * pow(input_x[5], 2) * pow(input_x[6], 1);
        idvd_poly_feat[5513] = pow(input_x[1], 2) * pow(input_x[2], 1) * pow(input_x[4], 2) * pow(input_x[5], 1) * pow(input_x[6], 2);
        idvd_poly_feat[5514] = pow(input_x[1], 2) * pow(input_x[2], 1) * pow(input_x[4], 2) * pow(input_x[6], 3);
        idvd_poly_feat[5515] = pow(input_x[1], 2) * pow(input_x[2], 1) * pow(input_x[4], 1) * pow(input_x[5], 4);
        idvd_poly_feat[5516] = pow(input_x[1], 2) * pow(input_x[2], 1) * pow(input_x[4], 1) * pow(input_x[5], 3) * pow(input_x[6], 1);
        idvd_poly_feat[5517] = pow(input_x[1], 2) * pow(input_x[2], 1) * pow(input_x[4], 1) * pow(input_x[5], 2) * pow(input_x[6], 2);
        idvd_poly_feat[5518] = pow(input_x[1], 2) * pow(input_x[2], 1) * pow(input_x[4], 1) * pow(input_x[5], 1) * pow(input_x[6], 3);
        idvd_poly_feat[5519] = pow(input_x[1], 2) * pow(input_x[2], 1) * pow(input_x[4], 1) * pow(input_x[6], 4);
        idvd_poly_feat[5520] = pow(input_x[1], 2) * pow(input_x[2], 1) * pow(input_x[5], 5);
        idvd_poly_feat[5521] = pow(input_x[1], 2) * pow(input_x[2], 1) * pow(input_x[5], 4) * pow(input_x[6], 1);
        idvd_poly_feat[5522] = pow(input_x[1], 2) * pow(input_x[2], 1) * pow(input_x[5], 3) * pow(input_x[6], 2);
        idvd_poly_feat[5523] = pow(input_x[1], 2) * pow(input_x[2], 1) * pow(input_x[5], 2) * pow(input_x[6], 3);
        idvd_poly_feat[5524] = pow(input_x[1], 2) * pow(input_x[2], 1) * pow(input_x[5], 1) * pow(input_x[6], 4);
        idvd_poly_feat[5525] = pow(input_x[1], 2) * pow(input_x[2], 1) * pow(input_x[6], 5);
        idvd_poly_feat[5526] = pow(input_x[1], 2) * pow(input_x[3], 6);
        idvd_poly_feat[5527] = pow(input_x[1], 2) * pow(input_x[3], 5) * pow(input_x[4], 1);
        idvd_poly_feat[5528] = pow(input_x[1], 2) * pow(input_x[3], 5) * pow(input_x[5], 1);
        idvd_poly_feat[5529] = pow(input_x[1], 2) * pow(input_x[3], 5) * pow(input_x[6], 1);
        idvd_poly_feat[5530] = pow(input_x[1], 2) * pow(input_x[3], 4) * pow(input_x[4], 2);
        idvd_poly_feat[5531] = pow(input_x[1], 2) * pow(input_x[3], 4) * pow(input_x[4], 1) * pow(input_x[5], 1);
        idvd_poly_feat[5532] = pow(input_x[1], 2) * pow(input_x[3], 4) * pow(input_x[4], 1) * pow(input_x[6], 1);
        idvd_poly_feat[5533] = pow(input_x[1], 2) * pow(input_x[3], 4) * pow(input_x[5], 2);
        idvd_poly_feat[5534] = pow(input_x[1], 2) * pow(input_x[3], 4) * pow(input_x[5], 1) * pow(input_x[6], 1);
        idvd_poly_feat[5535] = pow(input_x[1], 2) * pow(input_x[3], 4) * pow(input_x[6], 2);
        idvd_poly_feat[5536] = pow(input_x[1], 2) * pow(input_x[3], 3) * pow(input_x[4], 3);
        idvd_poly_feat[5537] = pow(input_x[1], 2) * pow(input_x[3], 3) * pow(input_x[4], 2) * pow(input_x[5], 1);
        idvd_poly_feat[5538] = pow(input_x[1], 2) * pow(input_x[3], 3) * pow(input_x[4], 2) * pow(input_x[6], 1);
        idvd_poly_feat[5539] = pow(input_x[1], 2) * pow(input_x[3], 3) * pow(input_x[4], 1) * pow(input_x[5], 2);
        idvd_poly_feat[5540] = pow(input_x[1], 2) * pow(input_x[3], 3) * pow(input_x[4], 1) * pow(input_x[5], 1) * pow(input_x[6], 1);
        idvd_poly_feat[5541] = pow(input_x[1], 2) * pow(input_x[3], 3) * pow(input_x[4], 1) * pow(input_x[6], 2);
        idvd_poly_feat[5542] = pow(input_x[1], 2) * pow(input_x[3], 3) * pow(input_x[5], 3);
        idvd_poly_feat[5543] = pow(input_x[1], 2) * pow(input_x[3], 3) * pow(input_x[5], 2) * pow(input_x[6], 1);
        idvd_poly_feat[5544] = pow(input_x[1], 2) * pow(input_x[3], 3) * pow(input_x[5], 1) * pow(input_x[6], 2);
        idvd_poly_feat[5545] = pow(input_x[1], 2) * pow(input_x[3], 3) * pow(input_x[6], 3);
        idvd_poly_feat[5546] = pow(input_x[1], 2) * pow(input_x[3], 2) * pow(input_x[4], 4);
        idvd_poly_feat[5547] = pow(input_x[1], 2) * pow(input_x[3], 2) * pow(input_x[4], 3) * pow(input_x[5], 1);
        idvd_poly_feat[5548] = pow(input_x[1], 2) * pow(input_x[3], 2) * pow(input_x[4], 3) * pow(input_x[6], 1);
        idvd_poly_feat[5549] = pow(input_x[1], 2) * pow(input_x[3], 2) * pow(input_x[4], 2) * pow(input_x[5], 2);
        idvd_poly_feat[5550] = pow(input_x[1], 2) * pow(input_x[3], 2) * pow(input_x[4], 2) * pow(input_x[5], 1) * pow(input_x[6], 1);
        idvd_poly_feat[5551] = pow(input_x[1], 2) * pow(input_x[3], 2) * pow(input_x[4], 2) * pow(input_x[6], 2);
        idvd_poly_feat[5552] = pow(input_x[1], 2) * pow(input_x[3], 2) * pow(input_x[4], 1) * pow(input_x[5], 3);
        idvd_poly_feat[5553] = pow(input_x[1], 2) * pow(input_x[3], 2) * pow(input_x[4], 1) * pow(input_x[5], 2) * pow(input_x[6], 1);
        idvd_poly_feat[5554] = pow(input_x[1], 2) * pow(input_x[3], 2) * pow(input_x[4], 1) * pow(input_x[5], 1) * pow(input_x[6], 2);
        idvd_poly_feat[5555] = pow(input_x[1], 2) * pow(input_x[3], 2) * pow(input_x[4], 1) * pow(input_x[6], 3);
        idvd_poly_feat[5556] = pow(input_x[1], 2) * pow(input_x[3], 2) * pow(input_x[5], 4);
        idvd_poly_feat[5557] = pow(input_x[1], 2) * pow(input_x[3], 2) * pow(input_x[5], 3) * pow(input_x[6], 1);
        idvd_poly_feat[5558] = pow(input_x[1], 2) * pow(input_x[3], 2) * pow(input_x[5], 2) * pow(input_x[6], 2);
        idvd_poly_feat[5559] = pow(input_x[1], 2) * pow(input_x[3], 2) * pow(input_x[5], 1) * pow(input_x[6], 3);
        idvd_poly_feat[5560] = pow(input_x[1], 2) * pow(input_x[3], 2) * pow(input_x[6], 4);
        idvd_poly_feat[5561] = pow(input_x[1], 2) * pow(input_x[3], 1) * pow(input_x[4], 5);
        idvd_poly_feat[5562] = pow(input_x[1], 2) * pow(input_x[3], 1) * pow(input_x[4], 4) * pow(input_x[5], 1);
        idvd_poly_feat[5563] = pow(input_x[1], 2) * pow(input_x[3], 1) * pow(input_x[4], 4) * pow(input_x[6], 1);
        idvd_poly_feat[5564] = pow(input_x[1], 2) * pow(input_x[3], 1) * pow(input_x[4], 3) * pow(input_x[5], 2);
        idvd_poly_feat[5565] = pow(input_x[1], 2) * pow(input_x[3], 1) * pow(input_x[4], 3) * pow(input_x[5], 1) * pow(input_x[6], 1);
        idvd_poly_feat[5566] = pow(input_x[1], 2) * pow(input_x[3], 1) * pow(input_x[4], 3) * pow(input_x[6], 2);
        idvd_poly_feat[5567] = pow(input_x[1], 2) * pow(input_x[3], 1) * pow(input_x[4], 2) * pow(input_x[5], 3);
        idvd_poly_feat[5568] = pow(input_x[1], 2) * pow(input_x[3], 1) * pow(input_x[4], 2) * pow(input_x[5], 2) * pow(input_x[6], 1);
        idvd_poly_feat[5569] = pow(input_x[1], 2) * pow(input_x[3], 1) * pow(input_x[4], 2) * pow(input_x[5], 1) * pow(input_x[6], 2);
        idvd_poly_feat[5570] = pow(input_x[1], 2) * pow(input_x[3], 1) * pow(input_x[4], 2) * pow(input_x[6], 3);
        idvd_poly_feat[5571] = pow(input_x[1], 2) * pow(input_x[3], 1) * pow(input_x[4], 1) * pow(input_x[5], 4);
        idvd_poly_feat[5572] = pow(input_x[1], 2) * pow(input_x[3], 1) * pow(input_x[4], 1) * pow(input_x[5], 3) * pow(input_x[6], 1);
        idvd_poly_feat[5573] = pow(input_x[1], 2) * pow(input_x[3], 1) * pow(input_x[4], 1) * pow(input_x[5], 2) * pow(input_x[6], 2);
        idvd_poly_feat[5574] = pow(input_x[1], 2) * pow(input_x[3], 1) * pow(input_x[4], 1) * pow(input_x[5], 1) * pow(input_x[6], 3);
        idvd_poly_feat[5575] = pow(input_x[1], 2) * pow(input_x[3], 1) * pow(input_x[4], 1) * pow(input_x[6], 4);
        idvd_poly_feat[5576] = pow(input_x[1], 2) * pow(input_x[3], 1) * pow(input_x[5], 5);
        idvd_poly_feat[5577] = pow(input_x[1], 2) * pow(input_x[3], 1) * pow(input_x[5], 4) * pow(input_x[6], 1);
        idvd_poly_feat[5578] = pow(input_x[1], 2) * pow(input_x[3], 1) * pow(input_x[5], 3) * pow(input_x[6], 2);
        idvd_poly_feat[5579] = pow(input_x[1], 2) * pow(input_x[3], 1) * pow(input_x[5], 2) * pow(input_x[6], 3);
        idvd_poly_feat[5580] = pow(input_x[1], 2) * pow(input_x[3], 1) * pow(input_x[5], 1) * pow(input_x[6], 4);
        idvd_poly_feat[5581] = pow(input_x[1], 2) * pow(input_x[3], 1) * pow(input_x[6], 5);
        idvd_poly_feat[5582] = pow(input_x[1], 2) * pow(input_x[4], 6);
        idvd_poly_feat[5583] = pow(input_x[1], 2) * pow(input_x[4], 5) * pow(input_x[5], 1);
        idvd_poly_feat[5584] = pow(input_x[1], 2) * pow(input_x[4], 5) * pow(input_x[6], 1);
        idvd_poly_feat[5585] = pow(input_x[1], 2) * pow(input_x[4], 4) * pow(input_x[5], 2);
        idvd_poly_feat[5586] = pow(input_x[1], 2) * pow(input_x[4], 4) * pow(input_x[5], 1) * pow(input_x[6], 1);
        idvd_poly_feat[5587] = pow(input_x[1], 2) * pow(input_x[4], 4) * pow(input_x[6], 2);
        idvd_poly_feat[5588] = pow(input_x[1], 2) * pow(input_x[4], 3) * pow(input_x[5], 3);
        idvd_poly_feat[5589] = pow(input_x[1], 2) * pow(input_x[4], 3) * pow(input_x[5], 2) * pow(input_x[6], 1);
        idvd_poly_feat[5590] = pow(input_x[1], 2) * pow(input_x[4], 3) * pow(input_x[5], 1) * pow(input_x[6], 2);
        idvd_poly_feat[5591] = pow(input_x[1], 2) * pow(input_x[4], 3) * pow(input_x[6], 3);
        idvd_poly_feat[5592] = pow(input_x[1], 2) * pow(input_x[4], 2) * pow(input_x[5], 4);
        idvd_poly_feat[5593] = pow(input_x[1], 2) * pow(input_x[4], 2) * pow(input_x[5], 3) * pow(input_x[6], 1);
        idvd_poly_feat[5594] = pow(input_x[1], 2) * pow(input_x[4], 2) * pow(input_x[5], 2) * pow(input_x[6], 2);
        idvd_poly_feat[5595] = pow(input_x[1], 2) * pow(input_x[4], 2) * pow(input_x[5], 1) * pow(input_x[6], 3);
        idvd_poly_feat[5596] = pow(input_x[1], 2) * pow(input_x[4], 2) * pow(input_x[6], 4);
        idvd_poly_feat[5597] = pow(input_x[1], 2) * pow(input_x[4], 1) * pow(input_x[5], 5);
        idvd_poly_feat[5598] = pow(input_x[1], 2) * pow(input_x[4], 1) * pow(input_x[5], 4) * pow(input_x[6], 1);
        idvd_poly_feat[5599] = pow(input_x[1], 2) * pow(input_x[4], 1) * pow(input_x[5], 3) * pow(input_x[6], 2);
        idvd_poly_feat[5600] = pow(input_x[1], 2) * pow(input_x[4], 1) * pow(input_x[5], 2) * pow(input_x[6], 3);
        idvd_poly_feat[5601] = pow(input_x[1], 2) * pow(input_x[4], 1) * pow(input_x[5], 1) * pow(input_x[6], 4);
        idvd_poly_feat[5602] = pow(input_x[1], 2) * pow(input_x[4], 1) * pow(input_x[6], 5);
        idvd_poly_feat[5603] = pow(input_x[1], 2) * pow(input_x[5], 6);
        idvd_poly_feat[5604] = pow(input_x[1], 2) * pow(input_x[5], 5) * pow(input_x[6], 1);
        idvd_poly_feat[5605] = pow(input_x[1], 2) * pow(input_x[5], 4) * pow(input_x[6], 2);
        idvd_poly_feat[5606] = pow(input_x[1], 2) * pow(input_x[5], 3) * pow(input_x[6], 3);
        idvd_poly_feat[5607] = pow(input_x[1], 2) * pow(input_x[5], 2) * pow(input_x[6], 4);
        idvd_poly_feat[5608] = pow(input_x[1], 2) * pow(input_x[5], 1) * pow(input_x[6], 5);
        idvd_poly_feat[5609] = pow(input_x[1], 2) * pow(input_x[6], 6);
        idvd_poly_feat[5610] = pow(input_x[1], 1) * pow(input_x[2], 7);
        idvd_poly_feat[5611] = pow(input_x[1], 1) * pow(input_x[2], 6) * pow(input_x[3], 1);
        idvd_poly_feat[5612] = pow(input_x[1], 1) * pow(input_x[2], 6) * pow(input_x[4], 1);
        idvd_poly_feat[5613] = pow(input_x[1], 1) * pow(input_x[2], 6) * pow(input_x[5], 1);
        idvd_poly_feat[5614] = pow(input_x[1], 1) * pow(input_x[2], 6) * pow(input_x[6], 1);
        idvd_poly_feat[5615] = pow(input_x[1], 1) * pow(input_x[2], 5) * pow(input_x[3], 2);
        idvd_poly_feat[5616] = pow(input_x[1], 1) * pow(input_x[2], 5) * pow(input_x[3], 1) * pow(input_x[4], 1);
        idvd_poly_feat[5617] = pow(input_x[1], 1) * pow(input_x[2], 5) * pow(input_x[3], 1) * pow(input_x[5], 1);
        idvd_poly_feat[5618] = pow(input_x[1], 1) * pow(input_x[2], 5) * pow(input_x[3], 1) * pow(input_x[6], 1);
        idvd_poly_feat[5619] = pow(input_x[1], 1) * pow(input_x[2], 5) * pow(input_x[4], 2);
        idvd_poly_feat[5620] = pow(input_x[1], 1) * pow(input_x[2], 5) * pow(input_x[4], 1) * pow(input_x[5], 1);
        idvd_poly_feat[5621] = pow(input_x[1], 1) * pow(input_x[2], 5) * pow(input_x[4], 1) * pow(input_x[6], 1);
        idvd_poly_feat[5622] = pow(input_x[1], 1) * pow(input_x[2], 5) * pow(input_x[5], 2);
        idvd_poly_feat[5623] = pow(input_x[1], 1) * pow(input_x[2], 5) * pow(input_x[5], 1) * pow(input_x[6], 1);
        idvd_poly_feat[5624] = pow(input_x[1], 1) * pow(input_x[2], 5) * pow(input_x[6], 2);
        idvd_poly_feat[5625] = pow(input_x[1], 1) * pow(input_x[2], 4) * pow(input_x[3], 3);
        idvd_poly_feat[5626] = pow(input_x[1], 1) * pow(input_x[2], 4) * pow(input_x[3], 2) * pow(input_x[4], 1);
        idvd_poly_feat[5627] = pow(input_x[1], 1) * pow(input_x[2], 4) * pow(input_x[3], 2) * pow(input_x[5], 1);
        idvd_poly_feat[5628] = pow(input_x[1], 1) * pow(input_x[2], 4) * pow(input_x[3], 2) * pow(input_x[6], 1);
        idvd_poly_feat[5629] = pow(input_x[1], 1) * pow(input_x[2], 4) * pow(input_x[3], 1) * pow(input_x[4], 2);
        idvd_poly_feat[5630] = pow(input_x[1], 1) * pow(input_x[2], 4) * pow(input_x[3], 1) * pow(input_x[4], 1) * pow(input_x[5], 1);
        idvd_poly_feat[5631] = pow(input_x[1], 1) * pow(input_x[2], 4) * pow(input_x[3], 1) * pow(input_x[4], 1) * pow(input_x[6], 1);
        idvd_poly_feat[5632] = pow(input_x[1], 1) * pow(input_x[2], 4) * pow(input_x[3], 1) * pow(input_x[5], 2);
        idvd_poly_feat[5633] = pow(input_x[1], 1) * pow(input_x[2], 4) * pow(input_x[3], 1) * pow(input_x[5], 1) * pow(input_x[6], 1);
        idvd_poly_feat[5634] = pow(input_x[1], 1) * pow(input_x[2], 4) * pow(input_x[3], 1) * pow(input_x[6], 2);
        idvd_poly_feat[5635] = pow(input_x[1], 1) * pow(input_x[2], 4) * pow(input_x[4], 3);
        idvd_poly_feat[5636] = pow(input_x[1], 1) * pow(input_x[2], 4) * pow(input_x[4], 2) * pow(input_x[5], 1);
        idvd_poly_feat[5637] = pow(input_x[1], 1) * pow(input_x[2], 4) * pow(input_x[4], 2) * pow(input_x[6], 1);
        idvd_poly_feat[5638] = pow(input_x[1], 1) * pow(input_x[2], 4) * pow(input_x[4], 1) * pow(input_x[5], 2);
        idvd_poly_feat[5639] = pow(input_x[1], 1) * pow(input_x[2], 4) * pow(input_x[4], 1) * pow(input_x[5], 1) * pow(input_x[6], 1);
        idvd_poly_feat[5640] = pow(input_x[1], 1) * pow(input_x[2], 4) * pow(input_x[4], 1) * pow(input_x[6], 2);
        idvd_poly_feat[5641] = pow(input_x[1], 1) * pow(input_x[2], 4) * pow(input_x[5], 3);
        idvd_poly_feat[5642] = pow(input_x[1], 1) * pow(input_x[2], 4) * pow(input_x[5], 2) * pow(input_x[6], 1);
        idvd_poly_feat[5643] = pow(input_x[1], 1) * pow(input_x[2], 4) * pow(input_x[5], 1) * pow(input_x[6], 2);
        idvd_poly_feat[5644] = pow(input_x[1], 1) * pow(input_x[2], 4) * pow(input_x[6], 3);
        idvd_poly_feat[5645] = pow(input_x[1], 1) * pow(input_x[2], 3) * pow(input_x[3], 4);
        idvd_poly_feat[5646] = pow(input_x[1], 1) * pow(input_x[2], 3) * pow(input_x[3], 3) * pow(input_x[4], 1);
        idvd_poly_feat[5647] = pow(input_x[1], 1) * pow(input_x[2], 3) * pow(input_x[3], 3) * pow(input_x[5], 1);
        idvd_poly_feat[5648] = pow(input_x[1], 1) * pow(input_x[2], 3) * pow(input_x[3], 3) * pow(input_x[6], 1);
        idvd_poly_feat[5649] = pow(input_x[1], 1) * pow(input_x[2], 3) * pow(input_x[3], 2) * pow(input_x[4], 2);
        idvd_poly_feat[5650] = pow(input_x[1], 1) * pow(input_x[2], 3) * pow(input_x[3], 2) * pow(input_x[4], 1) * pow(input_x[5], 1);
        idvd_poly_feat[5651] = pow(input_x[1], 1) * pow(input_x[2], 3) * pow(input_x[3], 2) * pow(input_x[4], 1) * pow(input_x[6], 1);
        idvd_poly_feat[5652] = pow(input_x[1], 1) * pow(input_x[2], 3) * pow(input_x[3], 2) * pow(input_x[5], 2);
        idvd_poly_feat[5653] = pow(input_x[1], 1) * pow(input_x[2], 3) * pow(input_x[3], 2) * pow(input_x[5], 1) * pow(input_x[6], 1);
        idvd_poly_feat[5654] = pow(input_x[1], 1) * pow(input_x[2], 3) * pow(input_x[3], 2) * pow(input_x[6], 2);
        idvd_poly_feat[5655] = pow(input_x[1], 1) * pow(input_x[2], 3) * pow(input_x[3], 1) * pow(input_x[4], 3);
        idvd_poly_feat[5656] = pow(input_x[1], 1) * pow(input_x[2], 3) * pow(input_x[3], 1) * pow(input_x[4], 2) * pow(input_x[5], 1);
        idvd_poly_feat[5657] = pow(input_x[1], 1) * pow(input_x[2], 3) * pow(input_x[3], 1) * pow(input_x[4], 2) * pow(input_x[6], 1);
        idvd_poly_feat[5658] = pow(input_x[1], 1) * pow(input_x[2], 3) * pow(input_x[3], 1) * pow(input_x[4], 1) * pow(input_x[5], 2);
        idvd_poly_feat[5659] = pow(input_x[1], 1) * pow(input_x[2], 3) * pow(input_x[3], 1) * pow(input_x[4], 1) * pow(input_x[5], 1) * pow(input_x[6], 1);
        idvd_poly_feat[5660] = pow(input_x[1], 1) * pow(input_x[2], 3) * pow(input_x[3], 1) * pow(input_x[4], 1) * pow(input_x[6], 2);
        idvd_poly_feat[5661] = pow(input_x[1], 1) * pow(input_x[2], 3) * pow(input_x[3], 1) * pow(input_x[5], 3);
        idvd_poly_feat[5662] = pow(input_x[1], 1) * pow(input_x[2], 3) * pow(input_x[3], 1) * pow(input_x[5], 2) * pow(input_x[6], 1);
        idvd_poly_feat[5663] = pow(input_x[1], 1) * pow(input_x[2], 3) * pow(input_x[3], 1) * pow(input_x[5], 1) * pow(input_x[6], 2);
        idvd_poly_feat[5664] = pow(input_x[1], 1) * pow(input_x[2], 3) * pow(input_x[3], 1) * pow(input_x[6], 3);
        idvd_poly_feat[5665] = pow(input_x[1], 1) * pow(input_x[2], 3) * pow(input_x[4], 4);
        idvd_poly_feat[5666] = pow(input_x[1], 1) * pow(input_x[2], 3) * pow(input_x[4], 3) * pow(input_x[5], 1);
        idvd_poly_feat[5667] = pow(input_x[1], 1) * pow(input_x[2], 3) * pow(input_x[4], 3) * pow(input_x[6], 1);
        idvd_poly_feat[5668] = pow(input_x[1], 1) * pow(input_x[2], 3) * pow(input_x[4], 2) * pow(input_x[5], 2);
        idvd_poly_feat[5669] = pow(input_x[1], 1) * pow(input_x[2], 3) * pow(input_x[4], 2) * pow(input_x[5], 1) * pow(input_x[6], 1);
        idvd_poly_feat[5670] = pow(input_x[1], 1) * pow(input_x[2], 3) * pow(input_x[4], 2) * pow(input_x[6], 2);
        idvd_poly_feat[5671] = pow(input_x[1], 1) * pow(input_x[2], 3) * pow(input_x[4], 1) * pow(input_x[5], 3);
        idvd_poly_feat[5672] = pow(input_x[1], 1) * pow(input_x[2], 3) * pow(input_x[4], 1) * pow(input_x[5], 2) * pow(input_x[6], 1);
        idvd_poly_feat[5673] = pow(input_x[1], 1) * pow(input_x[2], 3) * pow(input_x[4], 1) * pow(input_x[5], 1) * pow(input_x[6], 2);
        idvd_poly_feat[5674] = pow(input_x[1], 1) * pow(input_x[2], 3) * pow(input_x[4], 1) * pow(input_x[6], 3);
        idvd_poly_feat[5675] = pow(input_x[1], 1) * pow(input_x[2], 3) * pow(input_x[5], 4);
        idvd_poly_feat[5676] = pow(input_x[1], 1) * pow(input_x[2], 3) * pow(input_x[5], 3) * pow(input_x[6], 1);
        idvd_poly_feat[5677] = pow(input_x[1], 1) * pow(input_x[2], 3) * pow(input_x[5], 2) * pow(input_x[6], 2);
        idvd_poly_feat[5678] = pow(input_x[1], 1) * pow(input_x[2], 3) * pow(input_x[5], 1) * pow(input_x[6], 3);
        idvd_poly_feat[5679] = pow(input_x[1], 1) * pow(input_x[2], 3) * pow(input_x[6], 4);
        idvd_poly_feat[5680] = pow(input_x[1], 1) * pow(input_x[2], 2) * pow(input_x[3], 5);
        idvd_poly_feat[5681] = pow(input_x[1], 1) * pow(input_x[2], 2) * pow(input_x[3], 4) * pow(input_x[4], 1);
        idvd_poly_feat[5682] = pow(input_x[1], 1) * pow(input_x[2], 2) * pow(input_x[3], 4) * pow(input_x[5], 1);
        idvd_poly_feat[5683] = pow(input_x[1], 1) * pow(input_x[2], 2) * pow(input_x[3], 4) * pow(input_x[6], 1);
        idvd_poly_feat[5684] = pow(input_x[1], 1) * pow(input_x[2], 2) * pow(input_x[3], 3) * pow(input_x[4], 2);
        idvd_poly_feat[5685] = pow(input_x[1], 1) * pow(input_x[2], 2) * pow(input_x[3], 3) * pow(input_x[4], 1) * pow(input_x[5], 1);
        idvd_poly_feat[5686] = pow(input_x[1], 1) * pow(input_x[2], 2) * pow(input_x[3], 3) * pow(input_x[4], 1) * pow(input_x[6], 1);
        idvd_poly_feat[5687] = pow(input_x[1], 1) * pow(input_x[2], 2) * pow(input_x[3], 3) * pow(input_x[5], 2);
        idvd_poly_feat[5688] = pow(input_x[1], 1) * pow(input_x[2], 2) * pow(input_x[3], 3) * pow(input_x[5], 1) * pow(input_x[6], 1);
        idvd_poly_feat[5689] = pow(input_x[1], 1) * pow(input_x[2], 2) * pow(input_x[3], 3) * pow(input_x[6], 2);
        idvd_poly_feat[5690] = pow(input_x[1], 1) * pow(input_x[2], 2) * pow(input_x[3], 2) * pow(input_x[4], 3);
        idvd_poly_feat[5691] = pow(input_x[1], 1) * pow(input_x[2], 2) * pow(input_x[3], 2) * pow(input_x[4], 2) * pow(input_x[5], 1);
        idvd_poly_feat[5692] = pow(input_x[1], 1) * pow(input_x[2], 2) * pow(input_x[3], 2) * pow(input_x[4], 2) * pow(input_x[6], 1);
        idvd_poly_feat[5693] = pow(input_x[1], 1) * pow(input_x[2], 2) * pow(input_x[3], 2) * pow(input_x[4], 1) * pow(input_x[5], 2);
        idvd_poly_feat[5694] = pow(input_x[1], 1) * pow(input_x[2], 2) * pow(input_x[3], 2) * pow(input_x[4], 1) * pow(input_x[5], 1) * pow(input_x[6], 1);
        idvd_poly_feat[5695] = pow(input_x[1], 1) * pow(input_x[2], 2) * pow(input_x[3], 2) * pow(input_x[4], 1) * pow(input_x[6], 2);
        idvd_poly_feat[5696] = pow(input_x[1], 1) * pow(input_x[2], 2) * pow(input_x[3], 2) * pow(input_x[5], 3);
        idvd_poly_feat[5697] = pow(input_x[1], 1) * pow(input_x[2], 2) * pow(input_x[3], 2) * pow(input_x[5], 2) * pow(input_x[6], 1);
        idvd_poly_feat[5698] = pow(input_x[1], 1) * pow(input_x[2], 2) * pow(input_x[3], 2) * pow(input_x[5], 1) * pow(input_x[6], 2);
        idvd_poly_feat[5699] = pow(input_x[1], 1) * pow(input_x[2], 2) * pow(input_x[3], 2) * pow(input_x[6], 3);
        idvd_poly_feat[5700] = pow(input_x[1], 1) * pow(input_x[2], 2) * pow(input_x[3], 1) * pow(input_x[4], 4);
        idvd_poly_feat[5701] = pow(input_x[1], 1) * pow(input_x[2], 2) * pow(input_x[3], 1) * pow(input_x[4], 3) * pow(input_x[5], 1);
        idvd_poly_feat[5702] = pow(input_x[1], 1) * pow(input_x[2], 2) * pow(input_x[3], 1) * pow(input_x[4], 3) * pow(input_x[6], 1);
        idvd_poly_feat[5703] = pow(input_x[1], 1) * pow(input_x[2], 2) * pow(input_x[3], 1) * pow(input_x[4], 2) * pow(input_x[5], 2);
        idvd_poly_feat[5704] = pow(input_x[1], 1) * pow(input_x[2], 2) * pow(input_x[3], 1) * pow(input_x[4], 2) * pow(input_x[5], 1) * pow(input_x[6], 1);
        idvd_poly_feat[5705] = pow(input_x[1], 1) * pow(input_x[2], 2) * pow(input_x[3], 1) * pow(input_x[4], 2) * pow(input_x[6], 2);
        idvd_poly_feat[5706] = pow(input_x[1], 1) * pow(input_x[2], 2) * pow(input_x[3], 1) * pow(input_x[4], 1) * pow(input_x[5], 3);
        idvd_poly_feat[5707] = pow(input_x[1], 1) * pow(input_x[2], 2) * pow(input_x[3], 1) * pow(input_x[4], 1) * pow(input_x[5], 2) * pow(input_x[6], 1);
        idvd_poly_feat[5708] = pow(input_x[1], 1) * pow(input_x[2], 2) * pow(input_x[3], 1) * pow(input_x[4], 1) * pow(input_x[5], 1) * pow(input_x[6], 2);
        idvd_poly_feat[5709] = pow(input_x[1], 1) * pow(input_x[2], 2) * pow(input_x[3], 1) * pow(input_x[4], 1) * pow(input_x[6], 3);
        idvd_poly_feat[5710] = pow(input_x[1], 1) * pow(input_x[2], 2) * pow(input_x[3], 1) * pow(input_x[5], 4);
        idvd_poly_feat[5711] = pow(input_x[1], 1) * pow(input_x[2], 2) * pow(input_x[3], 1) * pow(input_x[5], 3) * pow(input_x[6], 1);
        idvd_poly_feat[5712] = pow(input_x[1], 1) * pow(input_x[2], 2) * pow(input_x[3], 1) * pow(input_x[5], 2) * pow(input_x[6], 2);
        idvd_poly_feat[5713] = pow(input_x[1], 1) * pow(input_x[2], 2) * pow(input_x[3], 1) * pow(input_x[5], 1) * pow(input_x[6], 3);
        idvd_poly_feat[5714] = pow(input_x[1], 1) * pow(input_x[2], 2) * pow(input_x[3], 1) * pow(input_x[6], 4);
        idvd_poly_feat[5715] = pow(input_x[1], 1) * pow(input_x[2], 2) * pow(input_x[4], 5);
        idvd_poly_feat[5716] = pow(input_x[1], 1) * pow(input_x[2], 2) * pow(input_x[4], 4) * pow(input_x[5], 1);
        idvd_poly_feat[5717] = pow(input_x[1], 1) * pow(input_x[2], 2) * pow(input_x[4], 4) * pow(input_x[6], 1);
        idvd_poly_feat[5718] = pow(input_x[1], 1) * pow(input_x[2], 2) * pow(input_x[4], 3) * pow(input_x[5], 2);
        idvd_poly_feat[5719] = pow(input_x[1], 1) * pow(input_x[2], 2) * pow(input_x[4], 3) * pow(input_x[5], 1) * pow(input_x[6], 1);
        idvd_poly_feat[5720] = pow(input_x[1], 1) * pow(input_x[2], 2) * pow(input_x[4], 3) * pow(input_x[6], 2);
        idvd_poly_feat[5721] = pow(input_x[1], 1) * pow(input_x[2], 2) * pow(input_x[4], 2) * pow(input_x[5], 3);
        idvd_poly_feat[5722] = pow(input_x[1], 1) * pow(input_x[2], 2) * pow(input_x[4], 2) * pow(input_x[5], 2) * pow(input_x[6], 1);
        idvd_poly_feat[5723] = pow(input_x[1], 1) * pow(input_x[2], 2) * pow(input_x[4], 2) * pow(input_x[5], 1) * pow(input_x[6], 2);
        idvd_poly_feat[5724] = pow(input_x[1], 1) * pow(input_x[2], 2) * pow(input_x[4], 2) * pow(input_x[6], 3);
        idvd_poly_feat[5725] = pow(input_x[1], 1) * pow(input_x[2], 2) * pow(input_x[4], 1) * pow(input_x[5], 4);
        idvd_poly_feat[5726] = pow(input_x[1], 1) * pow(input_x[2], 2) * pow(input_x[4], 1) * pow(input_x[5], 3) * pow(input_x[6], 1);
        idvd_poly_feat[5727] = pow(input_x[1], 1) * pow(input_x[2], 2) * pow(input_x[4], 1) * pow(input_x[5], 2) * pow(input_x[6], 2);
        idvd_poly_feat[5728] = pow(input_x[1], 1) * pow(input_x[2], 2) * pow(input_x[4], 1) * pow(input_x[5], 1) * pow(input_x[6], 3);
        idvd_poly_feat[5729] = pow(input_x[1], 1) * pow(input_x[2], 2) * pow(input_x[4], 1) * pow(input_x[6], 4);
        idvd_poly_feat[5730] = pow(input_x[1], 1) * pow(input_x[2], 2) * pow(input_x[5], 5);
        idvd_poly_feat[5731] = pow(input_x[1], 1) * pow(input_x[2], 2) * pow(input_x[5], 4) * pow(input_x[6], 1);
        idvd_poly_feat[5732] = pow(input_x[1], 1) * pow(input_x[2], 2) * pow(input_x[5], 3) * pow(input_x[6], 2);
        idvd_poly_feat[5733] = pow(input_x[1], 1) * pow(input_x[2], 2) * pow(input_x[5], 2) * pow(input_x[6], 3);
        idvd_poly_feat[5734] = pow(input_x[1], 1) * pow(input_x[2], 2) * pow(input_x[5], 1) * pow(input_x[6], 4);
        idvd_poly_feat[5735] = pow(input_x[1], 1) * pow(input_x[2], 2) * pow(input_x[6], 5);
        idvd_poly_feat[5736] = pow(input_x[1], 1) * pow(input_x[2], 1) * pow(input_x[3], 6);
        idvd_poly_feat[5737] = pow(input_x[1], 1) * pow(input_x[2], 1) * pow(input_x[3], 5) * pow(input_x[4], 1);
        idvd_poly_feat[5738] = pow(input_x[1], 1) * pow(input_x[2], 1) * pow(input_x[3], 5) * pow(input_x[5], 1);
        idvd_poly_feat[5739] = pow(input_x[1], 1) * pow(input_x[2], 1) * pow(input_x[3], 5) * pow(input_x[6], 1);
        idvd_poly_feat[5740] = pow(input_x[1], 1) * pow(input_x[2], 1) * pow(input_x[3], 4) * pow(input_x[4], 2);
        idvd_poly_feat[5741] = pow(input_x[1], 1) * pow(input_x[2], 1) * pow(input_x[3], 4) * pow(input_x[4], 1) * pow(input_x[5], 1);
        idvd_poly_feat[5742] = pow(input_x[1], 1) * pow(input_x[2], 1) * pow(input_x[3], 4) * pow(input_x[4], 1) * pow(input_x[6], 1);
        idvd_poly_feat[5743] = pow(input_x[1], 1) * pow(input_x[2], 1) * pow(input_x[3], 4) * pow(input_x[5], 2);
        idvd_poly_feat[5744] = pow(input_x[1], 1) * pow(input_x[2], 1) * pow(input_x[3], 4) * pow(input_x[5], 1) * pow(input_x[6], 1);
        idvd_poly_feat[5745] = pow(input_x[1], 1) * pow(input_x[2], 1) * pow(input_x[3], 4) * pow(input_x[6], 2);
        idvd_poly_feat[5746] = pow(input_x[1], 1) * pow(input_x[2], 1) * pow(input_x[3], 3) * pow(input_x[4], 3);
        idvd_poly_feat[5747] = pow(input_x[1], 1) * pow(input_x[2], 1) * pow(input_x[3], 3) * pow(input_x[4], 2) * pow(input_x[5], 1);
        idvd_poly_feat[5748] = pow(input_x[1], 1) * pow(input_x[2], 1) * pow(input_x[3], 3) * pow(input_x[4], 2) * pow(input_x[6], 1);
        idvd_poly_feat[5749] = pow(input_x[1], 1) * pow(input_x[2], 1) * pow(input_x[3], 3) * pow(input_x[4], 1) * pow(input_x[5], 2);
        idvd_poly_feat[5750] = pow(input_x[1], 1) * pow(input_x[2], 1) * pow(input_x[3], 3) * pow(input_x[4], 1) * pow(input_x[5], 1) * pow(input_x[6], 1);
        idvd_poly_feat[5751] = pow(input_x[1], 1) * pow(input_x[2], 1) * pow(input_x[3], 3) * pow(input_x[4], 1) * pow(input_x[6], 2);
        idvd_poly_feat[5752] = pow(input_x[1], 1) * pow(input_x[2], 1) * pow(input_x[3], 3) * pow(input_x[5], 3);
        idvd_poly_feat[5753] = pow(input_x[1], 1) * pow(input_x[2], 1) * pow(input_x[3], 3) * pow(input_x[5], 2) * pow(input_x[6], 1);
        idvd_poly_feat[5754] = pow(input_x[1], 1) * pow(input_x[2], 1) * pow(input_x[3], 3) * pow(input_x[5], 1) * pow(input_x[6], 2);
        idvd_poly_feat[5755] = pow(input_x[1], 1) * pow(input_x[2], 1) * pow(input_x[3], 3) * pow(input_x[6], 3);
        idvd_poly_feat[5756] = pow(input_x[1], 1) * pow(input_x[2], 1) * pow(input_x[3], 2) * pow(input_x[4], 4);
        idvd_poly_feat[5757] = pow(input_x[1], 1) * pow(input_x[2], 1) * pow(input_x[3], 2) * pow(input_x[4], 3) * pow(input_x[5], 1);
        idvd_poly_feat[5758] = pow(input_x[1], 1) * pow(input_x[2], 1) * pow(input_x[3], 2) * pow(input_x[4], 3) * pow(input_x[6], 1);
        idvd_poly_feat[5759] = pow(input_x[1], 1) * pow(input_x[2], 1) * pow(input_x[3], 2) * pow(input_x[4], 2) * pow(input_x[5], 2);
        idvd_poly_feat[5760] = pow(input_x[1], 1) * pow(input_x[2], 1) * pow(input_x[3], 2) * pow(input_x[4], 2) * pow(input_x[5], 1) * pow(input_x[6], 1);
        idvd_poly_feat[5761] = pow(input_x[1], 1) * pow(input_x[2], 1) * pow(input_x[3], 2) * pow(input_x[4], 2) * pow(input_x[6], 2);
        idvd_poly_feat[5762] = pow(input_x[1], 1) * pow(input_x[2], 1) * pow(input_x[3], 2) * pow(input_x[4], 1) * pow(input_x[5], 3);
        idvd_poly_feat[5763] = pow(input_x[1], 1) * pow(input_x[2], 1) * pow(input_x[3], 2) * pow(input_x[4], 1) * pow(input_x[5], 2) * pow(input_x[6], 1);
        idvd_poly_feat[5764] = pow(input_x[1], 1) * pow(input_x[2], 1) * pow(input_x[3], 2) * pow(input_x[4], 1) * pow(input_x[5], 1) * pow(input_x[6], 2);
        idvd_poly_feat[5765] = pow(input_x[1], 1) * pow(input_x[2], 1) * pow(input_x[3], 2) * pow(input_x[4], 1) * pow(input_x[6], 3);
        idvd_poly_feat[5766] = pow(input_x[1], 1) * pow(input_x[2], 1) * pow(input_x[3], 2) * pow(input_x[5], 4);
        idvd_poly_feat[5767] = pow(input_x[1], 1) * pow(input_x[2], 1) * pow(input_x[3], 2) * pow(input_x[5], 3) * pow(input_x[6], 1);
        idvd_poly_feat[5768] = pow(input_x[1], 1) * pow(input_x[2], 1) * pow(input_x[3], 2) * pow(input_x[5], 2) * pow(input_x[6], 2);
        idvd_poly_feat[5769] = pow(input_x[1], 1) * pow(input_x[2], 1) * pow(input_x[3], 2) * pow(input_x[5], 1) * pow(input_x[6], 3);
        idvd_poly_feat[5770] = pow(input_x[1], 1) * pow(input_x[2], 1) * pow(input_x[3], 2) * pow(input_x[6], 4);
        idvd_poly_feat[5771] = pow(input_x[1], 1) * pow(input_x[2], 1) * pow(input_x[3], 1) * pow(input_x[4], 5);
        idvd_poly_feat[5772] = pow(input_x[1], 1) * pow(input_x[2], 1) * pow(input_x[3], 1) * pow(input_x[4], 4) * pow(input_x[5], 1);
        idvd_poly_feat[5773] = pow(input_x[1], 1) * pow(input_x[2], 1) * pow(input_x[3], 1) * pow(input_x[4], 4) * pow(input_x[6], 1);
        idvd_poly_feat[5774] = pow(input_x[1], 1) * pow(input_x[2], 1) * pow(input_x[3], 1) * pow(input_x[4], 3) * pow(input_x[5], 2);
        idvd_poly_feat[5775] = pow(input_x[1], 1) * pow(input_x[2], 1) * pow(input_x[3], 1) * pow(input_x[4], 3) * pow(input_x[5], 1) * pow(input_x[6], 1);
        idvd_poly_feat[5776] = pow(input_x[1], 1) * pow(input_x[2], 1) * pow(input_x[3], 1) * pow(input_x[4], 3) * pow(input_x[6], 2);
        idvd_poly_feat[5777] = pow(input_x[1], 1) * pow(input_x[2], 1) * pow(input_x[3], 1) * pow(input_x[4], 2) * pow(input_x[5], 3);
        idvd_poly_feat[5778] = pow(input_x[1], 1) * pow(input_x[2], 1) * pow(input_x[3], 1) * pow(input_x[4], 2) * pow(input_x[5], 2) * pow(input_x[6], 1);
        idvd_poly_feat[5779] = pow(input_x[1], 1) * pow(input_x[2], 1) * pow(input_x[3], 1) * pow(input_x[4], 2) * pow(input_x[5], 1) * pow(input_x[6], 2);
        idvd_poly_feat[5780] = pow(input_x[1], 1) * pow(input_x[2], 1) * pow(input_x[3], 1) * pow(input_x[4], 2) * pow(input_x[6], 3);
        idvd_poly_feat[5781] = pow(input_x[1], 1) * pow(input_x[2], 1) * pow(input_x[3], 1) * pow(input_x[4], 1) * pow(input_x[5], 4);
        idvd_poly_feat[5782] = pow(input_x[1], 1) * pow(input_x[2], 1) * pow(input_x[3], 1) * pow(input_x[4], 1) * pow(input_x[5], 3) * pow(input_x[6], 1);
        idvd_poly_feat[5783] = pow(input_x[1], 1) * pow(input_x[2], 1) * pow(input_x[3], 1) * pow(input_x[4], 1) * pow(input_x[5], 2) * pow(input_x[6], 2);
        idvd_poly_feat[5784] = pow(input_x[1], 1) * pow(input_x[2], 1) * pow(input_x[3], 1) * pow(input_x[4], 1) * pow(input_x[5], 1) * pow(input_x[6], 3);
        idvd_poly_feat[5785] = pow(input_x[1], 1) * pow(input_x[2], 1) * pow(input_x[3], 1) * pow(input_x[4], 1) * pow(input_x[6], 4);
        idvd_poly_feat[5786] = pow(input_x[1], 1) * pow(input_x[2], 1) * pow(input_x[3], 1) * pow(input_x[5], 5);
        idvd_poly_feat[5787] = pow(input_x[1], 1) * pow(input_x[2], 1) * pow(input_x[3], 1) * pow(input_x[5], 4) * pow(input_x[6], 1);
        idvd_poly_feat[5788] = pow(input_x[1], 1) * pow(input_x[2], 1) * pow(input_x[3], 1) * pow(input_x[5], 3) * pow(input_x[6], 2);
        idvd_poly_feat[5789] = pow(input_x[1], 1) * pow(input_x[2], 1) * pow(input_x[3], 1) * pow(input_x[5], 2) * pow(input_x[6], 3);
        idvd_poly_feat[5790] = pow(input_x[1], 1) * pow(input_x[2], 1) * pow(input_x[3], 1) * pow(input_x[5], 1) * pow(input_x[6], 4);
        idvd_poly_feat[5791] = pow(input_x[1], 1) * pow(input_x[2], 1) * pow(input_x[3], 1) * pow(input_x[6], 5);
        idvd_poly_feat[5792] = pow(input_x[1], 1) * pow(input_x[2], 1) * pow(input_x[4], 6);
        idvd_poly_feat[5793] = pow(input_x[1], 1) * pow(input_x[2], 1) * pow(input_x[4], 5) * pow(input_x[5], 1);
        idvd_poly_feat[5794] = pow(input_x[1], 1) * pow(input_x[2], 1) * pow(input_x[4], 5) * pow(input_x[6], 1);
        idvd_poly_feat[5795] = pow(input_x[1], 1) * pow(input_x[2], 1) * pow(input_x[4], 4) * pow(input_x[5], 2);
        idvd_poly_feat[5796] = pow(input_x[1], 1) * pow(input_x[2], 1) * pow(input_x[4], 4) * pow(input_x[5], 1) * pow(input_x[6], 1);
        idvd_poly_feat[5797] = pow(input_x[1], 1) * pow(input_x[2], 1) * pow(input_x[4], 4) * pow(input_x[6], 2);
        idvd_poly_feat[5798] = pow(input_x[1], 1) * pow(input_x[2], 1) * pow(input_x[4], 3) * pow(input_x[5], 3);
        idvd_poly_feat[5799] = pow(input_x[1], 1) * pow(input_x[2], 1) * pow(input_x[4], 3) * pow(input_x[5], 2) * pow(input_x[6], 1);
        idvd_poly_feat[5800] = pow(input_x[1], 1) * pow(input_x[2], 1) * pow(input_x[4], 3) * pow(input_x[5], 1) * pow(input_x[6], 2);
        idvd_poly_feat[5801] = pow(input_x[1], 1) * pow(input_x[2], 1) * pow(input_x[4], 3) * pow(input_x[6], 3);
        idvd_poly_feat[5802] = pow(input_x[1], 1) * pow(input_x[2], 1) * pow(input_x[4], 2) * pow(input_x[5], 4);
        idvd_poly_feat[5803] = pow(input_x[1], 1) * pow(input_x[2], 1) * pow(input_x[4], 2) * pow(input_x[5], 3) * pow(input_x[6], 1);
        idvd_poly_feat[5804] = pow(input_x[1], 1) * pow(input_x[2], 1) * pow(input_x[4], 2) * pow(input_x[5], 2) * pow(input_x[6], 2);
        idvd_poly_feat[5805] = pow(input_x[1], 1) * pow(input_x[2], 1) * pow(input_x[4], 2) * pow(input_x[5], 1) * pow(input_x[6], 3);
        idvd_poly_feat[5806] = pow(input_x[1], 1) * pow(input_x[2], 1) * pow(input_x[4], 2) * pow(input_x[6], 4);
        idvd_poly_feat[5807] = pow(input_x[1], 1) * pow(input_x[2], 1) * pow(input_x[4], 1) * pow(input_x[5], 5);
        idvd_poly_feat[5808] = pow(input_x[1], 1) * pow(input_x[2], 1) * pow(input_x[4], 1) * pow(input_x[5], 4) * pow(input_x[6], 1);
        idvd_poly_feat[5809] = pow(input_x[1], 1) * pow(input_x[2], 1) * pow(input_x[4], 1) * pow(input_x[5], 3) * pow(input_x[6], 2);
        idvd_poly_feat[5810] = pow(input_x[1], 1) * pow(input_x[2], 1) * pow(input_x[4], 1) * pow(input_x[5], 2) * pow(input_x[6], 3);
        idvd_poly_feat[5811] = pow(input_x[1], 1) * pow(input_x[2], 1) * pow(input_x[4], 1) * pow(input_x[5], 1) * pow(input_x[6], 4);
        idvd_poly_feat[5812] = pow(input_x[1], 1) * pow(input_x[2], 1) * pow(input_x[4], 1) * pow(input_x[6], 5);
        idvd_poly_feat[5813] = pow(input_x[1], 1) * pow(input_x[2], 1) * pow(input_x[5], 6);
        idvd_poly_feat[5814] = pow(input_x[1], 1) * pow(input_x[2], 1) * pow(input_x[5], 5) * pow(input_x[6], 1);
        idvd_poly_feat[5815] = pow(input_x[1], 1) * pow(input_x[2], 1) * pow(input_x[5], 4) * pow(input_x[6], 2);
        idvd_poly_feat[5816] = pow(input_x[1], 1) * pow(input_x[2], 1) * pow(input_x[5], 3) * pow(input_x[6], 3);
        idvd_poly_feat[5817] = pow(input_x[1], 1) * pow(input_x[2], 1) * pow(input_x[5], 2) * pow(input_x[6], 4);
        idvd_poly_feat[5818] = pow(input_x[1], 1) * pow(input_x[2], 1) * pow(input_x[5], 1) * pow(input_x[6], 5);
        idvd_poly_feat[5819] = pow(input_x[1], 1) * pow(input_x[2], 1) * pow(input_x[6], 6);
        idvd_poly_feat[5820] = pow(input_x[1], 1) * pow(input_x[3], 7);
        idvd_poly_feat[5821] = pow(input_x[1], 1) * pow(input_x[3], 6) * pow(input_x[4], 1);
        idvd_poly_feat[5822] = pow(input_x[1], 1) * pow(input_x[3], 6) * pow(input_x[5], 1);
        idvd_poly_feat[5823] = pow(input_x[1], 1) * pow(input_x[3], 6) * pow(input_x[6], 1);
        idvd_poly_feat[5824] = pow(input_x[1], 1) * pow(input_x[3], 5) * pow(input_x[4], 2);
        idvd_poly_feat[5825] = pow(input_x[1], 1) * pow(input_x[3], 5) * pow(input_x[4], 1) * pow(input_x[5], 1);
        idvd_poly_feat[5826] = pow(input_x[1], 1) * pow(input_x[3], 5) * pow(input_x[4], 1) * pow(input_x[6], 1);
        idvd_poly_feat[5827] = pow(input_x[1], 1) * pow(input_x[3], 5) * pow(input_x[5], 2);
        idvd_poly_feat[5828] = pow(input_x[1], 1) * pow(input_x[3], 5) * pow(input_x[5], 1) * pow(input_x[6], 1);
        idvd_poly_feat[5829] = pow(input_x[1], 1) * pow(input_x[3], 5) * pow(input_x[6], 2);
        idvd_poly_feat[5830] = pow(input_x[1], 1) * pow(input_x[3], 4) * pow(input_x[4], 3);
        idvd_poly_feat[5831] = pow(input_x[1], 1) * pow(input_x[3], 4) * pow(input_x[4], 2) * pow(input_x[5], 1);
        idvd_poly_feat[5832] = pow(input_x[1], 1) * pow(input_x[3], 4) * pow(input_x[4], 2) * pow(input_x[6], 1);
        idvd_poly_feat[5833] = pow(input_x[1], 1) * pow(input_x[3], 4) * pow(input_x[4], 1) * pow(input_x[5], 2);
        idvd_poly_feat[5834] = pow(input_x[1], 1) * pow(input_x[3], 4) * pow(input_x[4], 1) * pow(input_x[5], 1) * pow(input_x[6], 1);
        idvd_poly_feat[5835] = pow(input_x[1], 1) * pow(input_x[3], 4) * pow(input_x[4], 1) * pow(input_x[6], 2);
        idvd_poly_feat[5836] = pow(input_x[1], 1) * pow(input_x[3], 4) * pow(input_x[5], 3);
        idvd_poly_feat[5837] = pow(input_x[1], 1) * pow(input_x[3], 4) * pow(input_x[5], 2) * pow(input_x[6], 1);
        idvd_poly_feat[5838] = pow(input_x[1], 1) * pow(input_x[3], 4) * pow(input_x[5], 1) * pow(input_x[6], 2);
        idvd_poly_feat[5839] = pow(input_x[1], 1) * pow(input_x[3], 4) * pow(input_x[6], 3);
        idvd_poly_feat[5840] = pow(input_x[1], 1) * pow(input_x[3], 3) * pow(input_x[4], 4);
        idvd_poly_feat[5841] = pow(input_x[1], 1) * pow(input_x[3], 3) * pow(input_x[4], 3) * pow(input_x[5], 1);
        idvd_poly_feat[5842] = pow(input_x[1], 1) * pow(input_x[3], 3) * pow(input_x[4], 3) * pow(input_x[6], 1);
        idvd_poly_feat[5843] = pow(input_x[1], 1) * pow(input_x[3], 3) * pow(input_x[4], 2) * pow(input_x[5], 2);
        idvd_poly_feat[5844] = pow(input_x[1], 1) * pow(input_x[3], 3) * pow(input_x[4], 2) * pow(input_x[5], 1) * pow(input_x[6], 1);
        idvd_poly_feat[5845] = pow(input_x[1], 1) * pow(input_x[3], 3) * pow(input_x[4], 2) * pow(input_x[6], 2);
        idvd_poly_feat[5846] = pow(input_x[1], 1) * pow(input_x[3], 3) * pow(input_x[4], 1) * pow(input_x[5], 3);
        idvd_poly_feat[5847] = pow(input_x[1], 1) * pow(input_x[3], 3) * pow(input_x[4], 1) * pow(input_x[5], 2) * pow(input_x[6], 1);
        idvd_poly_feat[5848] = pow(input_x[1], 1) * pow(input_x[3], 3) * pow(input_x[4], 1) * pow(input_x[5], 1) * pow(input_x[6], 2);
        idvd_poly_feat[5849] = pow(input_x[1], 1) * pow(input_x[3], 3) * pow(input_x[4], 1) * pow(input_x[6], 3);
        idvd_poly_feat[5850] = pow(input_x[1], 1) * pow(input_x[3], 3) * pow(input_x[5], 4);
        idvd_poly_feat[5851] = pow(input_x[1], 1) * pow(input_x[3], 3) * pow(input_x[5], 3) * pow(input_x[6], 1);
        idvd_poly_feat[5852] = pow(input_x[1], 1) * pow(input_x[3], 3) * pow(input_x[5], 2) * pow(input_x[6], 2);
        idvd_poly_feat[5853] = pow(input_x[1], 1) * pow(input_x[3], 3) * pow(input_x[5], 1) * pow(input_x[6], 3);
        idvd_poly_feat[5854] = pow(input_x[1], 1) * pow(input_x[3], 3) * pow(input_x[6], 4);
        idvd_poly_feat[5855] = pow(input_x[1], 1) * pow(input_x[3], 2) * pow(input_x[4], 5);
        idvd_poly_feat[5856] = pow(input_x[1], 1) * pow(input_x[3], 2) * pow(input_x[4], 4) * pow(input_x[5], 1);
        idvd_poly_feat[5857] = pow(input_x[1], 1) * pow(input_x[3], 2) * pow(input_x[4], 4) * pow(input_x[6], 1);
        idvd_poly_feat[5858] = pow(input_x[1], 1) * pow(input_x[3], 2) * pow(input_x[4], 3) * pow(input_x[5], 2);
        idvd_poly_feat[5859] = pow(input_x[1], 1) * pow(input_x[3], 2) * pow(input_x[4], 3) * pow(input_x[5], 1) * pow(input_x[6], 1);
        idvd_poly_feat[5860] = pow(input_x[1], 1) * pow(input_x[3], 2) * pow(input_x[4], 3) * pow(input_x[6], 2);
        idvd_poly_feat[5861] = pow(input_x[1], 1) * pow(input_x[3], 2) * pow(input_x[4], 2) * pow(input_x[5], 3);
        idvd_poly_feat[5862] = pow(input_x[1], 1) * pow(input_x[3], 2) * pow(input_x[4], 2) * pow(input_x[5], 2) * pow(input_x[6], 1);
        idvd_poly_feat[5863] = pow(input_x[1], 1) * pow(input_x[3], 2) * pow(input_x[4], 2) * pow(input_x[5], 1) * pow(input_x[6], 2);
        idvd_poly_feat[5864] = pow(input_x[1], 1) * pow(input_x[3], 2) * pow(input_x[4], 2) * pow(input_x[6], 3);
        idvd_poly_feat[5865] = pow(input_x[1], 1) * pow(input_x[3], 2) * pow(input_x[4], 1) * pow(input_x[5], 4);
        idvd_poly_feat[5866] = pow(input_x[1], 1) * pow(input_x[3], 2) * pow(input_x[4], 1) * pow(input_x[5], 3) * pow(input_x[6], 1);
        idvd_poly_feat[5867] = pow(input_x[1], 1) * pow(input_x[3], 2) * pow(input_x[4], 1) * pow(input_x[5], 2) * pow(input_x[6], 2);
        idvd_poly_feat[5868] = pow(input_x[1], 1) * pow(input_x[3], 2) * pow(input_x[4], 1) * pow(input_x[5], 1) * pow(input_x[6], 3);
        idvd_poly_feat[5869] = pow(input_x[1], 1) * pow(input_x[3], 2) * pow(input_x[4], 1) * pow(input_x[6], 4);
        idvd_poly_feat[5870] = pow(input_x[1], 1) * pow(input_x[3], 2) * pow(input_x[5], 5);
        idvd_poly_feat[5871] = pow(input_x[1], 1) * pow(input_x[3], 2) * pow(input_x[5], 4) * pow(input_x[6], 1);
        idvd_poly_feat[5872] = pow(input_x[1], 1) * pow(input_x[3], 2) * pow(input_x[5], 3) * pow(input_x[6], 2);
        idvd_poly_feat[5873] = pow(input_x[1], 1) * pow(input_x[3], 2) * pow(input_x[5], 2) * pow(input_x[6], 3);
        idvd_poly_feat[5874] = pow(input_x[1], 1) * pow(input_x[3], 2) * pow(input_x[5], 1) * pow(input_x[6], 4);
        idvd_poly_feat[5875] = pow(input_x[1], 1) * pow(input_x[3], 2) * pow(input_x[6], 5);
        idvd_poly_feat[5876] = pow(input_x[1], 1) * pow(input_x[3], 1) * pow(input_x[4], 6);
        idvd_poly_feat[5877] = pow(input_x[1], 1) * pow(input_x[3], 1) * pow(input_x[4], 5) * pow(input_x[5], 1);
        idvd_poly_feat[5878] = pow(input_x[1], 1) * pow(input_x[3], 1) * pow(input_x[4], 5) * pow(input_x[6], 1);
        idvd_poly_feat[5879] = pow(input_x[1], 1) * pow(input_x[3], 1) * pow(input_x[4], 4) * pow(input_x[5], 2);
        idvd_poly_feat[5880] = pow(input_x[1], 1) * pow(input_x[3], 1) * pow(input_x[4], 4) * pow(input_x[5], 1) * pow(input_x[6], 1);
        idvd_poly_feat[5881] = pow(input_x[1], 1) * pow(input_x[3], 1) * pow(input_x[4], 4) * pow(input_x[6], 2);
        idvd_poly_feat[5882] = pow(input_x[1], 1) * pow(input_x[3], 1) * pow(input_x[4], 3) * pow(input_x[5], 3);
        idvd_poly_feat[5883] = pow(input_x[1], 1) * pow(input_x[3], 1) * pow(input_x[4], 3) * pow(input_x[5], 2) * pow(input_x[6], 1);
        idvd_poly_feat[5884] = pow(input_x[1], 1) * pow(input_x[3], 1) * pow(input_x[4], 3) * pow(input_x[5], 1) * pow(input_x[6], 2);
        idvd_poly_feat[5885] = pow(input_x[1], 1) * pow(input_x[3], 1) * pow(input_x[4], 3) * pow(input_x[6], 3);
        idvd_poly_feat[5886] = pow(input_x[1], 1) * pow(input_x[3], 1) * pow(input_x[4], 2) * pow(input_x[5], 4);
        idvd_poly_feat[5887] = pow(input_x[1], 1) * pow(input_x[3], 1) * pow(input_x[4], 2) * pow(input_x[5], 3) * pow(input_x[6], 1);
        idvd_poly_feat[5888] = pow(input_x[1], 1) * pow(input_x[3], 1) * pow(input_x[4], 2) * pow(input_x[5], 2) * pow(input_x[6], 2);
        idvd_poly_feat[5889] = pow(input_x[1], 1) * pow(input_x[3], 1) * pow(input_x[4], 2) * pow(input_x[5], 1) * pow(input_x[6], 3);
        idvd_poly_feat[5890] = pow(input_x[1], 1) * pow(input_x[3], 1) * pow(input_x[4], 2) * pow(input_x[6], 4);
        idvd_poly_feat[5891] = pow(input_x[1], 1) * pow(input_x[3], 1) * pow(input_x[4], 1) * pow(input_x[5], 5);
        idvd_poly_feat[5892] = pow(input_x[1], 1) * pow(input_x[3], 1) * pow(input_x[4], 1) * pow(input_x[5], 4) * pow(input_x[6], 1);
        idvd_poly_feat[5893] = pow(input_x[1], 1) * pow(input_x[3], 1) * pow(input_x[4], 1) * pow(input_x[5], 3) * pow(input_x[6], 2);
        idvd_poly_feat[5894] = pow(input_x[1], 1) * pow(input_x[3], 1) * pow(input_x[4], 1) * pow(input_x[5], 2) * pow(input_x[6], 3);
        idvd_poly_feat[5895] = pow(input_x[1], 1) * pow(input_x[3], 1) * pow(input_x[4], 1) * pow(input_x[5], 1) * pow(input_x[6], 4);
        idvd_poly_feat[5896] = pow(input_x[1], 1) * pow(input_x[3], 1) * pow(input_x[4], 1) * pow(input_x[6], 5);
        idvd_poly_feat[5897] = pow(input_x[1], 1) * pow(input_x[3], 1) * pow(input_x[5], 6);
        idvd_poly_feat[5898] = pow(input_x[1], 1) * pow(input_x[3], 1) * pow(input_x[5], 5) * pow(input_x[6], 1);
        idvd_poly_feat[5899] = pow(input_x[1], 1) * pow(input_x[3], 1) * pow(input_x[5], 4) * pow(input_x[6], 2);
        idvd_poly_feat[5900] = pow(input_x[1], 1) * pow(input_x[3], 1) * pow(input_x[5], 3) * pow(input_x[6], 3);
        idvd_poly_feat[5901] = pow(input_x[1], 1) * pow(input_x[3], 1) * pow(input_x[5], 2) * pow(input_x[6], 4);
        idvd_poly_feat[5902] = pow(input_x[1], 1) * pow(input_x[3], 1) * pow(input_x[5], 1) * pow(input_x[6], 5);
        idvd_poly_feat[5903] = pow(input_x[1], 1) * pow(input_x[3], 1) * pow(input_x[6], 6);
        idvd_poly_feat[5904] = pow(input_x[1], 1) * pow(input_x[4], 7);
        idvd_poly_feat[5905] = pow(input_x[1], 1) * pow(input_x[4], 6) * pow(input_x[5], 1);
        idvd_poly_feat[5906] = pow(input_x[1], 1) * pow(input_x[4], 6) * pow(input_x[6], 1);
        idvd_poly_feat[5907] = pow(input_x[1], 1) * pow(input_x[4], 5) * pow(input_x[5], 2);
        idvd_poly_feat[5908] = pow(input_x[1], 1) * pow(input_x[4], 5) * pow(input_x[5], 1) * pow(input_x[6], 1);
        idvd_poly_feat[5909] = pow(input_x[1], 1) * pow(input_x[4], 5) * pow(input_x[6], 2);
        idvd_poly_feat[5910] = pow(input_x[1], 1) * pow(input_x[4], 4) * pow(input_x[5], 3);
        idvd_poly_feat[5911] = pow(input_x[1], 1) * pow(input_x[4], 4) * pow(input_x[5], 2) * pow(input_x[6], 1);
        idvd_poly_feat[5912] = pow(input_x[1], 1) * pow(input_x[4], 4) * pow(input_x[5], 1) * pow(input_x[6], 2);
        idvd_poly_feat[5913] = pow(input_x[1], 1) * pow(input_x[4], 4) * pow(input_x[6], 3);
        idvd_poly_feat[5914] = pow(input_x[1], 1) * pow(input_x[4], 3) * pow(input_x[5], 4);
        idvd_poly_feat[5915] = pow(input_x[1], 1) * pow(input_x[4], 3) * pow(input_x[5], 3) * pow(input_x[6], 1);
        idvd_poly_feat[5916] = pow(input_x[1], 1) * pow(input_x[4], 3) * pow(input_x[5], 2) * pow(input_x[6], 2);
        idvd_poly_feat[5917] = pow(input_x[1], 1) * pow(input_x[4], 3) * pow(input_x[5], 1) * pow(input_x[6], 3);
        idvd_poly_feat[5918] = pow(input_x[1], 1) * pow(input_x[4], 3) * pow(input_x[6], 4);
        idvd_poly_feat[5919] = pow(input_x[1], 1) * pow(input_x[4], 2) * pow(input_x[5], 5);
        idvd_poly_feat[5920] = pow(input_x[1], 1) * pow(input_x[4], 2) * pow(input_x[5], 4) * pow(input_x[6], 1);
        idvd_poly_feat[5921] = pow(input_x[1], 1) * pow(input_x[4], 2) * pow(input_x[5], 3) * pow(input_x[6], 2);
        idvd_poly_feat[5922] = pow(input_x[1], 1) * pow(input_x[4], 2) * pow(input_x[5], 2) * pow(input_x[6], 3);
        idvd_poly_feat[5923] = pow(input_x[1], 1) * pow(input_x[4], 2) * pow(input_x[5], 1) * pow(input_x[6], 4);
        idvd_poly_feat[5924] = pow(input_x[1], 1) * pow(input_x[4], 2) * pow(input_x[6], 5);
        idvd_poly_feat[5925] = pow(input_x[1], 1) * pow(input_x[4], 1) * pow(input_x[5], 6);
        idvd_poly_feat[5926] = pow(input_x[1], 1) * pow(input_x[4], 1) * pow(input_x[5], 5) * pow(input_x[6], 1);
        idvd_poly_feat[5927] = pow(input_x[1], 1) * pow(input_x[4], 1) * pow(input_x[5], 4) * pow(input_x[6], 2);
        idvd_poly_feat[5928] = pow(input_x[1], 1) * pow(input_x[4], 1) * pow(input_x[5], 3) * pow(input_x[6], 3);
        idvd_poly_feat[5929] = pow(input_x[1], 1) * pow(input_x[4], 1) * pow(input_x[5], 2) * pow(input_x[6], 4);
        idvd_poly_feat[5930] = pow(input_x[1], 1) * pow(input_x[4], 1) * pow(input_x[5], 1) * pow(input_x[6], 5);
        idvd_poly_feat[5931] = pow(input_x[1], 1) * pow(input_x[4], 1) * pow(input_x[6], 6);
        idvd_poly_feat[5932] = pow(input_x[1], 1) * pow(input_x[5], 7);
        idvd_poly_feat[5933] = pow(input_x[1], 1) * pow(input_x[5], 6) * pow(input_x[6], 1);
        idvd_poly_feat[5934] = pow(input_x[1], 1) * pow(input_x[5], 5) * pow(input_x[6], 2);
        idvd_poly_feat[5935] = pow(input_x[1], 1) * pow(input_x[5], 4) * pow(input_x[6], 3);
        idvd_poly_feat[5936] = pow(input_x[1], 1) * pow(input_x[5], 3) * pow(input_x[6], 4);
        idvd_poly_feat[5937] = pow(input_x[1], 1) * pow(input_x[5], 2) * pow(input_x[6], 5);
        idvd_poly_feat[5938] = pow(input_x[1], 1) * pow(input_x[5], 1) * pow(input_x[6], 6);
        idvd_poly_feat[5939] = pow(input_x[1], 1) * pow(input_x[6], 7);
        idvd_poly_feat[5940] = pow(input_x[2], 8);
        idvd_poly_feat[5941] = pow(input_x[2], 7) * pow(input_x[3], 1);
        idvd_poly_feat[5942] = pow(input_x[2], 7) * pow(input_x[4], 1);
        idvd_poly_feat[5943] = pow(input_x[2], 7) * pow(input_x[5], 1);
        idvd_poly_feat[5944] = pow(input_x[2], 7) * pow(input_x[6], 1);
        idvd_poly_feat[5945] = pow(input_x[2], 6) * pow(input_x[3], 2);
        idvd_poly_feat[5946] = pow(input_x[2], 6) * pow(input_x[3], 1) * pow(input_x[4], 1);
        idvd_poly_feat[5947] = pow(input_x[2], 6) * pow(input_x[3], 1) * pow(input_x[5], 1);
        idvd_poly_feat[5948] = pow(input_x[2], 6) * pow(input_x[3], 1) * pow(input_x[6], 1);
        idvd_poly_feat[5949] = pow(input_x[2], 6) * pow(input_x[4], 2);
        idvd_poly_feat[5950] = pow(input_x[2], 6) * pow(input_x[4], 1) * pow(input_x[5], 1);
        idvd_poly_feat[5951] = pow(input_x[2], 6) * pow(input_x[4], 1) * pow(input_x[6], 1);
        idvd_poly_feat[5952] = pow(input_x[2], 6) * pow(input_x[5], 2);
        idvd_poly_feat[5953] = pow(input_x[2], 6) * pow(input_x[5], 1) * pow(input_x[6], 1);
        idvd_poly_feat[5954] = pow(input_x[2], 6) * pow(input_x[6], 2);
        idvd_poly_feat[5955] = pow(input_x[2], 5) * pow(input_x[3], 3);
        idvd_poly_feat[5956] = pow(input_x[2], 5) * pow(input_x[3], 2) * pow(input_x[4], 1);
        idvd_poly_feat[5957] = pow(input_x[2], 5) * pow(input_x[3], 2) * pow(input_x[5], 1);
        idvd_poly_feat[5958] = pow(input_x[2], 5) * pow(input_x[3], 2) * pow(input_x[6], 1);
        idvd_poly_feat[5959] = pow(input_x[2], 5) * pow(input_x[3], 1) * pow(input_x[4], 2);
        idvd_poly_feat[5960] = pow(input_x[2], 5) * pow(input_x[3], 1) * pow(input_x[4], 1) * pow(input_x[5], 1);
        idvd_poly_feat[5961] = pow(input_x[2], 5) * pow(input_x[3], 1) * pow(input_x[4], 1) * pow(input_x[6], 1);
        idvd_poly_feat[5962] = pow(input_x[2], 5) * pow(input_x[3], 1) * pow(input_x[5], 2);
        idvd_poly_feat[5963] = pow(input_x[2], 5) * pow(input_x[3], 1) * pow(input_x[5], 1) * pow(input_x[6], 1);
        idvd_poly_feat[5964] = pow(input_x[2], 5) * pow(input_x[3], 1) * pow(input_x[6], 2);
        idvd_poly_feat[5965] = pow(input_x[2], 5) * pow(input_x[4], 3);
        idvd_poly_feat[5966] = pow(input_x[2], 5) * pow(input_x[4], 2) * pow(input_x[5], 1);
        idvd_poly_feat[5967] = pow(input_x[2], 5) * pow(input_x[4], 2) * pow(input_x[6], 1);
        idvd_poly_feat[5968] = pow(input_x[2], 5) * pow(input_x[4], 1) * pow(input_x[5], 2);
        idvd_poly_feat[5969] = pow(input_x[2], 5) * pow(input_x[4], 1) * pow(input_x[5], 1) * pow(input_x[6], 1);
        idvd_poly_feat[5970] = pow(input_x[2], 5) * pow(input_x[4], 1) * pow(input_x[6], 2);
        idvd_poly_feat[5971] = pow(input_x[2], 5) * pow(input_x[5], 3);
        idvd_poly_feat[5972] = pow(input_x[2], 5) * pow(input_x[5], 2) * pow(input_x[6], 1);
        idvd_poly_feat[5973] = pow(input_x[2], 5) * pow(input_x[5], 1) * pow(input_x[6], 2);
        idvd_poly_feat[5974] = pow(input_x[2], 5) * pow(input_x[6], 3);
        idvd_poly_feat[5975] = pow(input_x[2], 4) * pow(input_x[3], 4);
        idvd_poly_feat[5976] = pow(input_x[2], 4) * pow(input_x[3], 3) * pow(input_x[4], 1);
        idvd_poly_feat[5977] = pow(input_x[2], 4) * pow(input_x[3], 3) * pow(input_x[5], 1);
        idvd_poly_feat[5978] = pow(input_x[2], 4) * pow(input_x[3], 3) * pow(input_x[6], 1);
        idvd_poly_feat[5979] = pow(input_x[2], 4) * pow(input_x[3], 2) * pow(input_x[4], 2);
        idvd_poly_feat[5980] = pow(input_x[2], 4) * pow(input_x[3], 2) * pow(input_x[4], 1) * pow(input_x[5], 1);
        idvd_poly_feat[5981] = pow(input_x[2], 4) * pow(input_x[3], 2) * pow(input_x[4], 1) * pow(input_x[6], 1);
        idvd_poly_feat[5982] = pow(input_x[2], 4) * pow(input_x[3], 2) * pow(input_x[5], 2);
        idvd_poly_feat[5983] = pow(input_x[2], 4) * pow(input_x[3], 2) * pow(input_x[5], 1) * pow(input_x[6], 1);
        idvd_poly_feat[5984] = pow(input_x[2], 4) * pow(input_x[3], 2) * pow(input_x[6], 2);
        idvd_poly_feat[5985] = pow(input_x[2], 4) * pow(input_x[3], 1) * pow(input_x[4], 3);
        idvd_poly_feat[5986] = pow(input_x[2], 4) * pow(input_x[3], 1) * pow(input_x[4], 2) * pow(input_x[5], 1);
        idvd_poly_feat[5987] = pow(input_x[2], 4) * pow(input_x[3], 1) * pow(input_x[4], 2) * pow(input_x[6], 1);
        idvd_poly_feat[5988] = pow(input_x[2], 4) * pow(input_x[3], 1) * pow(input_x[4], 1) * pow(input_x[5], 2);
        idvd_poly_feat[5989] = pow(input_x[2], 4) * pow(input_x[3], 1) * pow(input_x[4], 1) * pow(input_x[5], 1) * pow(input_x[6], 1);
        idvd_poly_feat[5990] = pow(input_x[2], 4) * pow(input_x[3], 1) * pow(input_x[4], 1) * pow(input_x[6], 2);
        idvd_poly_feat[5991] = pow(input_x[2], 4) * pow(input_x[3], 1) * pow(input_x[5], 3);
        idvd_poly_feat[5992] = pow(input_x[2], 4) * pow(input_x[3], 1) * pow(input_x[5], 2) * pow(input_x[6], 1);
        idvd_poly_feat[5993] = pow(input_x[2], 4) * pow(input_x[3], 1) * pow(input_x[5], 1) * pow(input_x[6], 2);
        idvd_poly_feat[5994] = pow(input_x[2], 4) * pow(input_x[3], 1) * pow(input_x[6], 3);
        idvd_poly_feat[5995] = pow(input_x[2], 4) * pow(input_x[4], 4);
        idvd_poly_feat[5996] = pow(input_x[2], 4) * pow(input_x[4], 3) * pow(input_x[5], 1);
        idvd_poly_feat[5997] = pow(input_x[2], 4) * pow(input_x[4], 3) * pow(input_x[6], 1);
        idvd_poly_feat[5998] = pow(input_x[2], 4) * pow(input_x[4], 2) * pow(input_x[5], 2);
        idvd_poly_feat[5999] = pow(input_x[2], 4) * pow(input_x[4], 2) * pow(input_x[5], 1) * pow(input_x[6], 1);
        idvd_poly_feat[6000] = pow(input_x[2], 4) * pow(input_x[4], 2) * pow(input_x[6], 2);
        idvd_poly_feat[6001] = pow(input_x[2], 4) * pow(input_x[4], 1) * pow(input_x[5], 3);
        idvd_poly_feat[6002] = pow(input_x[2], 4) * pow(input_x[4], 1) * pow(input_x[5], 2) * pow(input_x[6], 1);
        idvd_poly_feat[6003] = pow(input_x[2], 4) * pow(input_x[4], 1) * pow(input_x[5], 1) * pow(input_x[6], 2);
        idvd_poly_feat[6004] = pow(input_x[2], 4) * pow(input_x[4], 1) * pow(input_x[6], 3);
        idvd_poly_feat[6005] = pow(input_x[2], 4) * pow(input_x[5], 4);
        idvd_poly_feat[6006] = pow(input_x[2], 4) * pow(input_x[5], 3) * pow(input_x[6], 1);
        idvd_poly_feat[6007] = pow(input_x[2], 4) * pow(input_x[5], 2) * pow(input_x[6], 2);
        idvd_poly_feat[6008] = pow(input_x[2], 4) * pow(input_x[5], 1) * pow(input_x[6], 3);
        idvd_poly_feat[6009] = pow(input_x[2], 4) * pow(input_x[6], 4);
        idvd_poly_feat[6010] = pow(input_x[2], 3) * pow(input_x[3], 5);
        idvd_poly_feat[6011] = pow(input_x[2], 3) * pow(input_x[3], 4) * pow(input_x[4], 1);
        idvd_poly_feat[6012] = pow(input_x[2], 3) * pow(input_x[3], 4) * pow(input_x[5], 1);
        idvd_poly_feat[6013] = pow(input_x[2], 3) * pow(input_x[3], 4) * pow(input_x[6], 1);
        idvd_poly_feat[6014] = pow(input_x[2], 3) * pow(input_x[3], 3) * pow(input_x[4], 2);
        idvd_poly_feat[6015] = pow(input_x[2], 3) * pow(input_x[3], 3) * pow(input_x[4], 1) * pow(input_x[5], 1);
        idvd_poly_feat[6016] = pow(input_x[2], 3) * pow(input_x[3], 3) * pow(input_x[4], 1) * pow(input_x[6], 1);
        idvd_poly_feat[6017] = pow(input_x[2], 3) * pow(input_x[3], 3) * pow(input_x[5], 2);
        idvd_poly_feat[6018] = pow(input_x[2], 3) * pow(input_x[3], 3) * pow(input_x[5], 1) * pow(input_x[6], 1);
        idvd_poly_feat[6019] = pow(input_x[2], 3) * pow(input_x[3], 3) * pow(input_x[6], 2);
        idvd_poly_feat[6020] = pow(input_x[2], 3) * pow(input_x[3], 2) * pow(input_x[4], 3);
        idvd_poly_feat[6021] = pow(input_x[2], 3) * pow(input_x[3], 2) * pow(input_x[4], 2) * pow(input_x[5], 1);
        idvd_poly_feat[6022] = pow(input_x[2], 3) * pow(input_x[3], 2) * pow(input_x[4], 2) * pow(input_x[6], 1);
        idvd_poly_feat[6023] = pow(input_x[2], 3) * pow(input_x[3], 2) * pow(input_x[4], 1) * pow(input_x[5], 2);
        idvd_poly_feat[6024] = pow(input_x[2], 3) * pow(input_x[3], 2) * pow(input_x[4], 1) * pow(input_x[5], 1) * pow(input_x[6], 1);
        idvd_poly_feat[6025] = pow(input_x[2], 3) * pow(input_x[3], 2) * pow(input_x[4], 1) * pow(input_x[6], 2);
        idvd_poly_feat[6026] = pow(input_x[2], 3) * pow(input_x[3], 2) * pow(input_x[5], 3);
        idvd_poly_feat[6027] = pow(input_x[2], 3) * pow(input_x[3], 2) * pow(input_x[5], 2) * pow(input_x[6], 1);
        idvd_poly_feat[6028] = pow(input_x[2], 3) * pow(input_x[3], 2) * pow(input_x[5], 1) * pow(input_x[6], 2);
        idvd_poly_feat[6029] = pow(input_x[2], 3) * pow(input_x[3], 2) * pow(input_x[6], 3);
        idvd_poly_feat[6030] = pow(input_x[2], 3) * pow(input_x[3], 1) * pow(input_x[4], 4);
        idvd_poly_feat[6031] = pow(input_x[2], 3) * pow(input_x[3], 1) * pow(input_x[4], 3) * pow(input_x[5], 1);
        idvd_poly_feat[6032] = pow(input_x[2], 3) * pow(input_x[3], 1) * pow(input_x[4], 3) * pow(input_x[6], 1);
        idvd_poly_feat[6033] = pow(input_x[2], 3) * pow(input_x[3], 1) * pow(input_x[4], 2) * pow(input_x[5], 2);
        idvd_poly_feat[6034] = pow(input_x[2], 3) * pow(input_x[3], 1) * pow(input_x[4], 2) * pow(input_x[5], 1) * pow(input_x[6], 1);
        idvd_poly_feat[6035] = pow(input_x[2], 3) * pow(input_x[3], 1) * pow(input_x[4], 2) * pow(input_x[6], 2);
        idvd_poly_feat[6036] = pow(input_x[2], 3) * pow(input_x[3], 1) * pow(input_x[4], 1) * pow(input_x[5], 3);
        idvd_poly_feat[6037] = pow(input_x[2], 3) * pow(input_x[3], 1) * pow(input_x[4], 1) * pow(input_x[5], 2) * pow(input_x[6], 1);
        idvd_poly_feat[6038] = pow(input_x[2], 3) * pow(input_x[3], 1) * pow(input_x[4], 1) * pow(input_x[5], 1) * pow(input_x[6], 2);
        idvd_poly_feat[6039] = pow(input_x[2], 3) * pow(input_x[3], 1) * pow(input_x[4], 1) * pow(input_x[6], 3);
        idvd_poly_feat[6040] = pow(input_x[2], 3) * pow(input_x[3], 1) * pow(input_x[5], 4);
        idvd_poly_feat[6041] = pow(input_x[2], 3) * pow(input_x[3], 1) * pow(input_x[5], 3) * pow(input_x[6], 1);
        idvd_poly_feat[6042] = pow(input_x[2], 3) * pow(input_x[3], 1) * pow(input_x[5], 2) * pow(input_x[6], 2);
        idvd_poly_feat[6043] = pow(input_x[2], 3) * pow(input_x[3], 1) * pow(input_x[5], 1) * pow(input_x[6], 3);
        idvd_poly_feat[6044] = pow(input_x[2], 3) * pow(input_x[3], 1) * pow(input_x[6], 4);
        idvd_poly_feat[6045] = pow(input_x[2], 3) * pow(input_x[4], 5);
        idvd_poly_feat[6046] = pow(input_x[2], 3) * pow(input_x[4], 4) * pow(input_x[5], 1);
        idvd_poly_feat[6047] = pow(input_x[2], 3) * pow(input_x[4], 4) * pow(input_x[6], 1);
        idvd_poly_feat[6048] = pow(input_x[2], 3) * pow(input_x[4], 3) * pow(input_x[5], 2);
        idvd_poly_feat[6049] = pow(input_x[2], 3) * pow(input_x[4], 3) * pow(input_x[5], 1) * pow(input_x[6], 1);
        idvd_poly_feat[6050] = pow(input_x[2], 3) * pow(input_x[4], 3) * pow(input_x[6], 2);
        idvd_poly_feat[6051] = pow(input_x[2], 3) * pow(input_x[4], 2) * pow(input_x[5], 3);
        idvd_poly_feat[6052] = pow(input_x[2], 3) * pow(input_x[4], 2) * pow(input_x[5], 2) * pow(input_x[6], 1);
        idvd_poly_feat[6053] = pow(input_x[2], 3) * pow(input_x[4], 2) * pow(input_x[5], 1) * pow(input_x[6], 2);
        idvd_poly_feat[6054] = pow(input_x[2], 3) * pow(input_x[4], 2) * pow(input_x[6], 3);
        idvd_poly_feat[6055] = pow(input_x[2], 3) * pow(input_x[4], 1) * pow(input_x[5], 4);
        idvd_poly_feat[6056] = pow(input_x[2], 3) * pow(input_x[4], 1) * pow(input_x[5], 3) * pow(input_x[6], 1);
        idvd_poly_feat[6057] = pow(input_x[2], 3) * pow(input_x[4], 1) * pow(input_x[5], 2) * pow(input_x[6], 2);
        idvd_poly_feat[6058] = pow(input_x[2], 3) * pow(input_x[4], 1) * pow(input_x[5], 1) * pow(input_x[6], 3);
        idvd_poly_feat[6059] = pow(input_x[2], 3) * pow(input_x[4], 1) * pow(input_x[6], 4);
        idvd_poly_feat[6060] = pow(input_x[2], 3) * pow(input_x[5], 5);
        idvd_poly_feat[6061] = pow(input_x[2], 3) * pow(input_x[5], 4) * pow(input_x[6], 1);
        idvd_poly_feat[6062] = pow(input_x[2], 3) * pow(input_x[5], 3) * pow(input_x[6], 2);
        idvd_poly_feat[6063] = pow(input_x[2], 3) * pow(input_x[5], 2) * pow(input_x[6], 3);
        idvd_poly_feat[6064] = pow(input_x[2], 3) * pow(input_x[5], 1) * pow(input_x[6], 4);
        idvd_poly_feat[6065] = pow(input_x[2], 3) * pow(input_x[6], 5);
        idvd_poly_feat[6066] = pow(input_x[2], 2) * pow(input_x[3], 6);
        idvd_poly_feat[6067] = pow(input_x[2], 2) * pow(input_x[3], 5) * pow(input_x[4], 1);
        idvd_poly_feat[6068] = pow(input_x[2], 2) * pow(input_x[3], 5) * pow(input_x[5], 1);
        idvd_poly_feat[6069] = pow(input_x[2], 2) * pow(input_x[3], 5) * pow(input_x[6], 1);
        idvd_poly_feat[6070] = pow(input_x[2], 2) * pow(input_x[3], 4) * pow(input_x[4], 2);
        idvd_poly_feat[6071] = pow(input_x[2], 2) * pow(input_x[3], 4) * pow(input_x[4], 1) * pow(input_x[5], 1);
        idvd_poly_feat[6072] = pow(input_x[2], 2) * pow(input_x[3], 4) * pow(input_x[4], 1) * pow(input_x[6], 1);
        idvd_poly_feat[6073] = pow(input_x[2], 2) * pow(input_x[3], 4) * pow(input_x[5], 2);
        idvd_poly_feat[6074] = pow(input_x[2], 2) * pow(input_x[3], 4) * pow(input_x[5], 1) * pow(input_x[6], 1);
        idvd_poly_feat[6075] = pow(input_x[2], 2) * pow(input_x[3], 4) * pow(input_x[6], 2);
        idvd_poly_feat[6076] = pow(input_x[2], 2) * pow(input_x[3], 3) * pow(input_x[4], 3);
        idvd_poly_feat[6077] = pow(input_x[2], 2) * pow(input_x[3], 3) * pow(input_x[4], 2) * pow(input_x[5], 1);
        idvd_poly_feat[6078] = pow(input_x[2], 2) * pow(input_x[3], 3) * pow(input_x[4], 2) * pow(input_x[6], 1);
        idvd_poly_feat[6079] = pow(input_x[2], 2) * pow(input_x[3], 3) * pow(input_x[4], 1) * pow(input_x[5], 2);
        idvd_poly_feat[6080] = pow(input_x[2], 2) * pow(input_x[3], 3) * pow(input_x[4], 1) * pow(input_x[5], 1) * pow(input_x[6], 1);
        idvd_poly_feat[6081] = pow(input_x[2], 2) * pow(input_x[3], 3) * pow(input_x[4], 1) * pow(input_x[6], 2);
        idvd_poly_feat[6082] = pow(input_x[2], 2) * pow(input_x[3], 3) * pow(input_x[5], 3);
        idvd_poly_feat[6083] = pow(input_x[2], 2) * pow(input_x[3], 3) * pow(input_x[5], 2) * pow(input_x[6], 1);
        idvd_poly_feat[6084] = pow(input_x[2], 2) * pow(input_x[3], 3) * pow(input_x[5], 1) * pow(input_x[6], 2);
        idvd_poly_feat[6085] = pow(input_x[2], 2) * pow(input_x[3], 3) * pow(input_x[6], 3);
        idvd_poly_feat[6086] = pow(input_x[2], 2) * pow(input_x[3], 2) * pow(input_x[4], 4);
        idvd_poly_feat[6087] = pow(input_x[2], 2) * pow(input_x[3], 2) * pow(input_x[4], 3) * pow(input_x[5], 1);
        idvd_poly_feat[6088] = pow(input_x[2], 2) * pow(input_x[3], 2) * pow(input_x[4], 3) * pow(input_x[6], 1);
        idvd_poly_feat[6089] = pow(input_x[2], 2) * pow(input_x[3], 2) * pow(input_x[4], 2) * pow(input_x[5], 2);
        idvd_poly_feat[6090] = pow(input_x[2], 2) * pow(input_x[3], 2) * pow(input_x[4], 2) * pow(input_x[5], 1) * pow(input_x[6], 1);
        idvd_poly_feat[6091] = pow(input_x[2], 2) * pow(input_x[3], 2) * pow(input_x[4], 2) * pow(input_x[6], 2);
        idvd_poly_feat[6092] = pow(input_x[2], 2) * pow(input_x[3], 2) * pow(input_x[4], 1) * pow(input_x[5], 3);
        idvd_poly_feat[6093] = pow(input_x[2], 2) * pow(input_x[3], 2) * pow(input_x[4], 1) * pow(input_x[5], 2) * pow(input_x[6], 1);
        idvd_poly_feat[6094] = pow(input_x[2], 2) * pow(input_x[3], 2) * pow(input_x[4], 1) * pow(input_x[5], 1) * pow(input_x[6], 2);
        idvd_poly_feat[6095] = pow(input_x[2], 2) * pow(input_x[3], 2) * pow(input_x[4], 1) * pow(input_x[6], 3);
        idvd_poly_feat[6096] = pow(input_x[2], 2) * pow(input_x[3], 2) * pow(input_x[5], 4);
        idvd_poly_feat[6097] = pow(input_x[2], 2) * pow(input_x[3], 2) * pow(input_x[5], 3) * pow(input_x[6], 1);
        idvd_poly_feat[6098] = pow(input_x[2], 2) * pow(input_x[3], 2) * pow(input_x[5], 2) * pow(input_x[6], 2);
        idvd_poly_feat[6099] = pow(input_x[2], 2) * pow(input_x[3], 2) * pow(input_x[5], 1) * pow(input_x[6], 3);
        idvd_poly_feat[6100] = pow(input_x[2], 2) * pow(input_x[3], 2) * pow(input_x[6], 4);
        idvd_poly_feat[6101] = pow(input_x[2], 2) * pow(input_x[3], 1) * pow(input_x[4], 5);
        idvd_poly_feat[6102] = pow(input_x[2], 2) * pow(input_x[3], 1) * pow(input_x[4], 4) * pow(input_x[5], 1);
        idvd_poly_feat[6103] = pow(input_x[2], 2) * pow(input_x[3], 1) * pow(input_x[4], 4) * pow(input_x[6], 1);
        idvd_poly_feat[6104] = pow(input_x[2], 2) * pow(input_x[3], 1) * pow(input_x[4], 3) * pow(input_x[5], 2);
        idvd_poly_feat[6105] = pow(input_x[2], 2) * pow(input_x[3], 1) * pow(input_x[4], 3) * pow(input_x[5], 1) * pow(input_x[6], 1);
        idvd_poly_feat[6106] = pow(input_x[2], 2) * pow(input_x[3], 1) * pow(input_x[4], 3) * pow(input_x[6], 2);
        idvd_poly_feat[6107] = pow(input_x[2], 2) * pow(input_x[3], 1) * pow(input_x[4], 2) * pow(input_x[5], 3);
        idvd_poly_feat[6108] = pow(input_x[2], 2) * pow(input_x[3], 1) * pow(input_x[4], 2) * pow(input_x[5], 2) * pow(input_x[6], 1);
        idvd_poly_feat[6109] = pow(input_x[2], 2) * pow(input_x[3], 1) * pow(input_x[4], 2) * pow(input_x[5], 1) * pow(input_x[6], 2);
        idvd_poly_feat[6110] = pow(input_x[2], 2) * pow(input_x[3], 1) * pow(input_x[4], 2) * pow(input_x[6], 3);
        idvd_poly_feat[6111] = pow(input_x[2], 2) * pow(input_x[3], 1) * pow(input_x[4], 1) * pow(input_x[5], 4);
        idvd_poly_feat[6112] = pow(input_x[2], 2) * pow(input_x[3], 1) * pow(input_x[4], 1) * pow(input_x[5], 3) * pow(input_x[6], 1);
        idvd_poly_feat[6113] = pow(input_x[2], 2) * pow(input_x[3], 1) * pow(input_x[4], 1) * pow(input_x[5], 2) * pow(input_x[6], 2);
        idvd_poly_feat[6114] = pow(input_x[2], 2) * pow(input_x[3], 1) * pow(input_x[4], 1) * pow(input_x[5], 1) * pow(input_x[6], 3);
        idvd_poly_feat[6115] = pow(input_x[2], 2) * pow(input_x[3], 1) * pow(input_x[4], 1) * pow(input_x[6], 4);
        idvd_poly_feat[6116] = pow(input_x[2], 2) * pow(input_x[3], 1) * pow(input_x[5], 5);
        idvd_poly_feat[6117] = pow(input_x[2], 2) * pow(input_x[3], 1) * pow(input_x[5], 4) * pow(input_x[6], 1);
        idvd_poly_feat[6118] = pow(input_x[2], 2) * pow(input_x[3], 1) * pow(input_x[5], 3) * pow(input_x[6], 2);
        idvd_poly_feat[6119] = pow(input_x[2], 2) * pow(input_x[3], 1) * pow(input_x[5], 2) * pow(input_x[6], 3);
        idvd_poly_feat[6120] = pow(input_x[2], 2) * pow(input_x[3], 1) * pow(input_x[5], 1) * pow(input_x[6], 4);
        idvd_poly_feat[6121] = pow(input_x[2], 2) * pow(input_x[3], 1) * pow(input_x[6], 5);
        idvd_poly_feat[6122] = pow(input_x[2], 2) * pow(input_x[4], 6);
        idvd_poly_feat[6123] = pow(input_x[2], 2) * pow(input_x[4], 5) * pow(input_x[5], 1);
        idvd_poly_feat[6124] = pow(input_x[2], 2) * pow(input_x[4], 5) * pow(input_x[6], 1);
        idvd_poly_feat[6125] = pow(input_x[2], 2) * pow(input_x[4], 4) * pow(input_x[5], 2);
        idvd_poly_feat[6126] = pow(input_x[2], 2) * pow(input_x[4], 4) * pow(input_x[5], 1) * pow(input_x[6], 1);
        idvd_poly_feat[6127] = pow(input_x[2], 2) * pow(input_x[4], 4) * pow(input_x[6], 2);
        idvd_poly_feat[6128] = pow(input_x[2], 2) * pow(input_x[4], 3) * pow(input_x[5], 3);
        idvd_poly_feat[6129] = pow(input_x[2], 2) * pow(input_x[4], 3) * pow(input_x[5], 2) * pow(input_x[6], 1);
        idvd_poly_feat[6130] = pow(input_x[2], 2) * pow(input_x[4], 3) * pow(input_x[5], 1) * pow(input_x[6], 2);
        idvd_poly_feat[6131] = pow(input_x[2], 2) * pow(input_x[4], 3) * pow(input_x[6], 3);
        idvd_poly_feat[6132] = pow(input_x[2], 2) * pow(input_x[4], 2) * pow(input_x[5], 4);
        idvd_poly_feat[6133] = pow(input_x[2], 2) * pow(input_x[4], 2) * pow(input_x[5], 3) * pow(input_x[6], 1);
        idvd_poly_feat[6134] = pow(input_x[2], 2) * pow(input_x[4], 2) * pow(input_x[5], 2) * pow(input_x[6], 2);
        idvd_poly_feat[6135] = pow(input_x[2], 2) * pow(input_x[4], 2) * pow(input_x[5], 1) * pow(input_x[6], 3);
        idvd_poly_feat[6136] = pow(input_x[2], 2) * pow(input_x[4], 2) * pow(input_x[6], 4);
        idvd_poly_feat[6137] = pow(input_x[2], 2) * pow(input_x[4], 1) * pow(input_x[5], 5);
        idvd_poly_feat[6138] = pow(input_x[2], 2) * pow(input_x[4], 1) * pow(input_x[5], 4) * pow(input_x[6], 1);
        idvd_poly_feat[6139] = pow(input_x[2], 2) * pow(input_x[4], 1) * pow(input_x[5], 3) * pow(input_x[6], 2);
        idvd_poly_feat[6140] = pow(input_x[2], 2) * pow(input_x[4], 1) * pow(input_x[5], 2) * pow(input_x[6], 3);
        idvd_poly_feat[6141] = pow(input_x[2], 2) * pow(input_x[4], 1) * pow(input_x[5], 1) * pow(input_x[6], 4);
        idvd_poly_feat[6142] = pow(input_x[2], 2) * pow(input_x[4], 1) * pow(input_x[6], 5);
        idvd_poly_feat[6143] = pow(input_x[2], 2) * pow(input_x[5], 6);
        idvd_poly_feat[6144] = pow(input_x[2], 2) * pow(input_x[5], 5) * pow(input_x[6], 1);
        idvd_poly_feat[6145] = pow(input_x[2], 2) * pow(input_x[5], 4) * pow(input_x[6], 2);
        idvd_poly_feat[6146] = pow(input_x[2], 2) * pow(input_x[5], 3) * pow(input_x[6], 3);
        idvd_poly_feat[6147] = pow(input_x[2], 2) * pow(input_x[5], 2) * pow(input_x[6], 4);
        idvd_poly_feat[6148] = pow(input_x[2], 2) * pow(input_x[5], 1) * pow(input_x[6], 5);
        idvd_poly_feat[6149] = pow(input_x[2], 2) * pow(input_x[6], 6);
        idvd_poly_feat[6150] = pow(input_x[2], 1) * pow(input_x[3], 7);
        idvd_poly_feat[6151] = pow(input_x[2], 1) * pow(input_x[3], 6) * pow(input_x[4], 1);
        idvd_poly_feat[6152] = pow(input_x[2], 1) * pow(input_x[3], 6) * pow(input_x[5], 1);
        idvd_poly_feat[6153] = pow(input_x[2], 1) * pow(input_x[3], 6) * pow(input_x[6], 1);
        idvd_poly_feat[6154] = pow(input_x[2], 1) * pow(input_x[3], 5) * pow(input_x[4], 2);
        idvd_poly_feat[6155] = pow(input_x[2], 1) * pow(input_x[3], 5) * pow(input_x[4], 1) * pow(input_x[5], 1);
        idvd_poly_feat[6156] = pow(input_x[2], 1) * pow(input_x[3], 5) * pow(input_x[4], 1) * pow(input_x[6], 1);
        idvd_poly_feat[6157] = pow(input_x[2], 1) * pow(input_x[3], 5) * pow(input_x[5], 2);
        idvd_poly_feat[6158] = pow(input_x[2], 1) * pow(input_x[3], 5) * pow(input_x[5], 1) * pow(input_x[6], 1);
        idvd_poly_feat[6159] = pow(input_x[2], 1) * pow(input_x[3], 5) * pow(input_x[6], 2);
        idvd_poly_feat[6160] = pow(input_x[2], 1) * pow(input_x[3], 4) * pow(input_x[4], 3);
        idvd_poly_feat[6161] = pow(input_x[2], 1) * pow(input_x[3], 4) * pow(input_x[4], 2) * pow(input_x[5], 1);
        idvd_poly_feat[6162] = pow(input_x[2], 1) * pow(input_x[3], 4) * pow(input_x[4], 2) * pow(input_x[6], 1);
        idvd_poly_feat[6163] = pow(input_x[2], 1) * pow(input_x[3], 4) * pow(input_x[4], 1) * pow(input_x[5], 2);
        idvd_poly_feat[6164] = pow(input_x[2], 1) * pow(input_x[3], 4) * pow(input_x[4], 1) * pow(input_x[5], 1) * pow(input_x[6], 1);
        idvd_poly_feat[6165] = pow(input_x[2], 1) * pow(input_x[3], 4) * pow(input_x[4], 1) * pow(input_x[6], 2);
        idvd_poly_feat[6166] = pow(input_x[2], 1) * pow(input_x[3], 4) * pow(input_x[5], 3);
        idvd_poly_feat[6167] = pow(input_x[2], 1) * pow(input_x[3], 4) * pow(input_x[5], 2) * pow(input_x[6], 1);
        idvd_poly_feat[6168] = pow(input_x[2], 1) * pow(input_x[3], 4) * pow(input_x[5], 1) * pow(input_x[6], 2);
        idvd_poly_feat[6169] = pow(input_x[2], 1) * pow(input_x[3], 4) * pow(input_x[6], 3);
        idvd_poly_feat[6170] = pow(input_x[2], 1) * pow(input_x[3], 3) * pow(input_x[4], 4);
        idvd_poly_feat[6171] = pow(input_x[2], 1) * pow(input_x[3], 3) * pow(input_x[4], 3) * pow(input_x[5], 1);
        idvd_poly_feat[6172] = pow(input_x[2], 1) * pow(input_x[3], 3) * pow(input_x[4], 3) * pow(input_x[6], 1);
        idvd_poly_feat[6173] = pow(input_x[2], 1) * pow(input_x[3], 3) * pow(input_x[4], 2) * pow(input_x[5], 2);
        idvd_poly_feat[6174] = pow(input_x[2], 1) * pow(input_x[3], 3) * pow(input_x[4], 2) * pow(input_x[5], 1) * pow(input_x[6], 1);
        idvd_poly_feat[6175] = pow(input_x[2], 1) * pow(input_x[3], 3) * pow(input_x[4], 2) * pow(input_x[6], 2);
        idvd_poly_feat[6176] = pow(input_x[2], 1) * pow(input_x[3], 3) * pow(input_x[4], 1) * pow(input_x[5], 3);
        idvd_poly_feat[6177] = pow(input_x[2], 1) * pow(input_x[3], 3) * pow(input_x[4], 1) * pow(input_x[5], 2) * pow(input_x[6], 1);
        idvd_poly_feat[6178] = pow(input_x[2], 1) * pow(input_x[3], 3) * pow(input_x[4], 1) * pow(input_x[5], 1) * pow(input_x[6], 2);
        idvd_poly_feat[6179] = pow(input_x[2], 1) * pow(input_x[3], 3) * pow(input_x[4], 1) * pow(input_x[6], 3);
        idvd_poly_feat[6180] = pow(input_x[2], 1) * pow(input_x[3], 3) * pow(input_x[5], 4);
        idvd_poly_feat[6181] = pow(input_x[2], 1) * pow(input_x[3], 3) * pow(input_x[5], 3) * pow(input_x[6], 1);
        idvd_poly_feat[6182] = pow(input_x[2], 1) * pow(input_x[3], 3) * pow(input_x[5], 2) * pow(input_x[6], 2);
        idvd_poly_feat[6183] = pow(input_x[2], 1) * pow(input_x[3], 3) * pow(input_x[5], 1) * pow(input_x[6], 3);
        idvd_poly_feat[6184] = pow(input_x[2], 1) * pow(input_x[3], 3) * pow(input_x[6], 4);
        idvd_poly_feat[6185] = pow(input_x[2], 1) * pow(input_x[3], 2) * pow(input_x[4], 5);
        idvd_poly_feat[6186] = pow(input_x[2], 1) * pow(input_x[3], 2) * pow(input_x[4], 4) * pow(input_x[5], 1);
        idvd_poly_feat[6187] = pow(input_x[2], 1) * pow(input_x[3], 2) * pow(input_x[4], 4) * pow(input_x[6], 1);
        idvd_poly_feat[6188] = pow(input_x[2], 1) * pow(input_x[3], 2) * pow(input_x[4], 3) * pow(input_x[5], 2);
        idvd_poly_feat[6189] = pow(input_x[2], 1) * pow(input_x[3], 2) * pow(input_x[4], 3) * pow(input_x[5], 1) * pow(input_x[6], 1);
        idvd_poly_feat[6190] = pow(input_x[2], 1) * pow(input_x[3], 2) * pow(input_x[4], 3) * pow(input_x[6], 2);
        idvd_poly_feat[6191] = pow(input_x[2], 1) * pow(input_x[3], 2) * pow(input_x[4], 2) * pow(input_x[5], 3);
        idvd_poly_feat[6192] = pow(input_x[2], 1) * pow(input_x[3], 2) * pow(input_x[4], 2) * pow(input_x[5], 2) * pow(input_x[6], 1);
        idvd_poly_feat[6193] = pow(input_x[2], 1) * pow(input_x[3], 2) * pow(input_x[4], 2) * pow(input_x[5], 1) * pow(input_x[6], 2);
        idvd_poly_feat[6194] = pow(input_x[2], 1) * pow(input_x[3], 2) * pow(input_x[4], 2) * pow(input_x[6], 3);
        idvd_poly_feat[6195] = pow(input_x[2], 1) * pow(input_x[3], 2) * pow(input_x[4], 1) * pow(input_x[5], 4);
        idvd_poly_feat[6196] = pow(input_x[2], 1) * pow(input_x[3], 2) * pow(input_x[4], 1) * pow(input_x[5], 3) * pow(input_x[6], 1);
        idvd_poly_feat[6197] = pow(input_x[2], 1) * pow(input_x[3], 2) * pow(input_x[4], 1) * pow(input_x[5], 2) * pow(input_x[6], 2);
        idvd_poly_feat[6198] = pow(input_x[2], 1) * pow(input_x[3], 2) * pow(input_x[4], 1) * pow(input_x[5], 1) * pow(input_x[6], 3);
        idvd_poly_feat[6199] = pow(input_x[2], 1) * pow(input_x[3], 2) * pow(input_x[4], 1) * pow(input_x[6], 4);
        idvd_poly_feat[6200] = pow(input_x[2], 1) * pow(input_x[3], 2) * pow(input_x[5], 5);
        idvd_poly_feat[6201] = pow(input_x[2], 1) * pow(input_x[3], 2) * pow(input_x[5], 4) * pow(input_x[6], 1);
        idvd_poly_feat[6202] = pow(input_x[2], 1) * pow(input_x[3], 2) * pow(input_x[5], 3) * pow(input_x[6], 2);
        idvd_poly_feat[6203] = pow(input_x[2], 1) * pow(input_x[3], 2) * pow(input_x[5], 2) * pow(input_x[6], 3);
        idvd_poly_feat[6204] = pow(input_x[2], 1) * pow(input_x[3], 2) * pow(input_x[5], 1) * pow(input_x[6], 4);
        idvd_poly_feat[6205] = pow(input_x[2], 1) * pow(input_x[3], 2) * pow(input_x[6], 5);
        idvd_poly_feat[6206] = pow(input_x[2], 1) * pow(input_x[3], 1) * pow(input_x[4], 6);
        idvd_poly_feat[6207] = pow(input_x[2], 1) * pow(input_x[3], 1) * pow(input_x[4], 5) * pow(input_x[5], 1);
        idvd_poly_feat[6208] = pow(input_x[2], 1) * pow(input_x[3], 1) * pow(input_x[4], 5) * pow(input_x[6], 1);
        idvd_poly_feat[6209] = pow(input_x[2], 1) * pow(input_x[3], 1) * pow(input_x[4], 4) * pow(input_x[5], 2);
        idvd_poly_feat[6210] = pow(input_x[2], 1) * pow(input_x[3], 1) * pow(input_x[4], 4) * pow(input_x[5], 1) * pow(input_x[6], 1);
        idvd_poly_feat[6211] = pow(input_x[2], 1) * pow(input_x[3], 1) * pow(input_x[4], 4) * pow(input_x[6], 2);
        idvd_poly_feat[6212] = pow(input_x[2], 1) * pow(input_x[3], 1) * pow(input_x[4], 3) * pow(input_x[5], 3);
        idvd_poly_feat[6213] = pow(input_x[2], 1) * pow(input_x[3], 1) * pow(input_x[4], 3) * pow(input_x[5], 2) * pow(input_x[6], 1);
        idvd_poly_feat[6214] = pow(input_x[2], 1) * pow(input_x[3], 1) * pow(input_x[4], 3) * pow(input_x[5], 1) * pow(input_x[6], 2);
        idvd_poly_feat[6215] = pow(input_x[2], 1) * pow(input_x[3], 1) * pow(input_x[4], 3) * pow(input_x[6], 3);
        idvd_poly_feat[6216] = pow(input_x[2], 1) * pow(input_x[3], 1) * pow(input_x[4], 2) * pow(input_x[5], 4);
        idvd_poly_feat[6217] = pow(input_x[2], 1) * pow(input_x[3], 1) * pow(input_x[4], 2) * pow(input_x[5], 3) * pow(input_x[6], 1);
        idvd_poly_feat[6218] = pow(input_x[2], 1) * pow(input_x[3], 1) * pow(input_x[4], 2) * pow(input_x[5], 2) * pow(input_x[6], 2);
        idvd_poly_feat[6219] = pow(input_x[2], 1) * pow(input_x[3], 1) * pow(input_x[4], 2) * pow(input_x[5], 1) * pow(input_x[6], 3);
        idvd_poly_feat[6220] = pow(input_x[2], 1) * pow(input_x[3], 1) * pow(input_x[4], 2) * pow(input_x[6], 4);
        idvd_poly_feat[6221] = pow(input_x[2], 1) * pow(input_x[3], 1) * pow(input_x[4], 1) * pow(input_x[5], 5);
        idvd_poly_feat[6222] = pow(input_x[2], 1) * pow(input_x[3], 1) * pow(input_x[4], 1) * pow(input_x[5], 4) * pow(input_x[6], 1);
        idvd_poly_feat[6223] = pow(input_x[2], 1) * pow(input_x[3], 1) * pow(input_x[4], 1) * pow(input_x[5], 3) * pow(input_x[6], 2);
        idvd_poly_feat[6224] = pow(input_x[2], 1) * pow(input_x[3], 1) * pow(input_x[4], 1) * pow(input_x[5], 2) * pow(input_x[6], 3);
        idvd_poly_feat[6225] = pow(input_x[2], 1) * pow(input_x[3], 1) * pow(input_x[4], 1) * pow(input_x[5], 1) * pow(input_x[6], 4);
        idvd_poly_feat[6226] = pow(input_x[2], 1) * pow(input_x[3], 1) * pow(input_x[4], 1) * pow(input_x[6], 5);
        idvd_poly_feat[6227] = pow(input_x[2], 1) * pow(input_x[3], 1) * pow(input_x[5], 6);
        idvd_poly_feat[6228] = pow(input_x[2], 1) * pow(input_x[3], 1) * pow(input_x[5], 5) * pow(input_x[6], 1);
        idvd_poly_feat[6229] = pow(input_x[2], 1) * pow(input_x[3], 1) * pow(input_x[5], 4) * pow(input_x[6], 2);
        idvd_poly_feat[6230] = pow(input_x[2], 1) * pow(input_x[3], 1) * pow(input_x[5], 3) * pow(input_x[6], 3);
        idvd_poly_feat[6231] = pow(input_x[2], 1) * pow(input_x[3], 1) * pow(input_x[5], 2) * pow(input_x[6], 4);
        idvd_poly_feat[6232] = pow(input_x[2], 1) * pow(input_x[3], 1) * pow(input_x[5], 1) * pow(input_x[6], 5);
        idvd_poly_feat[6233] = pow(input_x[2], 1) * pow(input_x[3], 1) * pow(input_x[6], 6);
        idvd_poly_feat[6234] = pow(input_x[2], 1) * pow(input_x[4], 7);
        idvd_poly_feat[6235] = pow(input_x[2], 1) * pow(input_x[4], 6) * pow(input_x[5], 1);
        idvd_poly_feat[6236] = pow(input_x[2], 1) * pow(input_x[4], 6) * pow(input_x[6], 1);
        idvd_poly_feat[6237] = pow(input_x[2], 1) * pow(input_x[4], 5) * pow(input_x[5], 2);
        idvd_poly_feat[6238] = pow(input_x[2], 1) * pow(input_x[4], 5) * pow(input_x[5], 1) * pow(input_x[6], 1);
        idvd_poly_feat[6239] = pow(input_x[2], 1) * pow(input_x[4], 5) * pow(input_x[6], 2);
        idvd_poly_feat[6240] = pow(input_x[2], 1) * pow(input_x[4], 4) * pow(input_x[5], 3);
        idvd_poly_feat[6241] = pow(input_x[2], 1) * pow(input_x[4], 4) * pow(input_x[5], 2) * pow(input_x[6], 1);
        idvd_poly_feat[6242] = pow(input_x[2], 1) * pow(input_x[4], 4) * pow(input_x[5], 1) * pow(input_x[6], 2);
        idvd_poly_feat[6243] = pow(input_x[2], 1) * pow(input_x[4], 4) * pow(input_x[6], 3);
        idvd_poly_feat[6244] = pow(input_x[2], 1) * pow(input_x[4], 3) * pow(input_x[5], 4);
        idvd_poly_feat[6245] = pow(input_x[2], 1) * pow(input_x[4], 3) * pow(input_x[5], 3) * pow(input_x[6], 1);
        idvd_poly_feat[6246] = pow(input_x[2], 1) * pow(input_x[4], 3) * pow(input_x[5], 2) * pow(input_x[6], 2);
        idvd_poly_feat[6247] = pow(input_x[2], 1) * pow(input_x[4], 3) * pow(input_x[5], 1) * pow(input_x[6], 3);
        idvd_poly_feat[6248] = pow(input_x[2], 1) * pow(input_x[4], 3) * pow(input_x[6], 4);
        idvd_poly_feat[6249] = pow(input_x[2], 1) * pow(input_x[4], 2) * pow(input_x[5], 5);
        idvd_poly_feat[6250] = pow(input_x[2], 1) * pow(input_x[4], 2) * pow(input_x[5], 4) * pow(input_x[6], 1);
        idvd_poly_feat[6251] = pow(input_x[2], 1) * pow(input_x[4], 2) * pow(input_x[5], 3) * pow(input_x[6], 2);
        idvd_poly_feat[6252] = pow(input_x[2], 1) * pow(input_x[4], 2) * pow(input_x[5], 2) * pow(input_x[6], 3);
        idvd_poly_feat[6253] = pow(input_x[2], 1) * pow(input_x[4], 2) * pow(input_x[5], 1) * pow(input_x[6], 4);
        idvd_poly_feat[6254] = pow(input_x[2], 1) * pow(input_x[4], 2) * pow(input_x[6], 5);
        idvd_poly_feat[6255] = pow(input_x[2], 1) * pow(input_x[4], 1) * pow(input_x[5], 6);
        idvd_poly_feat[6256] = pow(input_x[2], 1) * pow(input_x[4], 1) * pow(input_x[5], 5) * pow(input_x[6], 1);
        idvd_poly_feat[6257] = pow(input_x[2], 1) * pow(input_x[4], 1) * pow(input_x[5], 4) * pow(input_x[6], 2);
        idvd_poly_feat[6258] = pow(input_x[2], 1) * pow(input_x[4], 1) * pow(input_x[5], 3) * pow(input_x[6], 3);
        idvd_poly_feat[6259] = pow(input_x[2], 1) * pow(input_x[4], 1) * pow(input_x[5], 2) * pow(input_x[6], 4);
        idvd_poly_feat[6260] = pow(input_x[2], 1) * pow(input_x[4], 1) * pow(input_x[5], 1) * pow(input_x[6], 5);
        idvd_poly_feat[6261] = pow(input_x[2], 1) * pow(input_x[4], 1) * pow(input_x[6], 6);
        idvd_poly_feat[6262] = pow(input_x[2], 1) * pow(input_x[5], 7);
        idvd_poly_feat[6263] = pow(input_x[2], 1) * pow(input_x[5], 6) * pow(input_x[6], 1);
        idvd_poly_feat[6264] = pow(input_x[2], 1) * pow(input_x[5], 5) * pow(input_x[6], 2);
        idvd_poly_feat[6265] = pow(input_x[2], 1) * pow(input_x[5], 4) * pow(input_x[6], 3);
        idvd_poly_feat[6266] = pow(input_x[2], 1) * pow(input_x[5], 3) * pow(input_x[6], 4);
        idvd_poly_feat[6267] = pow(input_x[2], 1) * pow(input_x[5], 2) * pow(input_x[6], 5);
        idvd_poly_feat[6268] = pow(input_x[2], 1) * pow(input_x[5], 1) * pow(input_x[6], 6);
        idvd_poly_feat[6269] = pow(input_x[2], 1) * pow(input_x[6], 7);
        idvd_poly_feat[6270] = pow(input_x[3], 8);
        idvd_poly_feat[6271] = pow(input_x[3], 7) * pow(input_x[4], 1);
        idvd_poly_feat[6272] = pow(input_x[3], 7) * pow(input_x[5], 1);
        idvd_poly_feat[6273] = pow(input_x[3], 7) * pow(input_x[6], 1);
        idvd_poly_feat[6274] = pow(input_x[3], 6) * pow(input_x[4], 2);
        idvd_poly_feat[6275] = pow(input_x[3], 6) * pow(input_x[4], 1) * pow(input_x[5], 1);
        idvd_poly_feat[6276] = pow(input_x[3], 6) * pow(input_x[4], 1) * pow(input_x[6], 1);
        idvd_poly_feat[6277] = pow(input_x[3], 6) * pow(input_x[5], 2);
        idvd_poly_feat[6278] = pow(input_x[3], 6) * pow(input_x[5], 1) * pow(input_x[6], 1);
        idvd_poly_feat[6279] = pow(input_x[3], 6) * pow(input_x[6], 2);
        idvd_poly_feat[6280] = pow(input_x[3], 5) * pow(input_x[4], 3);
        idvd_poly_feat[6281] = pow(input_x[3], 5) * pow(input_x[4], 2) * pow(input_x[5], 1);
        idvd_poly_feat[6282] = pow(input_x[3], 5) * pow(input_x[4], 2) * pow(input_x[6], 1);
        idvd_poly_feat[6283] = pow(input_x[3], 5) * pow(input_x[4], 1) * pow(input_x[5], 2);
        idvd_poly_feat[6284] = pow(input_x[3], 5) * pow(input_x[4], 1) * pow(input_x[5], 1) * pow(input_x[6], 1);
        idvd_poly_feat[6285] = pow(input_x[3], 5) * pow(input_x[4], 1) * pow(input_x[6], 2);
        idvd_poly_feat[6286] = pow(input_x[3], 5) * pow(input_x[5], 3);
        idvd_poly_feat[6287] = pow(input_x[3], 5) * pow(input_x[5], 2) * pow(input_x[6], 1);
        idvd_poly_feat[6288] = pow(input_x[3], 5) * pow(input_x[5], 1) * pow(input_x[6], 2);
        idvd_poly_feat[6289] = pow(input_x[3], 5) * pow(input_x[6], 3);
        idvd_poly_feat[6290] = pow(input_x[3], 4) * pow(input_x[4], 4);
        idvd_poly_feat[6291] = pow(input_x[3], 4) * pow(input_x[4], 3) * pow(input_x[5], 1);
        idvd_poly_feat[6292] = pow(input_x[3], 4) * pow(input_x[4], 3) * pow(input_x[6], 1);
        idvd_poly_feat[6293] = pow(input_x[3], 4) * pow(input_x[4], 2) * pow(input_x[5], 2);
        idvd_poly_feat[6294] = pow(input_x[3], 4) * pow(input_x[4], 2) * pow(input_x[5], 1) * pow(input_x[6], 1);
        idvd_poly_feat[6295] = pow(input_x[3], 4) * pow(input_x[4], 2) * pow(input_x[6], 2);
        idvd_poly_feat[6296] = pow(input_x[3], 4) * pow(input_x[4], 1) * pow(input_x[5], 3);
        idvd_poly_feat[6297] = pow(input_x[3], 4) * pow(input_x[4], 1) * pow(input_x[5], 2) * pow(input_x[6], 1);
        idvd_poly_feat[6298] = pow(input_x[3], 4) * pow(input_x[4], 1) * pow(input_x[5], 1) * pow(input_x[6], 2);
        idvd_poly_feat[6299] = pow(input_x[3], 4) * pow(input_x[4], 1) * pow(input_x[6], 3);
        idvd_poly_feat[6300] = pow(input_x[3], 4) * pow(input_x[5], 4);
        idvd_poly_feat[6301] = pow(input_x[3], 4) * pow(input_x[5], 3) * pow(input_x[6], 1);
        idvd_poly_feat[6302] = pow(input_x[3], 4) * pow(input_x[5], 2) * pow(input_x[6], 2);
        idvd_poly_feat[6303] = pow(input_x[3], 4) * pow(input_x[5], 1) * pow(input_x[6], 3);
        idvd_poly_feat[6304] = pow(input_x[3], 4) * pow(input_x[6], 4);
        idvd_poly_feat[6305] = pow(input_x[3], 3) * pow(input_x[4], 5);
        idvd_poly_feat[6306] = pow(input_x[3], 3) * pow(input_x[4], 4) * pow(input_x[5], 1);
        idvd_poly_feat[6307] = pow(input_x[3], 3) * pow(input_x[4], 4) * pow(input_x[6], 1);
        idvd_poly_feat[6308] = pow(input_x[3], 3) * pow(input_x[4], 3) * pow(input_x[5], 2);
        idvd_poly_feat[6309] = pow(input_x[3], 3) * pow(input_x[4], 3) * pow(input_x[5], 1) * pow(input_x[6], 1);
        idvd_poly_feat[6310] = pow(input_x[3], 3) * pow(input_x[4], 3) * pow(input_x[6], 2);
        idvd_poly_feat[6311] = pow(input_x[3], 3) * pow(input_x[4], 2) * pow(input_x[5], 3);
        idvd_poly_feat[6312] = pow(input_x[3], 3) * pow(input_x[4], 2) * pow(input_x[5], 2) * pow(input_x[6], 1);
        idvd_poly_feat[6313] = pow(input_x[3], 3) * pow(input_x[4], 2) * pow(input_x[5], 1) * pow(input_x[6], 2);
        idvd_poly_feat[6314] = pow(input_x[3], 3) * pow(input_x[4], 2) * pow(input_x[6], 3);
        idvd_poly_feat[6315] = pow(input_x[3], 3) * pow(input_x[4], 1) * pow(input_x[5], 4);
        idvd_poly_feat[6316] = pow(input_x[3], 3) * pow(input_x[4], 1) * pow(input_x[5], 3) * pow(input_x[6], 1);
        idvd_poly_feat[6317] = pow(input_x[3], 3) * pow(input_x[4], 1) * pow(input_x[5], 2) * pow(input_x[6], 2);
        idvd_poly_feat[6318] = pow(input_x[3], 3) * pow(input_x[4], 1) * pow(input_x[5], 1) * pow(input_x[6], 3);
        idvd_poly_feat[6319] = pow(input_x[3], 3) * pow(input_x[4], 1) * pow(input_x[6], 4);
        idvd_poly_feat[6320] = pow(input_x[3], 3) * pow(input_x[5], 5);
        idvd_poly_feat[6321] = pow(input_x[3], 3) * pow(input_x[5], 4) * pow(input_x[6], 1);
        idvd_poly_feat[6322] = pow(input_x[3], 3) * pow(input_x[5], 3) * pow(input_x[6], 2);
        idvd_poly_feat[6323] = pow(input_x[3], 3) * pow(input_x[5], 2) * pow(input_x[6], 3);
        idvd_poly_feat[6324] = pow(input_x[3], 3) * pow(input_x[5], 1) * pow(input_x[6], 4);
        idvd_poly_feat[6325] = pow(input_x[3], 3) * pow(input_x[6], 5);
        idvd_poly_feat[6326] = pow(input_x[3], 2) * pow(input_x[4], 6);
        idvd_poly_feat[6327] = pow(input_x[3], 2) * pow(input_x[4], 5) * pow(input_x[5], 1);
        idvd_poly_feat[6328] = pow(input_x[3], 2) * pow(input_x[4], 5) * pow(input_x[6], 1);
        idvd_poly_feat[6329] = pow(input_x[3], 2) * pow(input_x[4], 4) * pow(input_x[5], 2);
        idvd_poly_feat[6330] = pow(input_x[3], 2) * pow(input_x[4], 4) * pow(input_x[5], 1) * pow(input_x[6], 1);
        idvd_poly_feat[6331] = pow(input_x[3], 2) * pow(input_x[4], 4) * pow(input_x[6], 2);
        idvd_poly_feat[6332] = pow(input_x[3], 2) * pow(input_x[4], 3) * pow(input_x[5], 3);
        idvd_poly_feat[6333] = pow(input_x[3], 2) * pow(input_x[4], 3) * pow(input_x[5], 2) * pow(input_x[6], 1);
        idvd_poly_feat[6334] = pow(input_x[3], 2) * pow(input_x[4], 3) * pow(input_x[5], 1) * pow(input_x[6], 2);
        idvd_poly_feat[6335] = pow(input_x[3], 2) * pow(input_x[4], 3) * pow(input_x[6], 3);
        idvd_poly_feat[6336] = pow(input_x[3], 2) * pow(input_x[4], 2) * pow(input_x[5], 4);
        idvd_poly_feat[6337] = pow(input_x[3], 2) * pow(input_x[4], 2) * pow(input_x[5], 3) * pow(input_x[6], 1);
        idvd_poly_feat[6338] = pow(input_x[3], 2) * pow(input_x[4], 2) * pow(input_x[5], 2) * pow(input_x[6], 2);
        idvd_poly_feat[6339] = pow(input_x[3], 2) * pow(input_x[4], 2) * pow(input_x[5], 1) * pow(input_x[6], 3);
        idvd_poly_feat[6340] = pow(input_x[3], 2) * pow(input_x[4], 2) * pow(input_x[6], 4);
        idvd_poly_feat[6341] = pow(input_x[3], 2) * pow(input_x[4], 1) * pow(input_x[5], 5);
        idvd_poly_feat[6342] = pow(input_x[3], 2) * pow(input_x[4], 1) * pow(input_x[5], 4) * pow(input_x[6], 1);
        idvd_poly_feat[6343] = pow(input_x[3], 2) * pow(input_x[4], 1) * pow(input_x[5], 3) * pow(input_x[6], 2);
        idvd_poly_feat[6344] = pow(input_x[3], 2) * pow(input_x[4], 1) * pow(input_x[5], 2) * pow(input_x[6], 3);
        idvd_poly_feat[6345] = pow(input_x[3], 2) * pow(input_x[4], 1) * pow(input_x[5], 1) * pow(input_x[6], 4);
        idvd_poly_feat[6346] = pow(input_x[3], 2) * pow(input_x[4], 1) * pow(input_x[6], 5);
        idvd_poly_feat[6347] = pow(input_x[3], 2) * pow(input_x[5], 6);
        idvd_poly_feat[6348] = pow(input_x[3], 2) * pow(input_x[5], 5) * pow(input_x[6], 1);
        idvd_poly_feat[6349] = pow(input_x[3], 2) * pow(input_x[5], 4) * pow(input_x[6], 2);
        idvd_poly_feat[6350] = pow(input_x[3], 2) * pow(input_x[5], 3) * pow(input_x[6], 3);
        idvd_poly_feat[6351] = pow(input_x[3], 2) * pow(input_x[5], 2) * pow(input_x[6], 4);
        idvd_poly_feat[6352] = pow(input_x[3], 2) * pow(input_x[5], 1) * pow(input_x[6], 5);
        idvd_poly_feat[6353] = pow(input_x[3], 2) * pow(input_x[6], 6);
        idvd_poly_feat[6354] = pow(input_x[3], 1) * pow(input_x[4], 7);
        idvd_poly_feat[6355] = pow(input_x[3], 1) * pow(input_x[4], 6) * pow(input_x[5], 1);
        idvd_poly_feat[6356] = pow(input_x[3], 1) * pow(input_x[4], 6) * pow(input_x[6], 1);
        idvd_poly_feat[6357] = pow(input_x[3], 1) * pow(input_x[4], 5) * pow(input_x[5], 2);
        idvd_poly_feat[6358] = pow(input_x[3], 1) * pow(input_x[4], 5) * pow(input_x[5], 1) * pow(input_x[6], 1);
        idvd_poly_feat[6359] = pow(input_x[3], 1) * pow(input_x[4], 5) * pow(input_x[6], 2);
        idvd_poly_feat[6360] = pow(input_x[3], 1) * pow(input_x[4], 4) * pow(input_x[5], 3);
        idvd_poly_feat[6361] = pow(input_x[3], 1) * pow(input_x[4], 4) * pow(input_x[5], 2) * pow(input_x[6], 1);
        idvd_poly_feat[6362] = pow(input_x[3], 1) * pow(input_x[4], 4) * pow(input_x[5], 1) * pow(input_x[6], 2);
        idvd_poly_feat[6363] = pow(input_x[3], 1) * pow(input_x[4], 4) * pow(input_x[6], 3);
        idvd_poly_feat[6364] = pow(input_x[3], 1) * pow(input_x[4], 3) * pow(input_x[5], 4);
        idvd_poly_feat[6365] = pow(input_x[3], 1) * pow(input_x[4], 3) * pow(input_x[5], 3) * pow(input_x[6], 1);
        idvd_poly_feat[6366] = pow(input_x[3], 1) * pow(input_x[4], 3) * pow(input_x[5], 2) * pow(input_x[6], 2);
        idvd_poly_feat[6367] = pow(input_x[3], 1) * pow(input_x[4], 3) * pow(input_x[5], 1) * pow(input_x[6], 3);
        idvd_poly_feat[6368] = pow(input_x[3], 1) * pow(input_x[4], 3) * pow(input_x[6], 4);
        idvd_poly_feat[6369] = pow(input_x[3], 1) * pow(input_x[4], 2) * pow(input_x[5], 5);
        idvd_poly_feat[6370] = pow(input_x[3], 1) * pow(input_x[4], 2) * pow(input_x[5], 4) * pow(input_x[6], 1);
        idvd_poly_feat[6371] = pow(input_x[3], 1) * pow(input_x[4], 2) * pow(input_x[5], 3) * pow(input_x[6], 2);
        idvd_poly_feat[6372] = pow(input_x[3], 1) * pow(input_x[4], 2) * pow(input_x[5], 2) * pow(input_x[6], 3);
        idvd_poly_feat[6373] = pow(input_x[3], 1) * pow(input_x[4], 2) * pow(input_x[5], 1) * pow(input_x[6], 4);
        idvd_poly_feat[6374] = pow(input_x[3], 1) * pow(input_x[4], 2) * pow(input_x[6], 5);
        idvd_poly_feat[6375] = pow(input_x[3], 1) * pow(input_x[4], 1) * pow(input_x[5], 6);
        idvd_poly_feat[6376] = pow(input_x[3], 1) * pow(input_x[4], 1) * pow(input_x[5], 5) * pow(input_x[6], 1);
        idvd_poly_feat[6377] = pow(input_x[3], 1) * pow(input_x[4], 1) * pow(input_x[5], 4) * pow(input_x[6], 2);
        idvd_poly_feat[6378] = pow(input_x[3], 1) * pow(input_x[4], 1) * pow(input_x[5], 3) * pow(input_x[6], 3);
        idvd_poly_feat[6379] = pow(input_x[3], 1) * pow(input_x[4], 1) * pow(input_x[5], 2) * pow(input_x[6], 4);
        idvd_poly_feat[6380] = pow(input_x[3], 1) * pow(input_x[4], 1) * pow(input_x[5], 1) * pow(input_x[6], 5);
        idvd_poly_feat[6381] = pow(input_x[3], 1) * pow(input_x[4], 1) * pow(input_x[6], 6);
        idvd_poly_feat[6382] = pow(input_x[3], 1) * pow(input_x[5], 7);
        idvd_poly_feat[6383] = pow(input_x[3], 1) * pow(input_x[5], 6) * pow(input_x[6], 1);
        idvd_poly_feat[6384] = pow(input_x[3], 1) * pow(input_x[5], 5) * pow(input_x[6], 2);
        idvd_poly_feat[6385] = pow(input_x[3], 1) * pow(input_x[5], 4) * pow(input_x[6], 3);
        idvd_poly_feat[6386] = pow(input_x[3], 1) * pow(input_x[5], 3) * pow(input_x[6], 4);
        idvd_poly_feat[6387] = pow(input_x[3], 1) * pow(input_x[5], 2) * pow(input_x[6], 5);
        idvd_poly_feat[6388] = pow(input_x[3], 1) * pow(input_x[5], 1) * pow(input_x[6], 6);
        idvd_poly_feat[6389] = pow(input_x[3], 1) * pow(input_x[6], 7);
        idvd_poly_feat[6390] = pow(input_x[4], 8);
        idvd_poly_feat[6391] = pow(input_x[4], 7) * pow(input_x[5], 1);
        idvd_poly_feat[6392] = pow(input_x[4], 7) * pow(input_x[6], 1);
        idvd_poly_feat[6393] = pow(input_x[4], 6) * pow(input_x[5], 2);
        idvd_poly_feat[6394] = pow(input_x[4], 6) * pow(input_x[5], 1) * pow(input_x[6], 1);
        idvd_poly_feat[6395] = pow(input_x[4], 6) * pow(input_x[6], 2);
        idvd_poly_feat[6396] = pow(input_x[4], 5) * pow(input_x[5], 3);
        idvd_poly_feat[6397] = pow(input_x[4], 5) * pow(input_x[5], 2) * pow(input_x[6], 1);
        idvd_poly_feat[6398] = pow(input_x[4], 5) * pow(input_x[5], 1) * pow(input_x[6], 2);
        idvd_poly_feat[6399] = pow(input_x[4], 5) * pow(input_x[6], 3);
        idvd_poly_feat[6400] = pow(input_x[4], 4) * pow(input_x[5], 4);
        idvd_poly_feat[6401] = pow(input_x[4], 4) * pow(input_x[5], 3) * pow(input_x[6], 1);
        idvd_poly_feat[6402] = pow(input_x[4], 4) * pow(input_x[5], 2) * pow(input_x[6], 2);
        idvd_poly_feat[6403] = pow(input_x[4], 4) * pow(input_x[5], 1) * pow(input_x[6], 3);
        idvd_poly_feat[6404] = pow(input_x[4], 4) * pow(input_x[6], 4);
        idvd_poly_feat[6405] = pow(input_x[4], 3) * pow(input_x[5], 5);
        idvd_poly_feat[6406] = pow(input_x[4], 3) * pow(input_x[5], 4) * pow(input_x[6], 1);
        idvd_poly_feat[6407] = pow(input_x[4], 3) * pow(input_x[5], 3) * pow(input_x[6], 2);
        idvd_poly_feat[6408] = pow(input_x[4], 3) * pow(input_x[5], 2) * pow(input_x[6], 3);
        idvd_poly_feat[6409] = pow(input_x[4], 3) * pow(input_x[5], 1) * pow(input_x[6], 4);
        idvd_poly_feat[6410] = pow(input_x[4], 3) * pow(input_x[6], 5);
        idvd_poly_feat[6411] = pow(input_x[4], 2) * pow(input_x[5], 6);
        idvd_poly_feat[6412] = pow(input_x[4], 2) * pow(input_x[5], 5) * pow(input_x[6], 1);
        idvd_poly_feat[6413] = pow(input_x[4], 2) * pow(input_x[5], 4) * pow(input_x[6], 2);
        idvd_poly_feat[6414] = pow(input_x[4], 2) * pow(input_x[5], 3) * pow(input_x[6], 3);
        idvd_poly_feat[6415] = pow(input_x[4], 2) * pow(input_x[5], 2) * pow(input_x[6], 4);
        idvd_poly_feat[6416] = pow(input_x[4], 2) * pow(input_x[5], 1) * pow(input_x[6], 5);
        idvd_poly_feat[6417] = pow(input_x[4], 2) * pow(input_x[6], 6);
        idvd_poly_feat[6418] = pow(input_x[4], 1) * pow(input_x[5], 7);
        idvd_poly_feat[6419] = pow(input_x[4], 1) * pow(input_x[5], 6) * pow(input_x[6], 1);
        idvd_poly_feat[6420] = pow(input_x[4], 1) * pow(input_x[5], 5) * pow(input_x[6], 2);
        idvd_poly_feat[6421] = pow(input_x[4], 1) * pow(input_x[5], 4) * pow(input_x[6], 3);
        idvd_poly_feat[6422] = pow(input_x[4], 1) * pow(input_x[5], 3) * pow(input_x[6], 4);
        idvd_poly_feat[6423] = pow(input_x[4], 1) * pow(input_x[5], 2) * pow(input_x[6], 5);
        idvd_poly_feat[6424] = pow(input_x[4], 1) * pow(input_x[5], 1) * pow(input_x[6], 6);
        idvd_poly_feat[6425] = pow(input_x[4], 1) * pow(input_x[6], 7);
        idvd_poly_feat[6426] = pow(input_x[5], 8);
        idvd_poly_feat[6427] = pow(input_x[5], 7) * pow(input_x[6], 1);
        idvd_poly_feat[6428] = pow(input_x[5], 6) * pow(input_x[6], 2);
        idvd_poly_feat[6429] = pow(input_x[5], 5) * pow(input_x[6], 3);
        idvd_poly_feat[6430] = pow(input_x[5], 4) * pow(input_x[6], 4);
        idvd_poly_feat[6431] = pow(input_x[5], 3) * pow(input_x[6], 5);
        idvd_poly_feat[6432] = pow(input_x[5], 2) * pow(input_x[6], 6);
        idvd_poly_feat[6433] = pow(input_x[5], 1) * pow(input_x[6], 7);
        idvd_poly_feat[6434] = pow(input_x[6], 8);
        idvd_poly_feat[6435] = pow(input_x[0], 9);
        idvd_poly_feat[6436] = pow(input_x[1], 9);
        idvd_poly_feat[6437] = pow(input_x[2], 9);
        idvd_poly_feat[6438] = pow(input_x[3], 9);
        idvd_poly_feat[6439] = pow(input_x[4], 9);
        idvd_poly_feat[6440] = pow(input_x[5], 9);
        idvd_poly_feat[6441] = pow(input_x[6], 9);
        idvd_poly_feat[6442] = pow(input_x[0], 10);
        idvd_poly_feat[6443] = pow(input_x[1], 10);
        idvd_poly_feat[6444] = pow(input_x[2], 10);
        idvd_poly_feat[6445] = pow(input_x[3], 10);
        idvd_poly_feat[6446] = pow(input_x[4], 10);
        idvd_poly_feat[6447] = pow(input_x[5], 10);
        idvd_poly_feat[6448] = pow(input_x[6], 10);
        idvd_poly_feat[6449] = pow(input_x[0], 11);
        idvd_poly_feat[6450] = pow(input_x[1], 11);
        idvd_poly_feat[6451] = pow(input_x[2], 11);
        idvd_poly_feat[6452] = pow(input_x[3], 11);
        idvd_poly_feat[6453] = pow(input_x[4], 11);
        idvd_poly_feat[6454] = pow(input_x[5], 11);
        idvd_poly_feat[6455] = pow(input_x[6], 11);
        idvd_poly_feat[6456] = pow(input_x[0], 12);
        idvd_poly_feat[6457] = pow(input_x[1], 12);
        idvd_poly_feat[6458] = pow(input_x[2], 12);
        idvd_poly_feat[6459] = pow(input_x[3], 12);
        idvd_poly_feat[6460] = pow(input_x[4], 12);
        idvd_poly_feat[6461] = pow(input_x[5], 12);
        idvd_poly_feat[6462] = pow(input_x[6], 12);
        for(i=0; i<18; i=i+1) begin
          tmp = idvd_poly_b[i];
          for(j=0; j<6463; j=j+1) tmp = tmp + idvd_poly_w[i*6463 + j] * idvd_poly_feat[j];
          idvd_z[i] = tmp * idvd_sl_mul[i] + idvd_sl_add[i];
        end
      for(i=0; i<56; i=i+1) begin
        tmp = idvd_ae_b0[i];
        for(j=0; j<18; j=j+1) tmp = tmp + idvd_ae_w0[i*18 + j] * idvd_z[j];
        idvd_h0[i] = (tmp > 0.0) ? tmp : 0.0;
      end
      for(i=0; i<225; i=i+1) begin
        tmp = idvd_ae_b1[i];
        for(j=0; j<56; j=j+1) tmp = tmp + idvd_ae_w1[i*56 + j] * idvd_h0[j];
        idvd_h1[i] = (tmp > 0.0) ? tmp : 0.0;
      end
      for(i=0; i<450; i=i+1) begin
        tmp = idvd_ae_b2[i];
        for(j=0; j<225; j=j+1) tmp = tmp + idvd_ae_w2[i*225 + j] * idvd_h1[j];
        idvd_h2[i] = (tmp > 0.0) ? tmp : 0.0;
      end
        for(i=0; i<900; i=i+1) begin
          tmp = idvd_ae_b3[i];
          for(j=0; j<450; j=j+1) tmp = tmp + idvd_ae_w3[i*450 + j] * idvd_h2[j];
          tmp = 1.0 / (1.0 + exp(-tmp));
          idvd_out[i] = tmp * idvd_siv_mul[i] + idvd_siv_add[i];
        end
      end else begin
        for(i=0; i<900; i=i+1) idvd_out[i] = 0.0;
      end

      input_x[0] = Lsg * idvg_sx_mul[0] + idvg_sx_add[0];
      input_x[1] = Lgd * idvg_sx_mul[1] + idvg_sx_add[1];
      input_x[2] = Lg * idvg_sx_mul[2] + idvg_sx_add[2];
      input_x[3] = hpas * idvg_sx_mul[3] + idvg_sx_add[3];
      input_x[4] = hAlGaN * idvg_sx_mul[4] + idvg_sx_add[4];
      input_x[5] = hch * idvg_sx_mul[5] + idvg_sx_add[5];
      input_x[6] = hg * idvg_sx_mul[6] + idvg_sx_add[6];
      idvg_poly_feat[0] = 1.0;
      idvg_poly_feat[1] = pow(input_x[0], 1);
      idvg_poly_feat[2] = pow(input_x[1], 1);
      idvg_poly_feat[3] = pow(input_x[2], 1);
      idvg_poly_feat[4] = pow(input_x[3], 1);
      idvg_poly_feat[5] = pow(input_x[4], 1);
      idvg_poly_feat[6] = pow(input_x[5], 1);
      idvg_poly_feat[7] = pow(input_x[6], 1);
      idvg_poly_feat[8] = pow(input_x[0], 2);
      idvg_poly_feat[9] = pow(input_x[0], 1) * pow(input_x[1], 1);
      idvg_poly_feat[10] = pow(input_x[0], 1) * pow(input_x[2], 1);
      idvg_poly_feat[11] = pow(input_x[0], 1) * pow(input_x[3], 1);
      idvg_poly_feat[12] = pow(input_x[0], 1) * pow(input_x[4], 1);
      idvg_poly_feat[13] = pow(input_x[0], 1) * pow(input_x[5], 1);
      idvg_poly_feat[14] = pow(input_x[0], 1) * pow(input_x[6], 1);
      idvg_poly_feat[15] = pow(input_x[1], 2);
      idvg_poly_feat[16] = pow(input_x[1], 1) * pow(input_x[2], 1);
      idvg_poly_feat[17] = pow(input_x[1], 1) * pow(input_x[3], 1);
      idvg_poly_feat[18] = pow(input_x[1], 1) * pow(input_x[4], 1);
      idvg_poly_feat[19] = pow(input_x[1], 1) * pow(input_x[5], 1);
      idvg_poly_feat[20] = pow(input_x[1], 1) * pow(input_x[6], 1);
      idvg_poly_feat[21] = pow(input_x[2], 2);
      idvg_poly_feat[22] = pow(input_x[2], 1) * pow(input_x[3], 1);
      idvg_poly_feat[23] = pow(input_x[2], 1) * pow(input_x[4], 1);
      idvg_poly_feat[24] = pow(input_x[2], 1) * pow(input_x[5], 1);
      idvg_poly_feat[25] = pow(input_x[2], 1) * pow(input_x[6], 1);
      idvg_poly_feat[26] = pow(input_x[3], 2);
      idvg_poly_feat[27] = pow(input_x[3], 1) * pow(input_x[4], 1);
      idvg_poly_feat[28] = pow(input_x[3], 1) * pow(input_x[5], 1);
      idvg_poly_feat[29] = pow(input_x[3], 1) * pow(input_x[6], 1);
      idvg_poly_feat[30] = pow(input_x[4], 2);
      idvg_poly_feat[31] = pow(input_x[4], 1) * pow(input_x[5], 1);
      idvg_poly_feat[32] = pow(input_x[4], 1) * pow(input_x[6], 1);
      idvg_poly_feat[33] = pow(input_x[5], 2);
      idvg_poly_feat[34] = pow(input_x[5], 1) * pow(input_x[6], 1);
      idvg_poly_feat[35] = pow(input_x[6], 2);
      idvg_poly_feat[36] = pow(input_x[0], 3);
      idvg_poly_feat[37] = pow(input_x[0], 2) * pow(input_x[1], 1);
      idvg_poly_feat[38] = pow(input_x[0], 2) * pow(input_x[2], 1);
      idvg_poly_feat[39] = pow(input_x[0], 2) * pow(input_x[3], 1);
      idvg_poly_feat[40] = pow(input_x[0], 2) * pow(input_x[4], 1);
      idvg_poly_feat[41] = pow(input_x[0], 2) * pow(input_x[5], 1);
      idvg_poly_feat[42] = pow(input_x[0], 2) * pow(input_x[6], 1);
      idvg_poly_feat[43] = pow(input_x[0], 1) * pow(input_x[1], 2);
      idvg_poly_feat[44] = pow(input_x[0], 1) * pow(input_x[1], 1) * pow(input_x[2], 1);
      idvg_poly_feat[45] = pow(input_x[0], 1) * pow(input_x[1], 1) * pow(input_x[3], 1);
      idvg_poly_feat[46] = pow(input_x[0], 1) * pow(input_x[1], 1) * pow(input_x[4], 1);
      idvg_poly_feat[47] = pow(input_x[0], 1) * pow(input_x[1], 1) * pow(input_x[5], 1);
      idvg_poly_feat[48] = pow(input_x[0], 1) * pow(input_x[1], 1) * pow(input_x[6], 1);
      idvg_poly_feat[49] = pow(input_x[0], 1) * pow(input_x[2], 2);
      idvg_poly_feat[50] = pow(input_x[0], 1) * pow(input_x[2], 1) * pow(input_x[3], 1);
      idvg_poly_feat[51] = pow(input_x[0], 1) * pow(input_x[2], 1) * pow(input_x[4], 1);
      idvg_poly_feat[52] = pow(input_x[0], 1) * pow(input_x[2], 1) * pow(input_x[5], 1);
      idvg_poly_feat[53] = pow(input_x[0], 1) * pow(input_x[2], 1) * pow(input_x[6], 1);
      idvg_poly_feat[54] = pow(input_x[0], 1) * pow(input_x[3], 2);
      idvg_poly_feat[55] = pow(input_x[0], 1) * pow(input_x[3], 1) * pow(input_x[4], 1);
      idvg_poly_feat[56] = pow(input_x[0], 1) * pow(input_x[3], 1) * pow(input_x[5], 1);
      idvg_poly_feat[57] = pow(input_x[0], 1) * pow(input_x[3], 1) * pow(input_x[6], 1);
      idvg_poly_feat[58] = pow(input_x[0], 1) * pow(input_x[4], 2);
      idvg_poly_feat[59] = pow(input_x[0], 1) * pow(input_x[4], 1) * pow(input_x[5], 1);
      idvg_poly_feat[60] = pow(input_x[0], 1) * pow(input_x[4], 1) * pow(input_x[6], 1);
      idvg_poly_feat[61] = pow(input_x[0], 1) * pow(input_x[5], 2);
      idvg_poly_feat[62] = pow(input_x[0], 1) * pow(input_x[5], 1) * pow(input_x[6], 1);
      idvg_poly_feat[63] = pow(input_x[0], 1) * pow(input_x[6], 2);
      idvg_poly_feat[64] = pow(input_x[1], 3);
      idvg_poly_feat[65] = pow(input_x[1], 2) * pow(input_x[2], 1);
      idvg_poly_feat[66] = pow(input_x[1], 2) * pow(input_x[3], 1);
      idvg_poly_feat[67] = pow(input_x[1], 2) * pow(input_x[4], 1);
      idvg_poly_feat[68] = pow(input_x[1], 2) * pow(input_x[5], 1);
      idvg_poly_feat[69] = pow(input_x[1], 2) * pow(input_x[6], 1);
      idvg_poly_feat[70] = pow(input_x[1], 1) * pow(input_x[2], 2);
      idvg_poly_feat[71] = pow(input_x[1], 1) * pow(input_x[2], 1) * pow(input_x[3], 1);
      idvg_poly_feat[72] = pow(input_x[1], 1) * pow(input_x[2], 1) * pow(input_x[4], 1);
      idvg_poly_feat[73] = pow(input_x[1], 1) * pow(input_x[2], 1) * pow(input_x[5], 1);
      idvg_poly_feat[74] = pow(input_x[1], 1) * pow(input_x[2], 1) * pow(input_x[6], 1);
      idvg_poly_feat[75] = pow(input_x[1], 1) * pow(input_x[3], 2);
      idvg_poly_feat[76] = pow(input_x[1], 1) * pow(input_x[3], 1) * pow(input_x[4], 1);
      idvg_poly_feat[77] = pow(input_x[1], 1) * pow(input_x[3], 1) * pow(input_x[5], 1);
      idvg_poly_feat[78] = pow(input_x[1], 1) * pow(input_x[3], 1) * pow(input_x[6], 1);
      idvg_poly_feat[79] = pow(input_x[1], 1) * pow(input_x[4], 2);
      idvg_poly_feat[80] = pow(input_x[1], 1) * pow(input_x[4], 1) * pow(input_x[5], 1);
      idvg_poly_feat[81] = pow(input_x[1], 1) * pow(input_x[4], 1) * pow(input_x[6], 1);
      idvg_poly_feat[82] = pow(input_x[1], 1) * pow(input_x[5], 2);
      idvg_poly_feat[83] = pow(input_x[1], 1) * pow(input_x[5], 1) * pow(input_x[6], 1);
      idvg_poly_feat[84] = pow(input_x[1], 1) * pow(input_x[6], 2);
      idvg_poly_feat[85] = pow(input_x[2], 3);
      idvg_poly_feat[86] = pow(input_x[2], 2) * pow(input_x[3], 1);
      idvg_poly_feat[87] = pow(input_x[2], 2) * pow(input_x[4], 1);
      idvg_poly_feat[88] = pow(input_x[2], 2) * pow(input_x[5], 1);
      idvg_poly_feat[89] = pow(input_x[2], 2) * pow(input_x[6], 1);
      idvg_poly_feat[90] = pow(input_x[2], 1) * pow(input_x[3], 2);
      idvg_poly_feat[91] = pow(input_x[2], 1) * pow(input_x[3], 1) * pow(input_x[4], 1);
      idvg_poly_feat[92] = pow(input_x[2], 1) * pow(input_x[3], 1) * pow(input_x[5], 1);
      idvg_poly_feat[93] = pow(input_x[2], 1) * pow(input_x[3], 1) * pow(input_x[6], 1);
      idvg_poly_feat[94] = pow(input_x[2], 1) * pow(input_x[4], 2);
      idvg_poly_feat[95] = pow(input_x[2], 1) * pow(input_x[4], 1) * pow(input_x[5], 1);
      idvg_poly_feat[96] = pow(input_x[2], 1) * pow(input_x[4], 1) * pow(input_x[6], 1);
      idvg_poly_feat[97] = pow(input_x[2], 1) * pow(input_x[5], 2);
      idvg_poly_feat[98] = pow(input_x[2], 1) * pow(input_x[5], 1) * pow(input_x[6], 1);
      idvg_poly_feat[99] = pow(input_x[2], 1) * pow(input_x[6], 2);
      idvg_poly_feat[100] = pow(input_x[3], 3);
      idvg_poly_feat[101] = pow(input_x[3], 2) * pow(input_x[4], 1);
      idvg_poly_feat[102] = pow(input_x[3], 2) * pow(input_x[5], 1);
      idvg_poly_feat[103] = pow(input_x[3], 2) * pow(input_x[6], 1);
      idvg_poly_feat[104] = pow(input_x[3], 1) * pow(input_x[4], 2);
      idvg_poly_feat[105] = pow(input_x[3], 1) * pow(input_x[4], 1) * pow(input_x[5], 1);
      idvg_poly_feat[106] = pow(input_x[3], 1) * pow(input_x[4], 1) * pow(input_x[6], 1);
      idvg_poly_feat[107] = pow(input_x[3], 1) * pow(input_x[5], 2);
      idvg_poly_feat[108] = pow(input_x[3], 1) * pow(input_x[5], 1) * pow(input_x[6], 1);
      idvg_poly_feat[109] = pow(input_x[3], 1) * pow(input_x[6], 2);
      idvg_poly_feat[110] = pow(input_x[4], 3);
      idvg_poly_feat[111] = pow(input_x[4], 2) * pow(input_x[5], 1);
      idvg_poly_feat[112] = pow(input_x[4], 2) * pow(input_x[6], 1);
      idvg_poly_feat[113] = pow(input_x[4], 1) * pow(input_x[5], 2);
      idvg_poly_feat[114] = pow(input_x[4], 1) * pow(input_x[5], 1) * pow(input_x[6], 1);
      idvg_poly_feat[115] = pow(input_x[4], 1) * pow(input_x[6], 2);
      idvg_poly_feat[116] = pow(input_x[5], 3);
      idvg_poly_feat[117] = pow(input_x[5], 2) * pow(input_x[6], 1);
      idvg_poly_feat[118] = pow(input_x[5], 1) * pow(input_x[6], 2);
      idvg_poly_feat[119] = pow(input_x[6], 3);
      idvg_poly_feat[120] = pow(input_x[0], 4);
      idvg_poly_feat[121] = pow(input_x[0], 3) * pow(input_x[1], 1);
      idvg_poly_feat[122] = pow(input_x[0], 3) * pow(input_x[2], 1);
      idvg_poly_feat[123] = pow(input_x[0], 3) * pow(input_x[3], 1);
      idvg_poly_feat[124] = pow(input_x[0], 3) * pow(input_x[4], 1);
      idvg_poly_feat[125] = pow(input_x[0], 3) * pow(input_x[5], 1);
      idvg_poly_feat[126] = pow(input_x[0], 3) * pow(input_x[6], 1);
      idvg_poly_feat[127] = pow(input_x[0], 2) * pow(input_x[1], 2);
      idvg_poly_feat[128] = pow(input_x[0], 2) * pow(input_x[1], 1) * pow(input_x[2], 1);
      idvg_poly_feat[129] = pow(input_x[0], 2) * pow(input_x[1], 1) * pow(input_x[3], 1);
      idvg_poly_feat[130] = pow(input_x[0], 2) * pow(input_x[1], 1) * pow(input_x[4], 1);
      idvg_poly_feat[131] = pow(input_x[0], 2) * pow(input_x[1], 1) * pow(input_x[5], 1);
      idvg_poly_feat[132] = pow(input_x[0], 2) * pow(input_x[1], 1) * pow(input_x[6], 1);
      idvg_poly_feat[133] = pow(input_x[0], 2) * pow(input_x[2], 2);
      idvg_poly_feat[134] = pow(input_x[0], 2) * pow(input_x[2], 1) * pow(input_x[3], 1);
      idvg_poly_feat[135] = pow(input_x[0], 2) * pow(input_x[2], 1) * pow(input_x[4], 1);
      idvg_poly_feat[136] = pow(input_x[0], 2) * pow(input_x[2], 1) * pow(input_x[5], 1);
      idvg_poly_feat[137] = pow(input_x[0], 2) * pow(input_x[2], 1) * pow(input_x[6], 1);
      idvg_poly_feat[138] = pow(input_x[0], 2) * pow(input_x[3], 2);
      idvg_poly_feat[139] = pow(input_x[0], 2) * pow(input_x[3], 1) * pow(input_x[4], 1);
      idvg_poly_feat[140] = pow(input_x[0], 2) * pow(input_x[3], 1) * pow(input_x[5], 1);
      idvg_poly_feat[141] = pow(input_x[0], 2) * pow(input_x[3], 1) * pow(input_x[6], 1);
      idvg_poly_feat[142] = pow(input_x[0], 2) * pow(input_x[4], 2);
      idvg_poly_feat[143] = pow(input_x[0], 2) * pow(input_x[4], 1) * pow(input_x[5], 1);
      idvg_poly_feat[144] = pow(input_x[0], 2) * pow(input_x[4], 1) * pow(input_x[6], 1);
      idvg_poly_feat[145] = pow(input_x[0], 2) * pow(input_x[5], 2);
      idvg_poly_feat[146] = pow(input_x[0], 2) * pow(input_x[5], 1) * pow(input_x[6], 1);
      idvg_poly_feat[147] = pow(input_x[0], 2) * pow(input_x[6], 2);
      idvg_poly_feat[148] = pow(input_x[0], 1) * pow(input_x[1], 3);
      idvg_poly_feat[149] = pow(input_x[0], 1) * pow(input_x[1], 2) * pow(input_x[2], 1);
      idvg_poly_feat[150] = pow(input_x[0], 1) * pow(input_x[1], 2) * pow(input_x[3], 1);
      idvg_poly_feat[151] = pow(input_x[0], 1) * pow(input_x[1], 2) * pow(input_x[4], 1);
      idvg_poly_feat[152] = pow(input_x[0], 1) * pow(input_x[1], 2) * pow(input_x[5], 1);
      idvg_poly_feat[153] = pow(input_x[0], 1) * pow(input_x[1], 2) * pow(input_x[6], 1);
      idvg_poly_feat[154] = pow(input_x[0], 1) * pow(input_x[1], 1) * pow(input_x[2], 2);
      idvg_poly_feat[155] = pow(input_x[0], 1) * pow(input_x[1], 1) * pow(input_x[2], 1) * pow(input_x[3], 1);
      idvg_poly_feat[156] = pow(input_x[0], 1) * pow(input_x[1], 1) * pow(input_x[2], 1) * pow(input_x[4], 1);
      idvg_poly_feat[157] = pow(input_x[0], 1) * pow(input_x[1], 1) * pow(input_x[2], 1) * pow(input_x[5], 1);
      idvg_poly_feat[158] = pow(input_x[0], 1) * pow(input_x[1], 1) * pow(input_x[2], 1) * pow(input_x[6], 1);
      idvg_poly_feat[159] = pow(input_x[0], 1) * pow(input_x[1], 1) * pow(input_x[3], 2);
      idvg_poly_feat[160] = pow(input_x[0], 1) * pow(input_x[1], 1) * pow(input_x[3], 1) * pow(input_x[4], 1);
      idvg_poly_feat[161] = pow(input_x[0], 1) * pow(input_x[1], 1) * pow(input_x[3], 1) * pow(input_x[5], 1);
      idvg_poly_feat[162] = pow(input_x[0], 1) * pow(input_x[1], 1) * pow(input_x[3], 1) * pow(input_x[6], 1);
      idvg_poly_feat[163] = pow(input_x[0], 1) * pow(input_x[1], 1) * pow(input_x[4], 2);
      idvg_poly_feat[164] = pow(input_x[0], 1) * pow(input_x[1], 1) * pow(input_x[4], 1) * pow(input_x[5], 1);
      idvg_poly_feat[165] = pow(input_x[0], 1) * pow(input_x[1], 1) * pow(input_x[4], 1) * pow(input_x[6], 1);
      idvg_poly_feat[166] = pow(input_x[0], 1) * pow(input_x[1], 1) * pow(input_x[5], 2);
      idvg_poly_feat[167] = pow(input_x[0], 1) * pow(input_x[1], 1) * pow(input_x[5], 1) * pow(input_x[6], 1);
      idvg_poly_feat[168] = pow(input_x[0], 1) * pow(input_x[1], 1) * pow(input_x[6], 2);
      idvg_poly_feat[169] = pow(input_x[0], 1) * pow(input_x[2], 3);
      idvg_poly_feat[170] = pow(input_x[0], 1) * pow(input_x[2], 2) * pow(input_x[3], 1);
      idvg_poly_feat[171] = pow(input_x[0], 1) * pow(input_x[2], 2) * pow(input_x[4], 1);
      idvg_poly_feat[172] = pow(input_x[0], 1) * pow(input_x[2], 2) * pow(input_x[5], 1);
      idvg_poly_feat[173] = pow(input_x[0], 1) * pow(input_x[2], 2) * pow(input_x[6], 1);
      idvg_poly_feat[174] = pow(input_x[0], 1) * pow(input_x[2], 1) * pow(input_x[3], 2);
      idvg_poly_feat[175] = pow(input_x[0], 1) * pow(input_x[2], 1) * pow(input_x[3], 1) * pow(input_x[4], 1);
      idvg_poly_feat[176] = pow(input_x[0], 1) * pow(input_x[2], 1) * pow(input_x[3], 1) * pow(input_x[5], 1);
      idvg_poly_feat[177] = pow(input_x[0], 1) * pow(input_x[2], 1) * pow(input_x[3], 1) * pow(input_x[6], 1);
      idvg_poly_feat[178] = pow(input_x[0], 1) * pow(input_x[2], 1) * pow(input_x[4], 2);
      idvg_poly_feat[179] = pow(input_x[0], 1) * pow(input_x[2], 1) * pow(input_x[4], 1) * pow(input_x[5], 1);
      idvg_poly_feat[180] = pow(input_x[0], 1) * pow(input_x[2], 1) * pow(input_x[4], 1) * pow(input_x[6], 1);
      idvg_poly_feat[181] = pow(input_x[0], 1) * pow(input_x[2], 1) * pow(input_x[5], 2);
      idvg_poly_feat[182] = pow(input_x[0], 1) * pow(input_x[2], 1) * pow(input_x[5], 1) * pow(input_x[6], 1);
      idvg_poly_feat[183] = pow(input_x[0], 1) * pow(input_x[2], 1) * pow(input_x[6], 2);
      idvg_poly_feat[184] = pow(input_x[0], 1) * pow(input_x[3], 3);
      idvg_poly_feat[185] = pow(input_x[0], 1) * pow(input_x[3], 2) * pow(input_x[4], 1);
      idvg_poly_feat[186] = pow(input_x[0], 1) * pow(input_x[3], 2) * pow(input_x[5], 1);
      idvg_poly_feat[187] = pow(input_x[0], 1) * pow(input_x[3], 2) * pow(input_x[6], 1);
      idvg_poly_feat[188] = pow(input_x[0], 1) * pow(input_x[3], 1) * pow(input_x[4], 2);
      idvg_poly_feat[189] = pow(input_x[0], 1) * pow(input_x[3], 1) * pow(input_x[4], 1) * pow(input_x[5], 1);
      idvg_poly_feat[190] = pow(input_x[0], 1) * pow(input_x[3], 1) * pow(input_x[4], 1) * pow(input_x[6], 1);
      idvg_poly_feat[191] = pow(input_x[0], 1) * pow(input_x[3], 1) * pow(input_x[5], 2);
      idvg_poly_feat[192] = pow(input_x[0], 1) * pow(input_x[3], 1) * pow(input_x[5], 1) * pow(input_x[6], 1);
      idvg_poly_feat[193] = pow(input_x[0], 1) * pow(input_x[3], 1) * pow(input_x[6], 2);
      idvg_poly_feat[194] = pow(input_x[0], 1) * pow(input_x[4], 3);
      idvg_poly_feat[195] = pow(input_x[0], 1) * pow(input_x[4], 2) * pow(input_x[5], 1);
      idvg_poly_feat[196] = pow(input_x[0], 1) * pow(input_x[4], 2) * pow(input_x[6], 1);
      idvg_poly_feat[197] = pow(input_x[0], 1) * pow(input_x[4], 1) * pow(input_x[5], 2);
      idvg_poly_feat[198] = pow(input_x[0], 1) * pow(input_x[4], 1) * pow(input_x[5], 1) * pow(input_x[6], 1);
      idvg_poly_feat[199] = pow(input_x[0], 1) * pow(input_x[4], 1) * pow(input_x[6], 2);
      idvg_poly_feat[200] = pow(input_x[0], 1) * pow(input_x[5], 3);
      idvg_poly_feat[201] = pow(input_x[0], 1) * pow(input_x[5], 2) * pow(input_x[6], 1);
      idvg_poly_feat[202] = pow(input_x[0], 1) * pow(input_x[5], 1) * pow(input_x[6], 2);
      idvg_poly_feat[203] = pow(input_x[0], 1) * pow(input_x[6], 3);
      idvg_poly_feat[204] = pow(input_x[1], 4);
      idvg_poly_feat[205] = pow(input_x[1], 3) * pow(input_x[2], 1);
      idvg_poly_feat[206] = pow(input_x[1], 3) * pow(input_x[3], 1);
      idvg_poly_feat[207] = pow(input_x[1], 3) * pow(input_x[4], 1);
      idvg_poly_feat[208] = pow(input_x[1], 3) * pow(input_x[5], 1);
      idvg_poly_feat[209] = pow(input_x[1], 3) * pow(input_x[6], 1);
      idvg_poly_feat[210] = pow(input_x[1], 2) * pow(input_x[2], 2);
      idvg_poly_feat[211] = pow(input_x[1], 2) * pow(input_x[2], 1) * pow(input_x[3], 1);
      idvg_poly_feat[212] = pow(input_x[1], 2) * pow(input_x[2], 1) * pow(input_x[4], 1);
      idvg_poly_feat[213] = pow(input_x[1], 2) * pow(input_x[2], 1) * pow(input_x[5], 1);
      idvg_poly_feat[214] = pow(input_x[1], 2) * pow(input_x[2], 1) * pow(input_x[6], 1);
      idvg_poly_feat[215] = pow(input_x[1], 2) * pow(input_x[3], 2);
      idvg_poly_feat[216] = pow(input_x[1], 2) * pow(input_x[3], 1) * pow(input_x[4], 1);
      idvg_poly_feat[217] = pow(input_x[1], 2) * pow(input_x[3], 1) * pow(input_x[5], 1);
      idvg_poly_feat[218] = pow(input_x[1], 2) * pow(input_x[3], 1) * pow(input_x[6], 1);
      idvg_poly_feat[219] = pow(input_x[1], 2) * pow(input_x[4], 2);
      idvg_poly_feat[220] = pow(input_x[1], 2) * pow(input_x[4], 1) * pow(input_x[5], 1);
      idvg_poly_feat[221] = pow(input_x[1], 2) * pow(input_x[4], 1) * pow(input_x[6], 1);
      idvg_poly_feat[222] = pow(input_x[1], 2) * pow(input_x[5], 2);
      idvg_poly_feat[223] = pow(input_x[1], 2) * pow(input_x[5], 1) * pow(input_x[6], 1);
      idvg_poly_feat[224] = pow(input_x[1], 2) * pow(input_x[6], 2);
      idvg_poly_feat[225] = pow(input_x[1], 1) * pow(input_x[2], 3);
      idvg_poly_feat[226] = pow(input_x[1], 1) * pow(input_x[2], 2) * pow(input_x[3], 1);
      idvg_poly_feat[227] = pow(input_x[1], 1) * pow(input_x[2], 2) * pow(input_x[4], 1);
      idvg_poly_feat[228] = pow(input_x[1], 1) * pow(input_x[2], 2) * pow(input_x[5], 1);
      idvg_poly_feat[229] = pow(input_x[1], 1) * pow(input_x[2], 2) * pow(input_x[6], 1);
      idvg_poly_feat[230] = pow(input_x[1], 1) * pow(input_x[2], 1) * pow(input_x[3], 2);
      idvg_poly_feat[231] = pow(input_x[1], 1) * pow(input_x[2], 1) * pow(input_x[3], 1) * pow(input_x[4], 1);
      idvg_poly_feat[232] = pow(input_x[1], 1) * pow(input_x[2], 1) * pow(input_x[3], 1) * pow(input_x[5], 1);
      idvg_poly_feat[233] = pow(input_x[1], 1) * pow(input_x[2], 1) * pow(input_x[3], 1) * pow(input_x[6], 1);
      idvg_poly_feat[234] = pow(input_x[1], 1) * pow(input_x[2], 1) * pow(input_x[4], 2);
      idvg_poly_feat[235] = pow(input_x[1], 1) * pow(input_x[2], 1) * pow(input_x[4], 1) * pow(input_x[5], 1);
      idvg_poly_feat[236] = pow(input_x[1], 1) * pow(input_x[2], 1) * pow(input_x[4], 1) * pow(input_x[6], 1);
      idvg_poly_feat[237] = pow(input_x[1], 1) * pow(input_x[2], 1) * pow(input_x[5], 2);
      idvg_poly_feat[238] = pow(input_x[1], 1) * pow(input_x[2], 1) * pow(input_x[5], 1) * pow(input_x[6], 1);
      idvg_poly_feat[239] = pow(input_x[1], 1) * pow(input_x[2], 1) * pow(input_x[6], 2);
      idvg_poly_feat[240] = pow(input_x[1], 1) * pow(input_x[3], 3);
      idvg_poly_feat[241] = pow(input_x[1], 1) * pow(input_x[3], 2) * pow(input_x[4], 1);
      idvg_poly_feat[242] = pow(input_x[1], 1) * pow(input_x[3], 2) * pow(input_x[5], 1);
      idvg_poly_feat[243] = pow(input_x[1], 1) * pow(input_x[3], 2) * pow(input_x[6], 1);
      idvg_poly_feat[244] = pow(input_x[1], 1) * pow(input_x[3], 1) * pow(input_x[4], 2);
      idvg_poly_feat[245] = pow(input_x[1], 1) * pow(input_x[3], 1) * pow(input_x[4], 1) * pow(input_x[5], 1);
      idvg_poly_feat[246] = pow(input_x[1], 1) * pow(input_x[3], 1) * pow(input_x[4], 1) * pow(input_x[6], 1);
      idvg_poly_feat[247] = pow(input_x[1], 1) * pow(input_x[3], 1) * pow(input_x[5], 2);
      idvg_poly_feat[248] = pow(input_x[1], 1) * pow(input_x[3], 1) * pow(input_x[5], 1) * pow(input_x[6], 1);
      idvg_poly_feat[249] = pow(input_x[1], 1) * pow(input_x[3], 1) * pow(input_x[6], 2);
      idvg_poly_feat[250] = pow(input_x[1], 1) * pow(input_x[4], 3);
      idvg_poly_feat[251] = pow(input_x[1], 1) * pow(input_x[4], 2) * pow(input_x[5], 1);
      idvg_poly_feat[252] = pow(input_x[1], 1) * pow(input_x[4], 2) * pow(input_x[6], 1);
      idvg_poly_feat[253] = pow(input_x[1], 1) * pow(input_x[4], 1) * pow(input_x[5], 2);
      idvg_poly_feat[254] = pow(input_x[1], 1) * pow(input_x[4], 1) * pow(input_x[5], 1) * pow(input_x[6], 1);
      idvg_poly_feat[255] = pow(input_x[1], 1) * pow(input_x[4], 1) * pow(input_x[6], 2);
      idvg_poly_feat[256] = pow(input_x[1], 1) * pow(input_x[5], 3);
      idvg_poly_feat[257] = pow(input_x[1], 1) * pow(input_x[5], 2) * pow(input_x[6], 1);
      idvg_poly_feat[258] = pow(input_x[1], 1) * pow(input_x[5], 1) * pow(input_x[6], 2);
      idvg_poly_feat[259] = pow(input_x[1], 1) * pow(input_x[6], 3);
      idvg_poly_feat[260] = pow(input_x[2], 4);
      idvg_poly_feat[261] = pow(input_x[2], 3) * pow(input_x[3], 1);
      idvg_poly_feat[262] = pow(input_x[2], 3) * pow(input_x[4], 1);
      idvg_poly_feat[263] = pow(input_x[2], 3) * pow(input_x[5], 1);
      idvg_poly_feat[264] = pow(input_x[2], 3) * pow(input_x[6], 1);
      idvg_poly_feat[265] = pow(input_x[2], 2) * pow(input_x[3], 2);
      idvg_poly_feat[266] = pow(input_x[2], 2) * pow(input_x[3], 1) * pow(input_x[4], 1);
      idvg_poly_feat[267] = pow(input_x[2], 2) * pow(input_x[3], 1) * pow(input_x[5], 1);
      idvg_poly_feat[268] = pow(input_x[2], 2) * pow(input_x[3], 1) * pow(input_x[6], 1);
      idvg_poly_feat[269] = pow(input_x[2], 2) * pow(input_x[4], 2);
      idvg_poly_feat[270] = pow(input_x[2], 2) * pow(input_x[4], 1) * pow(input_x[5], 1);
      idvg_poly_feat[271] = pow(input_x[2], 2) * pow(input_x[4], 1) * pow(input_x[6], 1);
      idvg_poly_feat[272] = pow(input_x[2], 2) * pow(input_x[5], 2);
      idvg_poly_feat[273] = pow(input_x[2], 2) * pow(input_x[5], 1) * pow(input_x[6], 1);
      idvg_poly_feat[274] = pow(input_x[2], 2) * pow(input_x[6], 2);
      idvg_poly_feat[275] = pow(input_x[2], 1) * pow(input_x[3], 3);
      idvg_poly_feat[276] = pow(input_x[2], 1) * pow(input_x[3], 2) * pow(input_x[4], 1);
      idvg_poly_feat[277] = pow(input_x[2], 1) * pow(input_x[3], 2) * pow(input_x[5], 1);
      idvg_poly_feat[278] = pow(input_x[2], 1) * pow(input_x[3], 2) * pow(input_x[6], 1);
      idvg_poly_feat[279] = pow(input_x[2], 1) * pow(input_x[3], 1) * pow(input_x[4], 2);
      idvg_poly_feat[280] = pow(input_x[2], 1) * pow(input_x[3], 1) * pow(input_x[4], 1) * pow(input_x[5], 1);
      idvg_poly_feat[281] = pow(input_x[2], 1) * pow(input_x[3], 1) * pow(input_x[4], 1) * pow(input_x[6], 1);
      idvg_poly_feat[282] = pow(input_x[2], 1) * pow(input_x[3], 1) * pow(input_x[5], 2);
      idvg_poly_feat[283] = pow(input_x[2], 1) * pow(input_x[3], 1) * pow(input_x[5], 1) * pow(input_x[6], 1);
      idvg_poly_feat[284] = pow(input_x[2], 1) * pow(input_x[3], 1) * pow(input_x[6], 2);
      idvg_poly_feat[285] = pow(input_x[2], 1) * pow(input_x[4], 3);
      idvg_poly_feat[286] = pow(input_x[2], 1) * pow(input_x[4], 2) * pow(input_x[5], 1);
      idvg_poly_feat[287] = pow(input_x[2], 1) * pow(input_x[4], 2) * pow(input_x[6], 1);
      idvg_poly_feat[288] = pow(input_x[2], 1) * pow(input_x[4], 1) * pow(input_x[5], 2);
      idvg_poly_feat[289] = pow(input_x[2], 1) * pow(input_x[4], 1) * pow(input_x[5], 1) * pow(input_x[6], 1);
      idvg_poly_feat[290] = pow(input_x[2], 1) * pow(input_x[4], 1) * pow(input_x[6], 2);
      idvg_poly_feat[291] = pow(input_x[2], 1) * pow(input_x[5], 3);
      idvg_poly_feat[292] = pow(input_x[2], 1) * pow(input_x[5], 2) * pow(input_x[6], 1);
      idvg_poly_feat[293] = pow(input_x[2], 1) * pow(input_x[5], 1) * pow(input_x[6], 2);
      idvg_poly_feat[294] = pow(input_x[2], 1) * pow(input_x[6], 3);
      idvg_poly_feat[295] = pow(input_x[3], 4);
      idvg_poly_feat[296] = pow(input_x[3], 3) * pow(input_x[4], 1);
      idvg_poly_feat[297] = pow(input_x[3], 3) * pow(input_x[5], 1);
      idvg_poly_feat[298] = pow(input_x[3], 3) * pow(input_x[6], 1);
      idvg_poly_feat[299] = pow(input_x[3], 2) * pow(input_x[4], 2);
      idvg_poly_feat[300] = pow(input_x[3], 2) * pow(input_x[4], 1) * pow(input_x[5], 1);
      idvg_poly_feat[301] = pow(input_x[3], 2) * pow(input_x[4], 1) * pow(input_x[6], 1);
      idvg_poly_feat[302] = pow(input_x[3], 2) * pow(input_x[5], 2);
      idvg_poly_feat[303] = pow(input_x[3], 2) * pow(input_x[5], 1) * pow(input_x[6], 1);
      idvg_poly_feat[304] = pow(input_x[3], 2) * pow(input_x[6], 2);
      idvg_poly_feat[305] = pow(input_x[3], 1) * pow(input_x[4], 3);
      idvg_poly_feat[306] = pow(input_x[3], 1) * pow(input_x[4], 2) * pow(input_x[5], 1);
      idvg_poly_feat[307] = pow(input_x[3], 1) * pow(input_x[4], 2) * pow(input_x[6], 1);
      idvg_poly_feat[308] = pow(input_x[3], 1) * pow(input_x[4], 1) * pow(input_x[5], 2);
      idvg_poly_feat[309] = pow(input_x[3], 1) * pow(input_x[4], 1) * pow(input_x[5], 1) * pow(input_x[6], 1);
      idvg_poly_feat[310] = pow(input_x[3], 1) * pow(input_x[4], 1) * pow(input_x[6], 2);
      idvg_poly_feat[311] = pow(input_x[3], 1) * pow(input_x[5], 3);
      idvg_poly_feat[312] = pow(input_x[3], 1) * pow(input_x[5], 2) * pow(input_x[6], 1);
      idvg_poly_feat[313] = pow(input_x[3], 1) * pow(input_x[5], 1) * pow(input_x[6], 2);
      idvg_poly_feat[314] = pow(input_x[3], 1) * pow(input_x[6], 3);
      idvg_poly_feat[315] = pow(input_x[4], 4);
      idvg_poly_feat[316] = pow(input_x[4], 3) * pow(input_x[5], 1);
      idvg_poly_feat[317] = pow(input_x[4], 3) * pow(input_x[6], 1);
      idvg_poly_feat[318] = pow(input_x[4], 2) * pow(input_x[5], 2);
      idvg_poly_feat[319] = pow(input_x[4], 2) * pow(input_x[5], 1) * pow(input_x[6], 1);
      idvg_poly_feat[320] = pow(input_x[4], 2) * pow(input_x[6], 2);
      idvg_poly_feat[321] = pow(input_x[4], 1) * pow(input_x[5], 3);
      idvg_poly_feat[322] = pow(input_x[4], 1) * pow(input_x[5], 2) * pow(input_x[6], 1);
      idvg_poly_feat[323] = pow(input_x[4], 1) * pow(input_x[5], 1) * pow(input_x[6], 2);
      idvg_poly_feat[324] = pow(input_x[4], 1) * pow(input_x[6], 3);
      idvg_poly_feat[325] = pow(input_x[5], 4);
      idvg_poly_feat[326] = pow(input_x[5], 3) * pow(input_x[6], 1);
      idvg_poly_feat[327] = pow(input_x[5], 2) * pow(input_x[6], 2);
      idvg_poly_feat[328] = pow(input_x[5], 1) * pow(input_x[6], 3);
      idvg_poly_feat[329] = pow(input_x[6], 4);
      idvg_poly_feat[330] = pow(input_x[0], 5);
      idvg_poly_feat[331] = pow(input_x[0], 4) * pow(input_x[1], 1);
      idvg_poly_feat[332] = pow(input_x[0], 4) * pow(input_x[2], 1);
      idvg_poly_feat[333] = pow(input_x[0], 4) * pow(input_x[3], 1);
      idvg_poly_feat[334] = pow(input_x[0], 4) * pow(input_x[4], 1);
      idvg_poly_feat[335] = pow(input_x[0], 4) * pow(input_x[5], 1);
      idvg_poly_feat[336] = pow(input_x[0], 4) * pow(input_x[6], 1);
      idvg_poly_feat[337] = pow(input_x[0], 3) * pow(input_x[1], 2);
      idvg_poly_feat[338] = pow(input_x[0], 3) * pow(input_x[1], 1) * pow(input_x[2], 1);
      idvg_poly_feat[339] = pow(input_x[0], 3) * pow(input_x[1], 1) * pow(input_x[3], 1);
      idvg_poly_feat[340] = pow(input_x[0], 3) * pow(input_x[1], 1) * pow(input_x[4], 1);
      idvg_poly_feat[341] = pow(input_x[0], 3) * pow(input_x[1], 1) * pow(input_x[5], 1);
      idvg_poly_feat[342] = pow(input_x[0], 3) * pow(input_x[1], 1) * pow(input_x[6], 1);
      idvg_poly_feat[343] = pow(input_x[0], 3) * pow(input_x[2], 2);
      idvg_poly_feat[344] = pow(input_x[0], 3) * pow(input_x[2], 1) * pow(input_x[3], 1);
      idvg_poly_feat[345] = pow(input_x[0], 3) * pow(input_x[2], 1) * pow(input_x[4], 1);
      idvg_poly_feat[346] = pow(input_x[0], 3) * pow(input_x[2], 1) * pow(input_x[5], 1);
      idvg_poly_feat[347] = pow(input_x[0], 3) * pow(input_x[2], 1) * pow(input_x[6], 1);
      idvg_poly_feat[348] = pow(input_x[0], 3) * pow(input_x[3], 2);
      idvg_poly_feat[349] = pow(input_x[0], 3) * pow(input_x[3], 1) * pow(input_x[4], 1);
      idvg_poly_feat[350] = pow(input_x[0], 3) * pow(input_x[3], 1) * pow(input_x[5], 1);
      idvg_poly_feat[351] = pow(input_x[0], 3) * pow(input_x[3], 1) * pow(input_x[6], 1);
      idvg_poly_feat[352] = pow(input_x[0], 3) * pow(input_x[4], 2);
      idvg_poly_feat[353] = pow(input_x[0], 3) * pow(input_x[4], 1) * pow(input_x[5], 1);
      idvg_poly_feat[354] = pow(input_x[0], 3) * pow(input_x[4], 1) * pow(input_x[6], 1);
      idvg_poly_feat[355] = pow(input_x[0], 3) * pow(input_x[5], 2);
      idvg_poly_feat[356] = pow(input_x[0], 3) * pow(input_x[5], 1) * pow(input_x[6], 1);
      idvg_poly_feat[357] = pow(input_x[0], 3) * pow(input_x[6], 2);
      idvg_poly_feat[358] = pow(input_x[0], 2) * pow(input_x[1], 3);
      idvg_poly_feat[359] = pow(input_x[0], 2) * pow(input_x[1], 2) * pow(input_x[2], 1);
      idvg_poly_feat[360] = pow(input_x[0], 2) * pow(input_x[1], 2) * pow(input_x[3], 1);
      idvg_poly_feat[361] = pow(input_x[0], 2) * pow(input_x[1], 2) * pow(input_x[4], 1);
      idvg_poly_feat[362] = pow(input_x[0], 2) * pow(input_x[1], 2) * pow(input_x[5], 1);
      idvg_poly_feat[363] = pow(input_x[0], 2) * pow(input_x[1], 2) * pow(input_x[6], 1);
      idvg_poly_feat[364] = pow(input_x[0], 2) * pow(input_x[1], 1) * pow(input_x[2], 2);
      idvg_poly_feat[365] = pow(input_x[0], 2) * pow(input_x[1], 1) * pow(input_x[2], 1) * pow(input_x[3], 1);
      idvg_poly_feat[366] = pow(input_x[0], 2) * pow(input_x[1], 1) * pow(input_x[2], 1) * pow(input_x[4], 1);
      idvg_poly_feat[367] = pow(input_x[0], 2) * pow(input_x[1], 1) * pow(input_x[2], 1) * pow(input_x[5], 1);
      idvg_poly_feat[368] = pow(input_x[0], 2) * pow(input_x[1], 1) * pow(input_x[2], 1) * pow(input_x[6], 1);
      idvg_poly_feat[369] = pow(input_x[0], 2) * pow(input_x[1], 1) * pow(input_x[3], 2);
      idvg_poly_feat[370] = pow(input_x[0], 2) * pow(input_x[1], 1) * pow(input_x[3], 1) * pow(input_x[4], 1);
      idvg_poly_feat[371] = pow(input_x[0], 2) * pow(input_x[1], 1) * pow(input_x[3], 1) * pow(input_x[5], 1);
      idvg_poly_feat[372] = pow(input_x[0], 2) * pow(input_x[1], 1) * pow(input_x[3], 1) * pow(input_x[6], 1);
      idvg_poly_feat[373] = pow(input_x[0], 2) * pow(input_x[1], 1) * pow(input_x[4], 2);
      idvg_poly_feat[374] = pow(input_x[0], 2) * pow(input_x[1], 1) * pow(input_x[4], 1) * pow(input_x[5], 1);
      idvg_poly_feat[375] = pow(input_x[0], 2) * pow(input_x[1], 1) * pow(input_x[4], 1) * pow(input_x[6], 1);
      idvg_poly_feat[376] = pow(input_x[0], 2) * pow(input_x[1], 1) * pow(input_x[5], 2);
      idvg_poly_feat[377] = pow(input_x[0], 2) * pow(input_x[1], 1) * pow(input_x[5], 1) * pow(input_x[6], 1);
      idvg_poly_feat[378] = pow(input_x[0], 2) * pow(input_x[1], 1) * pow(input_x[6], 2);
      idvg_poly_feat[379] = pow(input_x[0], 2) * pow(input_x[2], 3);
      idvg_poly_feat[380] = pow(input_x[0], 2) * pow(input_x[2], 2) * pow(input_x[3], 1);
      idvg_poly_feat[381] = pow(input_x[0], 2) * pow(input_x[2], 2) * pow(input_x[4], 1);
      idvg_poly_feat[382] = pow(input_x[0], 2) * pow(input_x[2], 2) * pow(input_x[5], 1);
      idvg_poly_feat[383] = pow(input_x[0], 2) * pow(input_x[2], 2) * pow(input_x[6], 1);
      idvg_poly_feat[384] = pow(input_x[0], 2) * pow(input_x[2], 1) * pow(input_x[3], 2);
      idvg_poly_feat[385] = pow(input_x[0], 2) * pow(input_x[2], 1) * pow(input_x[3], 1) * pow(input_x[4], 1);
      idvg_poly_feat[386] = pow(input_x[0], 2) * pow(input_x[2], 1) * pow(input_x[3], 1) * pow(input_x[5], 1);
      idvg_poly_feat[387] = pow(input_x[0], 2) * pow(input_x[2], 1) * pow(input_x[3], 1) * pow(input_x[6], 1);
      idvg_poly_feat[388] = pow(input_x[0], 2) * pow(input_x[2], 1) * pow(input_x[4], 2);
      idvg_poly_feat[389] = pow(input_x[0], 2) * pow(input_x[2], 1) * pow(input_x[4], 1) * pow(input_x[5], 1);
      idvg_poly_feat[390] = pow(input_x[0], 2) * pow(input_x[2], 1) * pow(input_x[4], 1) * pow(input_x[6], 1);
      idvg_poly_feat[391] = pow(input_x[0], 2) * pow(input_x[2], 1) * pow(input_x[5], 2);
      idvg_poly_feat[392] = pow(input_x[0], 2) * pow(input_x[2], 1) * pow(input_x[5], 1) * pow(input_x[6], 1);
      idvg_poly_feat[393] = pow(input_x[0], 2) * pow(input_x[2], 1) * pow(input_x[6], 2);
      idvg_poly_feat[394] = pow(input_x[0], 2) * pow(input_x[3], 3);
      idvg_poly_feat[395] = pow(input_x[0], 2) * pow(input_x[3], 2) * pow(input_x[4], 1);
      idvg_poly_feat[396] = pow(input_x[0], 2) * pow(input_x[3], 2) * pow(input_x[5], 1);
      idvg_poly_feat[397] = pow(input_x[0], 2) * pow(input_x[3], 2) * pow(input_x[6], 1);
      idvg_poly_feat[398] = pow(input_x[0], 2) * pow(input_x[3], 1) * pow(input_x[4], 2);
      idvg_poly_feat[399] = pow(input_x[0], 2) * pow(input_x[3], 1) * pow(input_x[4], 1) * pow(input_x[5], 1);
      idvg_poly_feat[400] = pow(input_x[0], 2) * pow(input_x[3], 1) * pow(input_x[4], 1) * pow(input_x[6], 1);
      idvg_poly_feat[401] = pow(input_x[0], 2) * pow(input_x[3], 1) * pow(input_x[5], 2);
      idvg_poly_feat[402] = pow(input_x[0], 2) * pow(input_x[3], 1) * pow(input_x[5], 1) * pow(input_x[6], 1);
      idvg_poly_feat[403] = pow(input_x[0], 2) * pow(input_x[3], 1) * pow(input_x[6], 2);
      idvg_poly_feat[404] = pow(input_x[0], 2) * pow(input_x[4], 3);
      idvg_poly_feat[405] = pow(input_x[0], 2) * pow(input_x[4], 2) * pow(input_x[5], 1);
      idvg_poly_feat[406] = pow(input_x[0], 2) * pow(input_x[4], 2) * pow(input_x[6], 1);
      idvg_poly_feat[407] = pow(input_x[0], 2) * pow(input_x[4], 1) * pow(input_x[5], 2);
      idvg_poly_feat[408] = pow(input_x[0], 2) * pow(input_x[4], 1) * pow(input_x[5], 1) * pow(input_x[6], 1);
      idvg_poly_feat[409] = pow(input_x[0], 2) * pow(input_x[4], 1) * pow(input_x[6], 2);
      idvg_poly_feat[410] = pow(input_x[0], 2) * pow(input_x[5], 3);
      idvg_poly_feat[411] = pow(input_x[0], 2) * pow(input_x[5], 2) * pow(input_x[6], 1);
      idvg_poly_feat[412] = pow(input_x[0], 2) * pow(input_x[5], 1) * pow(input_x[6], 2);
      idvg_poly_feat[413] = pow(input_x[0], 2) * pow(input_x[6], 3);
      idvg_poly_feat[414] = pow(input_x[0], 1) * pow(input_x[1], 4);
      idvg_poly_feat[415] = pow(input_x[0], 1) * pow(input_x[1], 3) * pow(input_x[2], 1);
      idvg_poly_feat[416] = pow(input_x[0], 1) * pow(input_x[1], 3) * pow(input_x[3], 1);
      idvg_poly_feat[417] = pow(input_x[0], 1) * pow(input_x[1], 3) * pow(input_x[4], 1);
      idvg_poly_feat[418] = pow(input_x[0], 1) * pow(input_x[1], 3) * pow(input_x[5], 1);
      idvg_poly_feat[419] = pow(input_x[0], 1) * pow(input_x[1], 3) * pow(input_x[6], 1);
      idvg_poly_feat[420] = pow(input_x[0], 1) * pow(input_x[1], 2) * pow(input_x[2], 2);
      idvg_poly_feat[421] = pow(input_x[0], 1) * pow(input_x[1], 2) * pow(input_x[2], 1) * pow(input_x[3], 1);
      idvg_poly_feat[422] = pow(input_x[0], 1) * pow(input_x[1], 2) * pow(input_x[2], 1) * pow(input_x[4], 1);
      idvg_poly_feat[423] = pow(input_x[0], 1) * pow(input_x[1], 2) * pow(input_x[2], 1) * pow(input_x[5], 1);
      idvg_poly_feat[424] = pow(input_x[0], 1) * pow(input_x[1], 2) * pow(input_x[2], 1) * pow(input_x[6], 1);
      idvg_poly_feat[425] = pow(input_x[0], 1) * pow(input_x[1], 2) * pow(input_x[3], 2);
      idvg_poly_feat[426] = pow(input_x[0], 1) * pow(input_x[1], 2) * pow(input_x[3], 1) * pow(input_x[4], 1);
      idvg_poly_feat[427] = pow(input_x[0], 1) * pow(input_x[1], 2) * pow(input_x[3], 1) * pow(input_x[5], 1);
      idvg_poly_feat[428] = pow(input_x[0], 1) * pow(input_x[1], 2) * pow(input_x[3], 1) * pow(input_x[6], 1);
      idvg_poly_feat[429] = pow(input_x[0], 1) * pow(input_x[1], 2) * pow(input_x[4], 2);
      idvg_poly_feat[430] = pow(input_x[0], 1) * pow(input_x[1], 2) * pow(input_x[4], 1) * pow(input_x[5], 1);
      idvg_poly_feat[431] = pow(input_x[0], 1) * pow(input_x[1], 2) * pow(input_x[4], 1) * pow(input_x[6], 1);
      idvg_poly_feat[432] = pow(input_x[0], 1) * pow(input_x[1], 2) * pow(input_x[5], 2);
      idvg_poly_feat[433] = pow(input_x[0], 1) * pow(input_x[1], 2) * pow(input_x[5], 1) * pow(input_x[6], 1);
      idvg_poly_feat[434] = pow(input_x[0], 1) * pow(input_x[1], 2) * pow(input_x[6], 2);
      idvg_poly_feat[435] = pow(input_x[0], 1) * pow(input_x[1], 1) * pow(input_x[2], 3);
      idvg_poly_feat[436] = pow(input_x[0], 1) * pow(input_x[1], 1) * pow(input_x[2], 2) * pow(input_x[3], 1);
      idvg_poly_feat[437] = pow(input_x[0], 1) * pow(input_x[1], 1) * pow(input_x[2], 2) * pow(input_x[4], 1);
      idvg_poly_feat[438] = pow(input_x[0], 1) * pow(input_x[1], 1) * pow(input_x[2], 2) * pow(input_x[5], 1);
      idvg_poly_feat[439] = pow(input_x[0], 1) * pow(input_x[1], 1) * pow(input_x[2], 2) * pow(input_x[6], 1);
      idvg_poly_feat[440] = pow(input_x[0], 1) * pow(input_x[1], 1) * pow(input_x[2], 1) * pow(input_x[3], 2);
      idvg_poly_feat[441] = pow(input_x[0], 1) * pow(input_x[1], 1) * pow(input_x[2], 1) * pow(input_x[3], 1) * pow(input_x[4], 1);
      idvg_poly_feat[442] = pow(input_x[0], 1) * pow(input_x[1], 1) * pow(input_x[2], 1) * pow(input_x[3], 1) * pow(input_x[5], 1);
      idvg_poly_feat[443] = pow(input_x[0], 1) * pow(input_x[1], 1) * pow(input_x[2], 1) * pow(input_x[3], 1) * pow(input_x[6], 1);
      idvg_poly_feat[444] = pow(input_x[0], 1) * pow(input_x[1], 1) * pow(input_x[2], 1) * pow(input_x[4], 2);
      idvg_poly_feat[445] = pow(input_x[0], 1) * pow(input_x[1], 1) * pow(input_x[2], 1) * pow(input_x[4], 1) * pow(input_x[5], 1);
      idvg_poly_feat[446] = pow(input_x[0], 1) * pow(input_x[1], 1) * pow(input_x[2], 1) * pow(input_x[4], 1) * pow(input_x[6], 1);
      idvg_poly_feat[447] = pow(input_x[0], 1) * pow(input_x[1], 1) * pow(input_x[2], 1) * pow(input_x[5], 2);
      idvg_poly_feat[448] = pow(input_x[0], 1) * pow(input_x[1], 1) * pow(input_x[2], 1) * pow(input_x[5], 1) * pow(input_x[6], 1);
      idvg_poly_feat[449] = pow(input_x[0], 1) * pow(input_x[1], 1) * pow(input_x[2], 1) * pow(input_x[6], 2);
      idvg_poly_feat[450] = pow(input_x[0], 1) * pow(input_x[1], 1) * pow(input_x[3], 3);
      idvg_poly_feat[451] = pow(input_x[0], 1) * pow(input_x[1], 1) * pow(input_x[3], 2) * pow(input_x[4], 1);
      idvg_poly_feat[452] = pow(input_x[0], 1) * pow(input_x[1], 1) * pow(input_x[3], 2) * pow(input_x[5], 1);
      idvg_poly_feat[453] = pow(input_x[0], 1) * pow(input_x[1], 1) * pow(input_x[3], 2) * pow(input_x[6], 1);
      idvg_poly_feat[454] = pow(input_x[0], 1) * pow(input_x[1], 1) * pow(input_x[3], 1) * pow(input_x[4], 2);
      idvg_poly_feat[455] = pow(input_x[0], 1) * pow(input_x[1], 1) * pow(input_x[3], 1) * pow(input_x[4], 1) * pow(input_x[5], 1);
      idvg_poly_feat[456] = pow(input_x[0], 1) * pow(input_x[1], 1) * pow(input_x[3], 1) * pow(input_x[4], 1) * pow(input_x[6], 1);
      idvg_poly_feat[457] = pow(input_x[0], 1) * pow(input_x[1], 1) * pow(input_x[3], 1) * pow(input_x[5], 2);
      idvg_poly_feat[458] = pow(input_x[0], 1) * pow(input_x[1], 1) * pow(input_x[3], 1) * pow(input_x[5], 1) * pow(input_x[6], 1);
      idvg_poly_feat[459] = pow(input_x[0], 1) * pow(input_x[1], 1) * pow(input_x[3], 1) * pow(input_x[6], 2);
      idvg_poly_feat[460] = pow(input_x[0], 1) * pow(input_x[1], 1) * pow(input_x[4], 3);
      idvg_poly_feat[461] = pow(input_x[0], 1) * pow(input_x[1], 1) * pow(input_x[4], 2) * pow(input_x[5], 1);
      idvg_poly_feat[462] = pow(input_x[0], 1) * pow(input_x[1], 1) * pow(input_x[4], 2) * pow(input_x[6], 1);
      idvg_poly_feat[463] = pow(input_x[0], 1) * pow(input_x[1], 1) * pow(input_x[4], 1) * pow(input_x[5], 2);
      idvg_poly_feat[464] = pow(input_x[0], 1) * pow(input_x[1], 1) * pow(input_x[4], 1) * pow(input_x[5], 1) * pow(input_x[6], 1);
      idvg_poly_feat[465] = pow(input_x[0], 1) * pow(input_x[1], 1) * pow(input_x[4], 1) * pow(input_x[6], 2);
      idvg_poly_feat[466] = pow(input_x[0], 1) * pow(input_x[1], 1) * pow(input_x[5], 3);
      idvg_poly_feat[467] = pow(input_x[0], 1) * pow(input_x[1], 1) * pow(input_x[5], 2) * pow(input_x[6], 1);
      idvg_poly_feat[468] = pow(input_x[0], 1) * pow(input_x[1], 1) * pow(input_x[5], 1) * pow(input_x[6], 2);
      idvg_poly_feat[469] = pow(input_x[0], 1) * pow(input_x[1], 1) * pow(input_x[6], 3);
      idvg_poly_feat[470] = pow(input_x[0], 1) * pow(input_x[2], 4);
      idvg_poly_feat[471] = pow(input_x[0], 1) * pow(input_x[2], 3) * pow(input_x[3], 1);
      idvg_poly_feat[472] = pow(input_x[0], 1) * pow(input_x[2], 3) * pow(input_x[4], 1);
      idvg_poly_feat[473] = pow(input_x[0], 1) * pow(input_x[2], 3) * pow(input_x[5], 1);
      idvg_poly_feat[474] = pow(input_x[0], 1) * pow(input_x[2], 3) * pow(input_x[6], 1);
      idvg_poly_feat[475] = pow(input_x[0], 1) * pow(input_x[2], 2) * pow(input_x[3], 2);
      idvg_poly_feat[476] = pow(input_x[0], 1) * pow(input_x[2], 2) * pow(input_x[3], 1) * pow(input_x[4], 1);
      idvg_poly_feat[477] = pow(input_x[0], 1) * pow(input_x[2], 2) * pow(input_x[3], 1) * pow(input_x[5], 1);
      idvg_poly_feat[478] = pow(input_x[0], 1) * pow(input_x[2], 2) * pow(input_x[3], 1) * pow(input_x[6], 1);
      idvg_poly_feat[479] = pow(input_x[0], 1) * pow(input_x[2], 2) * pow(input_x[4], 2);
      idvg_poly_feat[480] = pow(input_x[0], 1) * pow(input_x[2], 2) * pow(input_x[4], 1) * pow(input_x[5], 1);
      idvg_poly_feat[481] = pow(input_x[0], 1) * pow(input_x[2], 2) * pow(input_x[4], 1) * pow(input_x[6], 1);
      idvg_poly_feat[482] = pow(input_x[0], 1) * pow(input_x[2], 2) * pow(input_x[5], 2);
      idvg_poly_feat[483] = pow(input_x[0], 1) * pow(input_x[2], 2) * pow(input_x[5], 1) * pow(input_x[6], 1);
      idvg_poly_feat[484] = pow(input_x[0], 1) * pow(input_x[2], 2) * pow(input_x[6], 2);
      idvg_poly_feat[485] = pow(input_x[0], 1) * pow(input_x[2], 1) * pow(input_x[3], 3);
      idvg_poly_feat[486] = pow(input_x[0], 1) * pow(input_x[2], 1) * pow(input_x[3], 2) * pow(input_x[4], 1);
      idvg_poly_feat[487] = pow(input_x[0], 1) * pow(input_x[2], 1) * pow(input_x[3], 2) * pow(input_x[5], 1);
      idvg_poly_feat[488] = pow(input_x[0], 1) * pow(input_x[2], 1) * pow(input_x[3], 2) * pow(input_x[6], 1);
      idvg_poly_feat[489] = pow(input_x[0], 1) * pow(input_x[2], 1) * pow(input_x[3], 1) * pow(input_x[4], 2);
      idvg_poly_feat[490] = pow(input_x[0], 1) * pow(input_x[2], 1) * pow(input_x[3], 1) * pow(input_x[4], 1) * pow(input_x[5], 1);
      idvg_poly_feat[491] = pow(input_x[0], 1) * pow(input_x[2], 1) * pow(input_x[3], 1) * pow(input_x[4], 1) * pow(input_x[6], 1);
      idvg_poly_feat[492] = pow(input_x[0], 1) * pow(input_x[2], 1) * pow(input_x[3], 1) * pow(input_x[5], 2);
      idvg_poly_feat[493] = pow(input_x[0], 1) * pow(input_x[2], 1) * pow(input_x[3], 1) * pow(input_x[5], 1) * pow(input_x[6], 1);
      idvg_poly_feat[494] = pow(input_x[0], 1) * pow(input_x[2], 1) * pow(input_x[3], 1) * pow(input_x[6], 2);
      idvg_poly_feat[495] = pow(input_x[0], 1) * pow(input_x[2], 1) * pow(input_x[4], 3);
      idvg_poly_feat[496] = pow(input_x[0], 1) * pow(input_x[2], 1) * pow(input_x[4], 2) * pow(input_x[5], 1);
      idvg_poly_feat[497] = pow(input_x[0], 1) * pow(input_x[2], 1) * pow(input_x[4], 2) * pow(input_x[6], 1);
      idvg_poly_feat[498] = pow(input_x[0], 1) * pow(input_x[2], 1) * pow(input_x[4], 1) * pow(input_x[5], 2);
      idvg_poly_feat[499] = pow(input_x[0], 1) * pow(input_x[2], 1) * pow(input_x[4], 1) * pow(input_x[5], 1) * pow(input_x[6], 1);
      idvg_poly_feat[500] = pow(input_x[0], 1) * pow(input_x[2], 1) * pow(input_x[4], 1) * pow(input_x[6], 2);
      idvg_poly_feat[501] = pow(input_x[0], 1) * pow(input_x[2], 1) * pow(input_x[5], 3);
      idvg_poly_feat[502] = pow(input_x[0], 1) * pow(input_x[2], 1) * pow(input_x[5], 2) * pow(input_x[6], 1);
      idvg_poly_feat[503] = pow(input_x[0], 1) * pow(input_x[2], 1) * pow(input_x[5], 1) * pow(input_x[6], 2);
      idvg_poly_feat[504] = pow(input_x[0], 1) * pow(input_x[2], 1) * pow(input_x[6], 3);
      idvg_poly_feat[505] = pow(input_x[0], 1) * pow(input_x[3], 4);
      idvg_poly_feat[506] = pow(input_x[0], 1) * pow(input_x[3], 3) * pow(input_x[4], 1);
      idvg_poly_feat[507] = pow(input_x[0], 1) * pow(input_x[3], 3) * pow(input_x[5], 1);
      idvg_poly_feat[508] = pow(input_x[0], 1) * pow(input_x[3], 3) * pow(input_x[6], 1);
      idvg_poly_feat[509] = pow(input_x[0], 1) * pow(input_x[3], 2) * pow(input_x[4], 2);
      idvg_poly_feat[510] = pow(input_x[0], 1) * pow(input_x[3], 2) * pow(input_x[4], 1) * pow(input_x[5], 1);
      idvg_poly_feat[511] = pow(input_x[0], 1) * pow(input_x[3], 2) * pow(input_x[4], 1) * pow(input_x[6], 1);
      idvg_poly_feat[512] = pow(input_x[0], 1) * pow(input_x[3], 2) * pow(input_x[5], 2);
      idvg_poly_feat[513] = pow(input_x[0], 1) * pow(input_x[3], 2) * pow(input_x[5], 1) * pow(input_x[6], 1);
      idvg_poly_feat[514] = pow(input_x[0], 1) * pow(input_x[3], 2) * pow(input_x[6], 2);
      idvg_poly_feat[515] = pow(input_x[0], 1) * pow(input_x[3], 1) * pow(input_x[4], 3);
      idvg_poly_feat[516] = pow(input_x[0], 1) * pow(input_x[3], 1) * pow(input_x[4], 2) * pow(input_x[5], 1);
      idvg_poly_feat[517] = pow(input_x[0], 1) * pow(input_x[3], 1) * pow(input_x[4], 2) * pow(input_x[6], 1);
      idvg_poly_feat[518] = pow(input_x[0], 1) * pow(input_x[3], 1) * pow(input_x[4], 1) * pow(input_x[5], 2);
      idvg_poly_feat[519] = pow(input_x[0], 1) * pow(input_x[3], 1) * pow(input_x[4], 1) * pow(input_x[5], 1) * pow(input_x[6], 1);
      idvg_poly_feat[520] = pow(input_x[0], 1) * pow(input_x[3], 1) * pow(input_x[4], 1) * pow(input_x[6], 2);
      idvg_poly_feat[521] = pow(input_x[0], 1) * pow(input_x[3], 1) * pow(input_x[5], 3);
      idvg_poly_feat[522] = pow(input_x[0], 1) * pow(input_x[3], 1) * pow(input_x[5], 2) * pow(input_x[6], 1);
      idvg_poly_feat[523] = pow(input_x[0], 1) * pow(input_x[3], 1) * pow(input_x[5], 1) * pow(input_x[6], 2);
      idvg_poly_feat[524] = pow(input_x[0], 1) * pow(input_x[3], 1) * pow(input_x[6], 3);
      idvg_poly_feat[525] = pow(input_x[0], 1) * pow(input_x[4], 4);
      idvg_poly_feat[526] = pow(input_x[0], 1) * pow(input_x[4], 3) * pow(input_x[5], 1);
      idvg_poly_feat[527] = pow(input_x[0], 1) * pow(input_x[4], 3) * pow(input_x[6], 1);
      idvg_poly_feat[528] = pow(input_x[0], 1) * pow(input_x[4], 2) * pow(input_x[5], 2);
      idvg_poly_feat[529] = pow(input_x[0], 1) * pow(input_x[4], 2) * pow(input_x[5], 1) * pow(input_x[6], 1);
      idvg_poly_feat[530] = pow(input_x[0], 1) * pow(input_x[4], 2) * pow(input_x[6], 2);
      idvg_poly_feat[531] = pow(input_x[0], 1) * pow(input_x[4], 1) * pow(input_x[5], 3);
      idvg_poly_feat[532] = pow(input_x[0], 1) * pow(input_x[4], 1) * pow(input_x[5], 2) * pow(input_x[6], 1);
      idvg_poly_feat[533] = pow(input_x[0], 1) * pow(input_x[4], 1) * pow(input_x[5], 1) * pow(input_x[6], 2);
      idvg_poly_feat[534] = pow(input_x[0], 1) * pow(input_x[4], 1) * pow(input_x[6], 3);
      idvg_poly_feat[535] = pow(input_x[0], 1) * pow(input_x[5], 4);
      idvg_poly_feat[536] = pow(input_x[0], 1) * pow(input_x[5], 3) * pow(input_x[6], 1);
      idvg_poly_feat[537] = pow(input_x[0], 1) * pow(input_x[5], 2) * pow(input_x[6], 2);
      idvg_poly_feat[538] = pow(input_x[0], 1) * pow(input_x[5], 1) * pow(input_x[6], 3);
      idvg_poly_feat[539] = pow(input_x[0], 1) * pow(input_x[6], 4);
      idvg_poly_feat[540] = pow(input_x[1], 5);
      idvg_poly_feat[541] = pow(input_x[1], 4) * pow(input_x[2], 1);
      idvg_poly_feat[542] = pow(input_x[1], 4) * pow(input_x[3], 1);
      idvg_poly_feat[543] = pow(input_x[1], 4) * pow(input_x[4], 1);
      idvg_poly_feat[544] = pow(input_x[1], 4) * pow(input_x[5], 1);
      idvg_poly_feat[545] = pow(input_x[1], 4) * pow(input_x[6], 1);
      idvg_poly_feat[546] = pow(input_x[1], 3) * pow(input_x[2], 2);
      idvg_poly_feat[547] = pow(input_x[1], 3) * pow(input_x[2], 1) * pow(input_x[3], 1);
      idvg_poly_feat[548] = pow(input_x[1], 3) * pow(input_x[2], 1) * pow(input_x[4], 1);
      idvg_poly_feat[549] = pow(input_x[1], 3) * pow(input_x[2], 1) * pow(input_x[5], 1);
      idvg_poly_feat[550] = pow(input_x[1], 3) * pow(input_x[2], 1) * pow(input_x[6], 1);
      idvg_poly_feat[551] = pow(input_x[1], 3) * pow(input_x[3], 2);
      idvg_poly_feat[552] = pow(input_x[1], 3) * pow(input_x[3], 1) * pow(input_x[4], 1);
      idvg_poly_feat[553] = pow(input_x[1], 3) * pow(input_x[3], 1) * pow(input_x[5], 1);
      idvg_poly_feat[554] = pow(input_x[1], 3) * pow(input_x[3], 1) * pow(input_x[6], 1);
      idvg_poly_feat[555] = pow(input_x[1], 3) * pow(input_x[4], 2);
      idvg_poly_feat[556] = pow(input_x[1], 3) * pow(input_x[4], 1) * pow(input_x[5], 1);
      idvg_poly_feat[557] = pow(input_x[1], 3) * pow(input_x[4], 1) * pow(input_x[6], 1);
      idvg_poly_feat[558] = pow(input_x[1], 3) * pow(input_x[5], 2);
      idvg_poly_feat[559] = pow(input_x[1], 3) * pow(input_x[5], 1) * pow(input_x[6], 1);
      idvg_poly_feat[560] = pow(input_x[1], 3) * pow(input_x[6], 2);
      idvg_poly_feat[561] = pow(input_x[1], 2) * pow(input_x[2], 3);
      idvg_poly_feat[562] = pow(input_x[1], 2) * pow(input_x[2], 2) * pow(input_x[3], 1);
      idvg_poly_feat[563] = pow(input_x[1], 2) * pow(input_x[2], 2) * pow(input_x[4], 1);
      idvg_poly_feat[564] = pow(input_x[1], 2) * pow(input_x[2], 2) * pow(input_x[5], 1);
      idvg_poly_feat[565] = pow(input_x[1], 2) * pow(input_x[2], 2) * pow(input_x[6], 1);
      idvg_poly_feat[566] = pow(input_x[1], 2) * pow(input_x[2], 1) * pow(input_x[3], 2);
      idvg_poly_feat[567] = pow(input_x[1], 2) * pow(input_x[2], 1) * pow(input_x[3], 1) * pow(input_x[4], 1);
      idvg_poly_feat[568] = pow(input_x[1], 2) * pow(input_x[2], 1) * pow(input_x[3], 1) * pow(input_x[5], 1);
      idvg_poly_feat[569] = pow(input_x[1], 2) * pow(input_x[2], 1) * pow(input_x[3], 1) * pow(input_x[6], 1);
      idvg_poly_feat[570] = pow(input_x[1], 2) * pow(input_x[2], 1) * pow(input_x[4], 2);
      idvg_poly_feat[571] = pow(input_x[1], 2) * pow(input_x[2], 1) * pow(input_x[4], 1) * pow(input_x[5], 1);
      idvg_poly_feat[572] = pow(input_x[1], 2) * pow(input_x[2], 1) * pow(input_x[4], 1) * pow(input_x[6], 1);
      idvg_poly_feat[573] = pow(input_x[1], 2) * pow(input_x[2], 1) * pow(input_x[5], 2);
      idvg_poly_feat[574] = pow(input_x[1], 2) * pow(input_x[2], 1) * pow(input_x[5], 1) * pow(input_x[6], 1);
      idvg_poly_feat[575] = pow(input_x[1], 2) * pow(input_x[2], 1) * pow(input_x[6], 2);
      idvg_poly_feat[576] = pow(input_x[1], 2) * pow(input_x[3], 3);
      idvg_poly_feat[577] = pow(input_x[1], 2) * pow(input_x[3], 2) * pow(input_x[4], 1);
      idvg_poly_feat[578] = pow(input_x[1], 2) * pow(input_x[3], 2) * pow(input_x[5], 1);
      idvg_poly_feat[579] = pow(input_x[1], 2) * pow(input_x[3], 2) * pow(input_x[6], 1);
      idvg_poly_feat[580] = pow(input_x[1], 2) * pow(input_x[3], 1) * pow(input_x[4], 2);
      idvg_poly_feat[581] = pow(input_x[1], 2) * pow(input_x[3], 1) * pow(input_x[4], 1) * pow(input_x[5], 1);
      idvg_poly_feat[582] = pow(input_x[1], 2) * pow(input_x[3], 1) * pow(input_x[4], 1) * pow(input_x[6], 1);
      idvg_poly_feat[583] = pow(input_x[1], 2) * pow(input_x[3], 1) * pow(input_x[5], 2);
      idvg_poly_feat[584] = pow(input_x[1], 2) * pow(input_x[3], 1) * pow(input_x[5], 1) * pow(input_x[6], 1);
      idvg_poly_feat[585] = pow(input_x[1], 2) * pow(input_x[3], 1) * pow(input_x[6], 2);
      idvg_poly_feat[586] = pow(input_x[1], 2) * pow(input_x[4], 3);
      idvg_poly_feat[587] = pow(input_x[1], 2) * pow(input_x[4], 2) * pow(input_x[5], 1);
      idvg_poly_feat[588] = pow(input_x[1], 2) * pow(input_x[4], 2) * pow(input_x[6], 1);
      idvg_poly_feat[589] = pow(input_x[1], 2) * pow(input_x[4], 1) * pow(input_x[5], 2);
      idvg_poly_feat[590] = pow(input_x[1], 2) * pow(input_x[4], 1) * pow(input_x[5], 1) * pow(input_x[6], 1);
      idvg_poly_feat[591] = pow(input_x[1], 2) * pow(input_x[4], 1) * pow(input_x[6], 2);
      idvg_poly_feat[592] = pow(input_x[1], 2) * pow(input_x[5], 3);
      idvg_poly_feat[593] = pow(input_x[1], 2) * pow(input_x[5], 2) * pow(input_x[6], 1);
      idvg_poly_feat[594] = pow(input_x[1], 2) * pow(input_x[5], 1) * pow(input_x[6], 2);
      idvg_poly_feat[595] = pow(input_x[1], 2) * pow(input_x[6], 3);
      idvg_poly_feat[596] = pow(input_x[1], 1) * pow(input_x[2], 4);
      idvg_poly_feat[597] = pow(input_x[1], 1) * pow(input_x[2], 3) * pow(input_x[3], 1);
      idvg_poly_feat[598] = pow(input_x[1], 1) * pow(input_x[2], 3) * pow(input_x[4], 1);
      idvg_poly_feat[599] = pow(input_x[1], 1) * pow(input_x[2], 3) * pow(input_x[5], 1);
      idvg_poly_feat[600] = pow(input_x[1], 1) * pow(input_x[2], 3) * pow(input_x[6], 1);
      idvg_poly_feat[601] = pow(input_x[1], 1) * pow(input_x[2], 2) * pow(input_x[3], 2);
      idvg_poly_feat[602] = pow(input_x[1], 1) * pow(input_x[2], 2) * pow(input_x[3], 1) * pow(input_x[4], 1);
      idvg_poly_feat[603] = pow(input_x[1], 1) * pow(input_x[2], 2) * pow(input_x[3], 1) * pow(input_x[5], 1);
      idvg_poly_feat[604] = pow(input_x[1], 1) * pow(input_x[2], 2) * pow(input_x[3], 1) * pow(input_x[6], 1);
      idvg_poly_feat[605] = pow(input_x[1], 1) * pow(input_x[2], 2) * pow(input_x[4], 2);
      idvg_poly_feat[606] = pow(input_x[1], 1) * pow(input_x[2], 2) * pow(input_x[4], 1) * pow(input_x[5], 1);
      idvg_poly_feat[607] = pow(input_x[1], 1) * pow(input_x[2], 2) * pow(input_x[4], 1) * pow(input_x[6], 1);
      idvg_poly_feat[608] = pow(input_x[1], 1) * pow(input_x[2], 2) * pow(input_x[5], 2);
      idvg_poly_feat[609] = pow(input_x[1], 1) * pow(input_x[2], 2) * pow(input_x[5], 1) * pow(input_x[6], 1);
      idvg_poly_feat[610] = pow(input_x[1], 1) * pow(input_x[2], 2) * pow(input_x[6], 2);
      idvg_poly_feat[611] = pow(input_x[1], 1) * pow(input_x[2], 1) * pow(input_x[3], 3);
      idvg_poly_feat[612] = pow(input_x[1], 1) * pow(input_x[2], 1) * pow(input_x[3], 2) * pow(input_x[4], 1);
      idvg_poly_feat[613] = pow(input_x[1], 1) * pow(input_x[2], 1) * pow(input_x[3], 2) * pow(input_x[5], 1);
      idvg_poly_feat[614] = pow(input_x[1], 1) * pow(input_x[2], 1) * pow(input_x[3], 2) * pow(input_x[6], 1);
      idvg_poly_feat[615] = pow(input_x[1], 1) * pow(input_x[2], 1) * pow(input_x[3], 1) * pow(input_x[4], 2);
      idvg_poly_feat[616] = pow(input_x[1], 1) * pow(input_x[2], 1) * pow(input_x[3], 1) * pow(input_x[4], 1) * pow(input_x[5], 1);
      idvg_poly_feat[617] = pow(input_x[1], 1) * pow(input_x[2], 1) * pow(input_x[3], 1) * pow(input_x[4], 1) * pow(input_x[6], 1);
      idvg_poly_feat[618] = pow(input_x[1], 1) * pow(input_x[2], 1) * pow(input_x[3], 1) * pow(input_x[5], 2);
      idvg_poly_feat[619] = pow(input_x[1], 1) * pow(input_x[2], 1) * pow(input_x[3], 1) * pow(input_x[5], 1) * pow(input_x[6], 1);
      idvg_poly_feat[620] = pow(input_x[1], 1) * pow(input_x[2], 1) * pow(input_x[3], 1) * pow(input_x[6], 2);
      idvg_poly_feat[621] = pow(input_x[1], 1) * pow(input_x[2], 1) * pow(input_x[4], 3);
      idvg_poly_feat[622] = pow(input_x[1], 1) * pow(input_x[2], 1) * pow(input_x[4], 2) * pow(input_x[5], 1);
      idvg_poly_feat[623] = pow(input_x[1], 1) * pow(input_x[2], 1) * pow(input_x[4], 2) * pow(input_x[6], 1);
      idvg_poly_feat[624] = pow(input_x[1], 1) * pow(input_x[2], 1) * pow(input_x[4], 1) * pow(input_x[5], 2);
      idvg_poly_feat[625] = pow(input_x[1], 1) * pow(input_x[2], 1) * pow(input_x[4], 1) * pow(input_x[5], 1) * pow(input_x[6], 1);
      idvg_poly_feat[626] = pow(input_x[1], 1) * pow(input_x[2], 1) * pow(input_x[4], 1) * pow(input_x[6], 2);
      idvg_poly_feat[627] = pow(input_x[1], 1) * pow(input_x[2], 1) * pow(input_x[5], 3);
      idvg_poly_feat[628] = pow(input_x[1], 1) * pow(input_x[2], 1) * pow(input_x[5], 2) * pow(input_x[6], 1);
      idvg_poly_feat[629] = pow(input_x[1], 1) * pow(input_x[2], 1) * pow(input_x[5], 1) * pow(input_x[6], 2);
      idvg_poly_feat[630] = pow(input_x[1], 1) * pow(input_x[2], 1) * pow(input_x[6], 3);
      idvg_poly_feat[631] = pow(input_x[1], 1) * pow(input_x[3], 4);
      idvg_poly_feat[632] = pow(input_x[1], 1) * pow(input_x[3], 3) * pow(input_x[4], 1);
      idvg_poly_feat[633] = pow(input_x[1], 1) * pow(input_x[3], 3) * pow(input_x[5], 1);
      idvg_poly_feat[634] = pow(input_x[1], 1) * pow(input_x[3], 3) * pow(input_x[6], 1);
      idvg_poly_feat[635] = pow(input_x[1], 1) * pow(input_x[3], 2) * pow(input_x[4], 2);
      idvg_poly_feat[636] = pow(input_x[1], 1) * pow(input_x[3], 2) * pow(input_x[4], 1) * pow(input_x[5], 1);
      idvg_poly_feat[637] = pow(input_x[1], 1) * pow(input_x[3], 2) * pow(input_x[4], 1) * pow(input_x[6], 1);
      idvg_poly_feat[638] = pow(input_x[1], 1) * pow(input_x[3], 2) * pow(input_x[5], 2);
      idvg_poly_feat[639] = pow(input_x[1], 1) * pow(input_x[3], 2) * pow(input_x[5], 1) * pow(input_x[6], 1);
      idvg_poly_feat[640] = pow(input_x[1], 1) * pow(input_x[3], 2) * pow(input_x[6], 2);
      idvg_poly_feat[641] = pow(input_x[1], 1) * pow(input_x[3], 1) * pow(input_x[4], 3);
      idvg_poly_feat[642] = pow(input_x[1], 1) * pow(input_x[3], 1) * pow(input_x[4], 2) * pow(input_x[5], 1);
      idvg_poly_feat[643] = pow(input_x[1], 1) * pow(input_x[3], 1) * pow(input_x[4], 2) * pow(input_x[6], 1);
      idvg_poly_feat[644] = pow(input_x[1], 1) * pow(input_x[3], 1) * pow(input_x[4], 1) * pow(input_x[5], 2);
      idvg_poly_feat[645] = pow(input_x[1], 1) * pow(input_x[3], 1) * pow(input_x[4], 1) * pow(input_x[5], 1) * pow(input_x[6], 1);
      idvg_poly_feat[646] = pow(input_x[1], 1) * pow(input_x[3], 1) * pow(input_x[4], 1) * pow(input_x[6], 2);
      idvg_poly_feat[647] = pow(input_x[1], 1) * pow(input_x[3], 1) * pow(input_x[5], 3);
      idvg_poly_feat[648] = pow(input_x[1], 1) * pow(input_x[3], 1) * pow(input_x[5], 2) * pow(input_x[6], 1);
      idvg_poly_feat[649] = pow(input_x[1], 1) * pow(input_x[3], 1) * pow(input_x[5], 1) * pow(input_x[6], 2);
      idvg_poly_feat[650] = pow(input_x[1], 1) * pow(input_x[3], 1) * pow(input_x[6], 3);
      idvg_poly_feat[651] = pow(input_x[1], 1) * pow(input_x[4], 4);
      idvg_poly_feat[652] = pow(input_x[1], 1) * pow(input_x[4], 3) * pow(input_x[5], 1);
      idvg_poly_feat[653] = pow(input_x[1], 1) * pow(input_x[4], 3) * pow(input_x[6], 1);
      idvg_poly_feat[654] = pow(input_x[1], 1) * pow(input_x[4], 2) * pow(input_x[5], 2);
      idvg_poly_feat[655] = pow(input_x[1], 1) * pow(input_x[4], 2) * pow(input_x[5], 1) * pow(input_x[6], 1);
      idvg_poly_feat[656] = pow(input_x[1], 1) * pow(input_x[4], 2) * pow(input_x[6], 2);
      idvg_poly_feat[657] = pow(input_x[1], 1) * pow(input_x[4], 1) * pow(input_x[5], 3);
      idvg_poly_feat[658] = pow(input_x[1], 1) * pow(input_x[4], 1) * pow(input_x[5], 2) * pow(input_x[6], 1);
      idvg_poly_feat[659] = pow(input_x[1], 1) * pow(input_x[4], 1) * pow(input_x[5], 1) * pow(input_x[6], 2);
      idvg_poly_feat[660] = pow(input_x[1], 1) * pow(input_x[4], 1) * pow(input_x[6], 3);
      idvg_poly_feat[661] = pow(input_x[1], 1) * pow(input_x[5], 4);
      idvg_poly_feat[662] = pow(input_x[1], 1) * pow(input_x[5], 3) * pow(input_x[6], 1);
      idvg_poly_feat[663] = pow(input_x[1], 1) * pow(input_x[5], 2) * pow(input_x[6], 2);
      idvg_poly_feat[664] = pow(input_x[1], 1) * pow(input_x[5], 1) * pow(input_x[6], 3);
      idvg_poly_feat[665] = pow(input_x[1], 1) * pow(input_x[6], 4);
      idvg_poly_feat[666] = pow(input_x[2], 5);
      idvg_poly_feat[667] = pow(input_x[2], 4) * pow(input_x[3], 1);
      idvg_poly_feat[668] = pow(input_x[2], 4) * pow(input_x[4], 1);
      idvg_poly_feat[669] = pow(input_x[2], 4) * pow(input_x[5], 1);
      idvg_poly_feat[670] = pow(input_x[2], 4) * pow(input_x[6], 1);
      idvg_poly_feat[671] = pow(input_x[2], 3) * pow(input_x[3], 2);
      idvg_poly_feat[672] = pow(input_x[2], 3) * pow(input_x[3], 1) * pow(input_x[4], 1);
      idvg_poly_feat[673] = pow(input_x[2], 3) * pow(input_x[3], 1) * pow(input_x[5], 1);
      idvg_poly_feat[674] = pow(input_x[2], 3) * pow(input_x[3], 1) * pow(input_x[6], 1);
      idvg_poly_feat[675] = pow(input_x[2], 3) * pow(input_x[4], 2);
      idvg_poly_feat[676] = pow(input_x[2], 3) * pow(input_x[4], 1) * pow(input_x[5], 1);
      idvg_poly_feat[677] = pow(input_x[2], 3) * pow(input_x[4], 1) * pow(input_x[6], 1);
      idvg_poly_feat[678] = pow(input_x[2], 3) * pow(input_x[5], 2);
      idvg_poly_feat[679] = pow(input_x[2], 3) * pow(input_x[5], 1) * pow(input_x[6], 1);
      idvg_poly_feat[680] = pow(input_x[2], 3) * pow(input_x[6], 2);
      idvg_poly_feat[681] = pow(input_x[2], 2) * pow(input_x[3], 3);
      idvg_poly_feat[682] = pow(input_x[2], 2) * pow(input_x[3], 2) * pow(input_x[4], 1);
      idvg_poly_feat[683] = pow(input_x[2], 2) * pow(input_x[3], 2) * pow(input_x[5], 1);
      idvg_poly_feat[684] = pow(input_x[2], 2) * pow(input_x[3], 2) * pow(input_x[6], 1);
      idvg_poly_feat[685] = pow(input_x[2], 2) * pow(input_x[3], 1) * pow(input_x[4], 2);
      idvg_poly_feat[686] = pow(input_x[2], 2) * pow(input_x[3], 1) * pow(input_x[4], 1) * pow(input_x[5], 1);
      idvg_poly_feat[687] = pow(input_x[2], 2) * pow(input_x[3], 1) * pow(input_x[4], 1) * pow(input_x[6], 1);
      idvg_poly_feat[688] = pow(input_x[2], 2) * pow(input_x[3], 1) * pow(input_x[5], 2);
      idvg_poly_feat[689] = pow(input_x[2], 2) * pow(input_x[3], 1) * pow(input_x[5], 1) * pow(input_x[6], 1);
      idvg_poly_feat[690] = pow(input_x[2], 2) * pow(input_x[3], 1) * pow(input_x[6], 2);
      idvg_poly_feat[691] = pow(input_x[2], 2) * pow(input_x[4], 3);
      idvg_poly_feat[692] = pow(input_x[2], 2) * pow(input_x[4], 2) * pow(input_x[5], 1);
      idvg_poly_feat[693] = pow(input_x[2], 2) * pow(input_x[4], 2) * pow(input_x[6], 1);
      idvg_poly_feat[694] = pow(input_x[2], 2) * pow(input_x[4], 1) * pow(input_x[5], 2);
      idvg_poly_feat[695] = pow(input_x[2], 2) * pow(input_x[4], 1) * pow(input_x[5], 1) * pow(input_x[6], 1);
      idvg_poly_feat[696] = pow(input_x[2], 2) * pow(input_x[4], 1) * pow(input_x[6], 2);
      idvg_poly_feat[697] = pow(input_x[2], 2) * pow(input_x[5], 3);
      idvg_poly_feat[698] = pow(input_x[2], 2) * pow(input_x[5], 2) * pow(input_x[6], 1);
      idvg_poly_feat[699] = pow(input_x[2], 2) * pow(input_x[5], 1) * pow(input_x[6], 2);
      idvg_poly_feat[700] = pow(input_x[2], 2) * pow(input_x[6], 3);
      idvg_poly_feat[701] = pow(input_x[2], 1) * pow(input_x[3], 4);
      idvg_poly_feat[702] = pow(input_x[2], 1) * pow(input_x[3], 3) * pow(input_x[4], 1);
      idvg_poly_feat[703] = pow(input_x[2], 1) * pow(input_x[3], 3) * pow(input_x[5], 1);
      idvg_poly_feat[704] = pow(input_x[2], 1) * pow(input_x[3], 3) * pow(input_x[6], 1);
      idvg_poly_feat[705] = pow(input_x[2], 1) * pow(input_x[3], 2) * pow(input_x[4], 2);
      idvg_poly_feat[706] = pow(input_x[2], 1) * pow(input_x[3], 2) * pow(input_x[4], 1) * pow(input_x[5], 1);
      idvg_poly_feat[707] = pow(input_x[2], 1) * pow(input_x[3], 2) * pow(input_x[4], 1) * pow(input_x[6], 1);
      idvg_poly_feat[708] = pow(input_x[2], 1) * pow(input_x[3], 2) * pow(input_x[5], 2);
      idvg_poly_feat[709] = pow(input_x[2], 1) * pow(input_x[3], 2) * pow(input_x[5], 1) * pow(input_x[6], 1);
      idvg_poly_feat[710] = pow(input_x[2], 1) * pow(input_x[3], 2) * pow(input_x[6], 2);
      idvg_poly_feat[711] = pow(input_x[2], 1) * pow(input_x[3], 1) * pow(input_x[4], 3);
      idvg_poly_feat[712] = pow(input_x[2], 1) * pow(input_x[3], 1) * pow(input_x[4], 2) * pow(input_x[5], 1);
      idvg_poly_feat[713] = pow(input_x[2], 1) * pow(input_x[3], 1) * pow(input_x[4], 2) * pow(input_x[6], 1);
      idvg_poly_feat[714] = pow(input_x[2], 1) * pow(input_x[3], 1) * pow(input_x[4], 1) * pow(input_x[5], 2);
      idvg_poly_feat[715] = pow(input_x[2], 1) * pow(input_x[3], 1) * pow(input_x[4], 1) * pow(input_x[5], 1) * pow(input_x[6], 1);
      idvg_poly_feat[716] = pow(input_x[2], 1) * pow(input_x[3], 1) * pow(input_x[4], 1) * pow(input_x[6], 2);
      idvg_poly_feat[717] = pow(input_x[2], 1) * pow(input_x[3], 1) * pow(input_x[5], 3);
      idvg_poly_feat[718] = pow(input_x[2], 1) * pow(input_x[3], 1) * pow(input_x[5], 2) * pow(input_x[6], 1);
      idvg_poly_feat[719] = pow(input_x[2], 1) * pow(input_x[3], 1) * pow(input_x[5], 1) * pow(input_x[6], 2);
      idvg_poly_feat[720] = pow(input_x[2], 1) * pow(input_x[3], 1) * pow(input_x[6], 3);
      idvg_poly_feat[721] = pow(input_x[2], 1) * pow(input_x[4], 4);
      idvg_poly_feat[722] = pow(input_x[2], 1) * pow(input_x[4], 3) * pow(input_x[5], 1);
      idvg_poly_feat[723] = pow(input_x[2], 1) * pow(input_x[4], 3) * pow(input_x[6], 1);
      idvg_poly_feat[724] = pow(input_x[2], 1) * pow(input_x[4], 2) * pow(input_x[5], 2);
      idvg_poly_feat[725] = pow(input_x[2], 1) * pow(input_x[4], 2) * pow(input_x[5], 1) * pow(input_x[6], 1);
      idvg_poly_feat[726] = pow(input_x[2], 1) * pow(input_x[4], 2) * pow(input_x[6], 2);
      idvg_poly_feat[727] = pow(input_x[2], 1) * pow(input_x[4], 1) * pow(input_x[5], 3);
      idvg_poly_feat[728] = pow(input_x[2], 1) * pow(input_x[4], 1) * pow(input_x[5], 2) * pow(input_x[6], 1);
      idvg_poly_feat[729] = pow(input_x[2], 1) * pow(input_x[4], 1) * pow(input_x[5], 1) * pow(input_x[6], 2);
      idvg_poly_feat[730] = pow(input_x[2], 1) * pow(input_x[4], 1) * pow(input_x[6], 3);
      idvg_poly_feat[731] = pow(input_x[2], 1) * pow(input_x[5], 4);
      idvg_poly_feat[732] = pow(input_x[2], 1) * pow(input_x[5], 3) * pow(input_x[6], 1);
      idvg_poly_feat[733] = pow(input_x[2], 1) * pow(input_x[5], 2) * pow(input_x[6], 2);
      idvg_poly_feat[734] = pow(input_x[2], 1) * pow(input_x[5], 1) * pow(input_x[6], 3);
      idvg_poly_feat[735] = pow(input_x[2], 1) * pow(input_x[6], 4);
      idvg_poly_feat[736] = pow(input_x[3], 5);
      idvg_poly_feat[737] = pow(input_x[3], 4) * pow(input_x[4], 1);
      idvg_poly_feat[738] = pow(input_x[3], 4) * pow(input_x[5], 1);
      idvg_poly_feat[739] = pow(input_x[3], 4) * pow(input_x[6], 1);
      idvg_poly_feat[740] = pow(input_x[3], 3) * pow(input_x[4], 2);
      idvg_poly_feat[741] = pow(input_x[3], 3) * pow(input_x[4], 1) * pow(input_x[5], 1);
      idvg_poly_feat[742] = pow(input_x[3], 3) * pow(input_x[4], 1) * pow(input_x[6], 1);
      idvg_poly_feat[743] = pow(input_x[3], 3) * pow(input_x[5], 2);
      idvg_poly_feat[744] = pow(input_x[3], 3) * pow(input_x[5], 1) * pow(input_x[6], 1);
      idvg_poly_feat[745] = pow(input_x[3], 3) * pow(input_x[6], 2);
      idvg_poly_feat[746] = pow(input_x[3], 2) * pow(input_x[4], 3);
      idvg_poly_feat[747] = pow(input_x[3], 2) * pow(input_x[4], 2) * pow(input_x[5], 1);
      idvg_poly_feat[748] = pow(input_x[3], 2) * pow(input_x[4], 2) * pow(input_x[6], 1);
      idvg_poly_feat[749] = pow(input_x[3], 2) * pow(input_x[4], 1) * pow(input_x[5], 2);
      idvg_poly_feat[750] = pow(input_x[3], 2) * pow(input_x[4], 1) * pow(input_x[5], 1) * pow(input_x[6], 1);
      idvg_poly_feat[751] = pow(input_x[3], 2) * pow(input_x[4], 1) * pow(input_x[6], 2);
      idvg_poly_feat[752] = pow(input_x[3], 2) * pow(input_x[5], 3);
      idvg_poly_feat[753] = pow(input_x[3], 2) * pow(input_x[5], 2) * pow(input_x[6], 1);
      idvg_poly_feat[754] = pow(input_x[3], 2) * pow(input_x[5], 1) * pow(input_x[6], 2);
      idvg_poly_feat[755] = pow(input_x[3], 2) * pow(input_x[6], 3);
      idvg_poly_feat[756] = pow(input_x[3], 1) * pow(input_x[4], 4);
      idvg_poly_feat[757] = pow(input_x[3], 1) * pow(input_x[4], 3) * pow(input_x[5], 1);
      idvg_poly_feat[758] = pow(input_x[3], 1) * pow(input_x[4], 3) * pow(input_x[6], 1);
      idvg_poly_feat[759] = pow(input_x[3], 1) * pow(input_x[4], 2) * pow(input_x[5], 2);
      idvg_poly_feat[760] = pow(input_x[3], 1) * pow(input_x[4], 2) * pow(input_x[5], 1) * pow(input_x[6], 1);
      idvg_poly_feat[761] = pow(input_x[3], 1) * pow(input_x[4], 2) * pow(input_x[6], 2);
      idvg_poly_feat[762] = pow(input_x[3], 1) * pow(input_x[4], 1) * pow(input_x[5], 3);
      idvg_poly_feat[763] = pow(input_x[3], 1) * pow(input_x[4], 1) * pow(input_x[5], 2) * pow(input_x[6], 1);
      idvg_poly_feat[764] = pow(input_x[3], 1) * pow(input_x[4], 1) * pow(input_x[5], 1) * pow(input_x[6], 2);
      idvg_poly_feat[765] = pow(input_x[3], 1) * pow(input_x[4], 1) * pow(input_x[6], 3);
      idvg_poly_feat[766] = pow(input_x[3], 1) * pow(input_x[5], 4);
      idvg_poly_feat[767] = pow(input_x[3], 1) * pow(input_x[5], 3) * pow(input_x[6], 1);
      idvg_poly_feat[768] = pow(input_x[3], 1) * pow(input_x[5], 2) * pow(input_x[6], 2);
      idvg_poly_feat[769] = pow(input_x[3], 1) * pow(input_x[5], 1) * pow(input_x[6], 3);
      idvg_poly_feat[770] = pow(input_x[3], 1) * pow(input_x[6], 4);
      idvg_poly_feat[771] = pow(input_x[4], 5);
      idvg_poly_feat[772] = pow(input_x[4], 4) * pow(input_x[5], 1);
      idvg_poly_feat[773] = pow(input_x[4], 4) * pow(input_x[6], 1);
      idvg_poly_feat[774] = pow(input_x[4], 3) * pow(input_x[5], 2);
      idvg_poly_feat[775] = pow(input_x[4], 3) * pow(input_x[5], 1) * pow(input_x[6], 1);
      idvg_poly_feat[776] = pow(input_x[4], 3) * pow(input_x[6], 2);
      idvg_poly_feat[777] = pow(input_x[4], 2) * pow(input_x[5], 3);
      idvg_poly_feat[778] = pow(input_x[4], 2) * pow(input_x[5], 2) * pow(input_x[6], 1);
      idvg_poly_feat[779] = pow(input_x[4], 2) * pow(input_x[5], 1) * pow(input_x[6], 2);
      idvg_poly_feat[780] = pow(input_x[4], 2) * pow(input_x[6], 3);
      idvg_poly_feat[781] = pow(input_x[4], 1) * pow(input_x[5], 4);
      idvg_poly_feat[782] = pow(input_x[4], 1) * pow(input_x[5], 3) * pow(input_x[6], 1);
      idvg_poly_feat[783] = pow(input_x[4], 1) * pow(input_x[5], 2) * pow(input_x[6], 2);
      idvg_poly_feat[784] = pow(input_x[4], 1) * pow(input_x[5], 1) * pow(input_x[6], 3);
      idvg_poly_feat[785] = pow(input_x[4], 1) * pow(input_x[6], 4);
      idvg_poly_feat[786] = pow(input_x[5], 5);
      idvg_poly_feat[787] = pow(input_x[5], 4) * pow(input_x[6], 1);
      idvg_poly_feat[788] = pow(input_x[5], 3) * pow(input_x[6], 2);
      idvg_poly_feat[789] = pow(input_x[5], 2) * pow(input_x[6], 3);
      idvg_poly_feat[790] = pow(input_x[5], 1) * pow(input_x[6], 4);
      idvg_poly_feat[791] = pow(input_x[6], 5);
      idvg_poly_feat[792] = pow(input_x[0], 6);
      idvg_poly_feat[793] = pow(input_x[1], 6);
      idvg_poly_feat[794] = pow(input_x[2], 6);
      idvg_poly_feat[795] = pow(input_x[3], 6);
      idvg_poly_feat[796] = pow(input_x[4], 6);
      idvg_poly_feat[797] = pow(input_x[5], 6);
      idvg_poly_feat[798] = pow(input_x[6], 6);
      idvg_poly_feat[799] = pow(input_x[0], 7);
      idvg_poly_feat[800] = pow(input_x[1], 7);
      idvg_poly_feat[801] = pow(input_x[2], 7);
      idvg_poly_feat[802] = pow(input_x[3], 7);
      idvg_poly_feat[803] = pow(input_x[4], 7);
      idvg_poly_feat[804] = pow(input_x[5], 7);
      idvg_poly_feat[805] = pow(input_x[6], 7);
      idvg_poly_feat[806] = pow(input_x[0], 8);
      idvg_poly_feat[807] = pow(input_x[1], 8);
      idvg_poly_feat[808] = pow(input_x[2], 8);
      idvg_poly_feat[809] = pow(input_x[3], 8);
      idvg_poly_feat[810] = pow(input_x[4], 8);
      idvg_poly_feat[811] = pow(input_x[5], 8);
      idvg_poly_feat[812] = pow(input_x[6], 8);
      idvg_poly_feat[813] = pow(input_x[0], 9);
      idvg_poly_feat[814] = pow(input_x[1], 9);
      idvg_poly_feat[815] = pow(input_x[2], 9);
      idvg_poly_feat[816] = pow(input_x[3], 9);
      idvg_poly_feat[817] = pow(input_x[4], 9);
      idvg_poly_feat[818] = pow(input_x[5], 9);
      idvg_poly_feat[819] = pow(input_x[6], 9);
      idvg_poly_feat[820] = pow(input_x[0], 10);
      idvg_poly_feat[821] = pow(input_x[1], 10);
      idvg_poly_feat[822] = pow(input_x[2], 10);
      idvg_poly_feat[823] = pow(input_x[3], 10);
      idvg_poly_feat[824] = pow(input_x[4], 10);
      idvg_poly_feat[825] = pow(input_x[5], 10);
      idvg_poly_feat[826] = pow(input_x[6], 10);
      idvg_poly_feat[827] = pow(input_x[0], 11);
      idvg_poly_feat[828] = pow(input_x[1], 11);
      idvg_poly_feat[829] = pow(input_x[2], 11);
      idvg_poly_feat[830] = pow(input_x[3], 11);
      idvg_poly_feat[831] = pow(input_x[4], 11);
      idvg_poly_feat[832] = pow(input_x[5], 11);
      idvg_poly_feat[833] = pow(input_x[6], 11);
      idvg_poly_feat[834] = pow(input_x[0], 12);
      idvg_poly_feat[835] = pow(input_x[1], 12);
      idvg_poly_feat[836] = pow(input_x[2], 12);
      idvg_poly_feat[837] = pow(input_x[3], 12);
      idvg_poly_feat[838] = pow(input_x[4], 12);
      idvg_poly_feat[839] = pow(input_x[5], 12);
      idvg_poly_feat[840] = pow(input_x[6], 12);
      for(i=0; i<20; i=i+1) begin
        tmp = idvg_poly_b[i];
        for(j=0; j<841; j=j+1) tmp = tmp + idvg_poly_w[i*841 + j] * idvg_poly_feat[j];
        idvg_z[i] = tmp * idvg_sl_mul[i] + idvg_sl_add[i];
      end
      for(i=0; i<112; i=i+1) begin
        tmp = idvg_ae_b0[i];
        for(j=0; j<20; j=j+1) tmp = tmp + idvg_ae_w0[i*20 + j] * idvg_z[j];
        idvg_h0[i] = (tmp > 0.0) ? tmp : 0.0;
      end
      for(i=0; i<446; i=i+1) begin
        tmp = idvg_ae_b1[i];
        for(j=0; j<112; j=j+1) tmp = tmp + idvg_ae_w1[i*112 + j] * idvg_h0[j];
        idvg_h1[i] = (tmp > 0.0) ? tmp : 0.0;
      end
      for(i=0; i<892; i=i+1) begin
        tmp = idvg_ae_b2[i];
        for(j=0; j<446; j=j+1) tmp = tmp + idvg_ae_w2[i*446 + j] * idvg_h1[j];
        idvg_h2[i] = (tmp > 0.0) ? tmp : 0.0;
      end
      for(i=0; i<892; i=i+1) begin
        tmp = idvg_ae_b3[i];
        for(j=0; j<892; j=j+1) tmp = tmp + idvg_ae_w3[i*892 + j] * idvg_h2[j];
        tmp = 1.0 / (1.0 + exp(-tmp));
        idvg_out[i] = tmp * idvg_siv_mul[i] + idvg_siv_add[i];
      end
    end

    val_vg = V(g, s);
    val_vd = V(d, s);
    sign_vd = val_vd / sqrt(val_vd*val_vd + vds_sign_delta*vds_sign_delta);
    vd_mag = sqrt(val_vd*val_vd + vds_sign_delta*vds_sign_delta);

    // Id-Vd surface: 3 Vg anchors x 300 Vd samples
    if(val_vg <= 1.0) begin
      idvd_vg0_idx = 0;
      idvd_vg1_idx = 1;
      idvd_vg_frac = 0.0;
      idvd_excess = 1.0 - val_vg;
    end else if(val_vg >= 5.0) begin
      idvd_vg0_idx = 1;
      idvd_vg1_idx = 2;
      idvd_vg_frac = 1.0;
      idvd_excess = val_vg - 5.0;
    end else begin
      idvd_vg_pos = (val_vg - 1.0) / 2.0;
      idvd_vg0_idx = $rtoi(idvd_vg_pos);
      if(idvd_vg0_idx > 1) idvd_vg0_idx = 1;
      idvd_vg1_idx = idvd_vg0_idx + 1;
      idvd_vg_frac = idvd_vg_pos - idvd_vg0_idx;
      idvd_excess = 0.0;
    end

    if(vd_mag <= 0.02) begin
      idvd_vd0_idx = 0;
      idvd_vd1_idx = 1;
      idvd_vd_frac = 0.0;
    end else if(vd_mag >= 18.0) begin
      idvd_vd0_idx = 298;
      idvd_vd1_idx = 299;
      idvd_vd_frac = 1.0;
    end else begin
      idvd_vd_pos = (vd_mag - 0.02) / (17.98 / 299.0);
      idvd_vd0_idx = $rtoi(idvd_vd_pos);
      if(idvd_vd0_idx > 298) idvd_vd0_idx = 298;
      idvd_vd1_idx = idvd_vd0_idx + 1;
      idvd_vd_frac = idvd_vd_pos - idvd_vd0_idx;
    end

    idvd_i00 = idvd_out[idvd_vg0_idx * 300 + idvd_vd0_idx];
    idvd_i01 = idvd_out[idvd_vg0_idx * 300 + idvd_vd1_idx];
    idvd_i10 = idvd_out[idvd_vg1_idx * 300 + idvd_vd0_idx];
    idvd_i11 = idvd_out[idvd_vg1_idx * 300 + idvd_vd1_idx];
    idvd_interp = (1.0 - idvd_vg_frac) * ((1.0 - idvd_vd_frac) * idvd_i00 + idvd_vd_frac * idvd_i01)
                + idvd_vg_frac * ((1.0 - idvd_vd_frac) * idvd_i10 + idvd_vd_frac * idvd_i11);

    // Id-Vg surface: 2 Vd anchors x 446 Vg samples
    if(val_vg <= -1.9) begin
      idvg_vg0_idx = 0;
      idvg_vg1_idx = 1;
      idvg_vg_frac = 0.0;
    end else if(val_vg >= 7.0) begin
      idvg_vg0_idx = 444;
      idvg_vg1_idx = 445;
      idvg_vg_frac = 1.0;
    end else begin
      idvg_vg_pos = (val_vg + 1.9) / 0.02;
      idvg_vg0_idx = $rtoi(idvg_vg_pos);
      if(idvg_vg0_idx > 444) idvg_vg0_idx = 444;
      idvg_vg1_idx = idvg_vg0_idx + 1;
      idvg_vg_frac = idvg_vg_pos - idvg_vg0_idx;
    end

    if(vd_mag <= 1.0) begin
      idvg_vd0_idx = 0;
      idvg_vd1_idx = 1;
      idvg_vd_frac = 0.0;
      idvg_excess = 1.0 - vd_mag;
    end else if(vd_mag >= 15.0) begin
      idvg_vd0_idx = 0;
      idvg_vd1_idx = 1;
      idvg_vd_frac = 1.0;
      idvg_excess = vd_mag - 15.0;
    end else begin
      idvg_vd0_idx = 0;
      idvg_vd1_idx = 1;
      idvg_vd_frac = (vd_mag - 1.0) / 14.0;
      idvg_excess = 0.0;
    end

    idvg_i00 = idvg_out[idvg_vd0_idx * 446 + idvg_vg0_idx];
    idvg_i01 = idvg_out[idvg_vd0_idx * 446 + idvg_vg1_idx];
    idvg_i10 = idvg_out[idvg_vd1_idx * 446 + idvg_vg0_idx];
    idvg_i11 = idvg_out[idvg_vd1_idx * 446 + idvg_vg1_idx];
    idvg_interp = (1.0 - idvg_vd_frac) * ((1.0 - idvg_vg_frac) * idvg_i00 + idvg_vg_frac * idvg_i01)
                + idvg_vd_frac * ((1.0 - idvg_vg_frac) * idvg_i10 + idvg_vg_frac * idvg_i11);

    if(idvd_vg_frac < 0.5) idvd_vg_dist = 2.0 * idvd_vg_frac;
    else idvd_vg_dist = 2.0 * (1.0 - idvd_vg_frac);
    if(idvg_vd_frac < 0.5) idvg_vd_dist = 2.0 * idvg_vd_frac;
    else idvg_vd_dist = 2.0 * (1.0 - idvg_vd_frac);

    w_idvd = 1.0 / (0.05 + (idvd_vg_dist + 2.0 * idvd_excess) * (idvd_vg_dist + 2.0 * idvd_excess));
    w_idvg = 1.0 / (0.05 + (idvg_vd_dist + 2.0 * idvg_excess) * (idvg_vd_dist + 2.0 * idvg_excess));

    if(current_mode == 1) begin
      res_id_mag = idvd_interp;
    end else if(current_mode == 2) begin
      res_id_mag = idvg_interp;
    end else begin
      w_sum = w_idvd + w_idvg;
      if(w_sum > 0.0) res_id_mag = (w_idvd * idvd_interp + w_idvg * idvg_interp) / w_sum;
      else res_id_mag = 0.5 * (idvd_interp + idvg_interp);
    end

    I(d, s) <+ sign_vd * res_id_mag;
    I(d, s) <+ gmin_ds * V(d, s);
  end
endmodule
