// Automatically generated Verilog-A planar NMOS drain-current model
`include "constants.vams"
`include "disciplines.vams"

module NMOSVA(d, g, s);
  inout d, g, s;
  electrical d, g, s;

  // Geometry parameters in nm, matching the SEMLDB planar NMOS UI.
  parameter real Lg = 32.0;
  parameter real THF = 2.0;
  parameter real XjSD = 40.0;
  // 0: blended current, 1: Id-Vd surface only, 2: Id-Vg surface only
  parameter integer current_mode = 0;
  parameter real gmin_ds = 1e-12 from [0:inf);
  parameter real vds_sign_delta = 1e-4 from [0:inf);

  real idvd_poly_w[0:704];
  real idvd_poly_b[0:2];
  real idvd_ae_w0[0:149];
  real idvd_ae_b0[0:49];
  real idvd_ae_w1[0:9999];
  real idvd_ae_b1[0:199];
  real idvd_ae_w2[0:79999];
  real idvd_ae_b2[0:399];
  real idvd_ae_w3[0:319999];
  real idvd_ae_b3[0:799];
  real idvg_poly_w[0:599];
  real idvg_poly_b[0:4];
  real idvg_ae_w0[0:249];
  real idvg_ae_b0[0:49];
  real idvg_ae_w1[0:9999];
  real idvg_ae_b1[0:199];
  real idvg_ae_w2[0:79999];
  real idvg_ae_b2[0:399];
  real idvg_ae_w3[0:159999];
  real idvg_ae_b3[0:399];
  real idvd_sx_mul[0:2];
  real idvd_sx_add[0:2];
  real idvd_sl_mul[0:2];
  real idvd_sl_add[0:2];
  real idvd_siv_mul[0:799];
  real idvd_siv_add[0:799];
  real idvg_sx_mul[0:2];
  real idvg_sx_add[0:2];
  real idvg_sl_mul[0:4];
  real idvg_sl_add[0:4];
  real idvg_siv_mul[0:399];
  real idvg_siv_add[0:399];

  // Temporary buffers
  real input_x[0:2];
  real idvd_poly_feat[0:234];
  real idvd_z[0:2];
  real idvd_h0[0:49];
  real idvd_h1[0:199];
  real idvd_h2[0:399];
  real idvd_out[0:799];
  real idvg_poly_feat[0:119];
  real idvg_z[0:4];
  real idvg_h0[0:49];
  real idvg_h1[0:199];
  real idvg_h2[0:399];
  real idvg_out[0:399];
  integer i, j, fd, count_tmp;
  integer idvd_vg0_idx, idvd_vg1_idx, idvd_vd0_idx, idvd_vd1_idx;
  integer idvg_vg0_idx, idvg_vg1_idx, idvg_vd0_idx, idvg_vd1_idx;
  real tmp, val_vg, val_vd, vd_mag, sign_vd, res_id_mag;
  real idvd_vg_pos, idvd_vg_frac, idvd_vd_pos, idvd_vd_frac;
  real idvg_vg_pos, idvg_vg_frac, idvg_vd_frac;
  real idvd_i00, idvd_i01, idvd_i10, idvd_i11, idvd_interp;
  real idvg_i00, idvg_i01, idvg_i10, idvg_i11, idvg_interp;
  real idvd_vg_dist, idvg_vd_dist, idvd_excess, idvg_excess;
  real w_idvd, w_idvg, w_sum;

  analog begin
    @(initial_step) begin
      fd = $fopen("C:/Users/ta688/UF Dropbox/PC/VerilogA/verilogA_v2/SEMLDB_veriloga_converter/outputs/NMOS/nmosva_idvd_poly_w.txt", "r");
      for(i=0; i<705; i=i+1) count_tmp = $fscanf(fd, "%e", idvd_poly_w[i]);
      $fclose(fd);
      fd = $fopen("C:/Users/ta688/UF Dropbox/PC/VerilogA/verilogA_v2/SEMLDB_veriloga_converter/outputs/NMOS/nmosva_idvd_poly_b.txt", "r");
      for(i=0; i<3; i=i+1) count_tmp = $fscanf(fd, "%e", idvd_poly_b[i]);
      $fclose(fd);
      fd = $fopen("C:/Users/ta688/UF Dropbox/PC/VerilogA/verilogA_v2/SEMLDB_veriloga_converter/outputs/NMOS/nmosva_idvd_ae_w0.txt", "r");
      for(i=0; i<150; i=i+1) count_tmp = $fscanf(fd, "%e", idvd_ae_w0[i]);
      $fclose(fd);
      fd = $fopen("C:/Users/ta688/UF Dropbox/PC/VerilogA/verilogA_v2/SEMLDB_veriloga_converter/outputs/NMOS/nmosva_idvd_ae_b0.txt", "r");
      for(i=0; i<50; i=i+1) count_tmp = $fscanf(fd, "%e", idvd_ae_b0[i]);
      $fclose(fd);
      fd = $fopen("C:/Users/ta688/UF Dropbox/PC/VerilogA/verilogA_v2/SEMLDB_veriloga_converter/outputs/NMOS/nmosva_idvd_ae_w1.txt", "r");
      for(i=0; i<10000; i=i+1) count_tmp = $fscanf(fd, "%e", idvd_ae_w1[i]);
      $fclose(fd);
      fd = $fopen("C:/Users/ta688/UF Dropbox/PC/VerilogA/verilogA_v2/SEMLDB_veriloga_converter/outputs/NMOS/nmosva_idvd_ae_b1.txt", "r");
      for(i=0; i<200; i=i+1) count_tmp = $fscanf(fd, "%e", idvd_ae_b1[i]);
      $fclose(fd);
      fd = $fopen("C:/Users/ta688/UF Dropbox/PC/VerilogA/verilogA_v2/SEMLDB_veriloga_converter/outputs/NMOS/nmosva_idvd_ae_w2.txt", "r");
      for(i=0; i<80000; i=i+1) count_tmp = $fscanf(fd, "%e", idvd_ae_w2[i]);
      $fclose(fd);
      fd = $fopen("C:/Users/ta688/UF Dropbox/PC/VerilogA/verilogA_v2/SEMLDB_veriloga_converter/outputs/NMOS/nmosva_idvd_ae_b2.txt", "r");
      for(i=0; i<400; i=i+1) count_tmp = $fscanf(fd, "%e", idvd_ae_b2[i]);
      $fclose(fd);
      fd = $fopen("C:/Users/ta688/UF Dropbox/PC/VerilogA/verilogA_v2/SEMLDB_veriloga_converter/outputs/NMOS/nmosva_idvd_ae_w3.txt", "r");
      for(i=0; i<320000; i=i+1) count_tmp = $fscanf(fd, "%e", idvd_ae_w3[i]);
      $fclose(fd);
      fd = $fopen("C:/Users/ta688/UF Dropbox/PC/VerilogA/verilogA_v2/SEMLDB_veriloga_converter/outputs/NMOS/nmosva_idvd_ae_b3.txt", "r");
      for(i=0; i<800; i=i+1) count_tmp = $fscanf(fd, "%e", idvd_ae_b3[i]);
      $fclose(fd);
      fd = $fopen("C:/Users/ta688/UF Dropbox/PC/VerilogA/verilogA_v2/SEMLDB_veriloga_converter/outputs/NMOS/nmosva_idvg_poly_w.txt", "r");
      for(i=0; i<600; i=i+1) count_tmp = $fscanf(fd, "%e", idvg_poly_w[i]);
      $fclose(fd);
      fd = $fopen("C:/Users/ta688/UF Dropbox/PC/VerilogA/verilogA_v2/SEMLDB_veriloga_converter/outputs/NMOS/nmosva_idvg_poly_b.txt", "r");
      for(i=0; i<5; i=i+1) count_tmp = $fscanf(fd, "%e", idvg_poly_b[i]);
      $fclose(fd);
      fd = $fopen("C:/Users/ta688/UF Dropbox/PC/VerilogA/verilogA_v2/SEMLDB_veriloga_converter/outputs/NMOS/nmosva_idvg_ae_w0.txt", "r");
      for(i=0; i<250; i=i+1) count_tmp = $fscanf(fd, "%e", idvg_ae_w0[i]);
      $fclose(fd);
      fd = $fopen("C:/Users/ta688/UF Dropbox/PC/VerilogA/verilogA_v2/SEMLDB_veriloga_converter/outputs/NMOS/nmosva_idvg_ae_b0.txt", "r");
      for(i=0; i<50; i=i+1) count_tmp = $fscanf(fd, "%e", idvg_ae_b0[i]);
      $fclose(fd);
      fd = $fopen("C:/Users/ta688/UF Dropbox/PC/VerilogA/verilogA_v2/SEMLDB_veriloga_converter/outputs/NMOS/nmosva_idvg_ae_w1.txt", "r");
      for(i=0; i<10000; i=i+1) count_tmp = $fscanf(fd, "%e", idvg_ae_w1[i]);
      $fclose(fd);
      fd = $fopen("C:/Users/ta688/UF Dropbox/PC/VerilogA/verilogA_v2/SEMLDB_veriloga_converter/outputs/NMOS/nmosva_idvg_ae_b1.txt", "r");
      for(i=0; i<200; i=i+1) count_tmp = $fscanf(fd, "%e", idvg_ae_b1[i]);
      $fclose(fd);
      fd = $fopen("C:/Users/ta688/UF Dropbox/PC/VerilogA/verilogA_v2/SEMLDB_veriloga_converter/outputs/NMOS/nmosva_idvg_ae_w2.txt", "r");
      for(i=0; i<80000; i=i+1) count_tmp = $fscanf(fd, "%e", idvg_ae_w2[i]);
      $fclose(fd);
      fd = $fopen("C:/Users/ta688/UF Dropbox/PC/VerilogA/verilogA_v2/SEMLDB_veriloga_converter/outputs/NMOS/nmosva_idvg_ae_b2.txt", "r");
      for(i=0; i<400; i=i+1) count_tmp = $fscanf(fd, "%e", idvg_ae_b2[i]);
      $fclose(fd);
      fd = $fopen("C:/Users/ta688/UF Dropbox/PC/VerilogA/verilogA_v2/SEMLDB_veriloga_converter/outputs/NMOS/nmosva_idvg_ae_w3.txt", "r");
      for(i=0; i<160000; i=i+1) count_tmp = $fscanf(fd, "%e", idvg_ae_w3[i]);
      $fclose(fd);
      fd = $fopen("C:/Users/ta688/UF Dropbox/PC/VerilogA/verilogA_v2/SEMLDB_veriloga_converter/outputs/NMOS/nmosva_idvg_ae_b3.txt", "r");
      for(i=0; i<400; i=i+1) count_tmp = $fscanf(fd, "%e", idvg_ae_b3[i]);
      $fclose(fd);
      fd = $fopen("C:/Users/ta688/UF Dropbox/PC/VerilogA/verilogA_v2/SEMLDB_veriloga_converter/outputs/NMOS/nmosva_idvd_sx_mul.txt", "r");
      for(i=0; i<3; i=i+1) count_tmp = $fscanf(fd, "%e", idvd_sx_mul[i]);
      $fclose(fd);
      fd = $fopen("C:/Users/ta688/UF Dropbox/PC/VerilogA/verilogA_v2/SEMLDB_veriloga_converter/outputs/NMOS/nmosva_idvd_sx_add.txt", "r");
      for(i=0; i<3; i=i+1) count_tmp = $fscanf(fd, "%e", idvd_sx_add[i]);
      $fclose(fd);
      fd = $fopen("C:/Users/ta688/UF Dropbox/PC/VerilogA/verilogA_v2/SEMLDB_veriloga_converter/outputs/NMOS/nmosva_idvd_sl_mul.txt", "r");
      for(i=0; i<3; i=i+1) count_tmp = $fscanf(fd, "%e", idvd_sl_mul[i]);
      $fclose(fd);
      fd = $fopen("C:/Users/ta688/UF Dropbox/PC/VerilogA/verilogA_v2/SEMLDB_veriloga_converter/outputs/NMOS/nmosva_idvd_sl_add.txt", "r");
      for(i=0; i<3; i=i+1) count_tmp = $fscanf(fd, "%e", idvd_sl_add[i]);
      $fclose(fd);
      fd = $fopen("C:/Users/ta688/UF Dropbox/PC/VerilogA/verilogA_v2/SEMLDB_veriloga_converter/outputs/NMOS/nmosva_idvd_siv_mul.txt", "r");
      for(i=0; i<800; i=i+1) count_tmp = $fscanf(fd, "%e", idvd_siv_mul[i]);
      $fclose(fd);
      fd = $fopen("C:/Users/ta688/UF Dropbox/PC/VerilogA/verilogA_v2/SEMLDB_veriloga_converter/outputs/NMOS/nmosva_idvd_siv_add.txt", "r");
      for(i=0; i<800; i=i+1) count_tmp = $fscanf(fd, "%e", idvd_siv_add[i]);
      $fclose(fd);
      fd = $fopen("C:/Users/ta688/UF Dropbox/PC/VerilogA/verilogA_v2/SEMLDB_veriloga_converter/outputs/NMOS/nmosva_idvg_sx_mul.txt", "r");
      for(i=0; i<3; i=i+1) count_tmp = $fscanf(fd, "%e", idvg_sx_mul[i]);
      $fclose(fd);
      fd = $fopen("C:/Users/ta688/UF Dropbox/PC/VerilogA/verilogA_v2/SEMLDB_veriloga_converter/outputs/NMOS/nmosva_idvg_sx_add.txt", "r");
      for(i=0; i<3; i=i+1) count_tmp = $fscanf(fd, "%e", idvg_sx_add[i]);
      $fclose(fd);
      fd = $fopen("C:/Users/ta688/UF Dropbox/PC/VerilogA/verilogA_v2/SEMLDB_veriloga_converter/outputs/NMOS/nmosva_idvg_sl_mul.txt", "r");
      for(i=0; i<5; i=i+1) count_tmp = $fscanf(fd, "%e", idvg_sl_mul[i]);
      $fclose(fd);
      fd = $fopen("C:/Users/ta688/UF Dropbox/PC/VerilogA/verilogA_v2/SEMLDB_veriloga_converter/outputs/NMOS/nmosva_idvg_sl_add.txt", "r");
      for(i=0; i<5; i=i+1) count_tmp = $fscanf(fd, "%e", idvg_sl_add[i]);
      $fclose(fd);
      fd = $fopen("C:/Users/ta688/UF Dropbox/PC/VerilogA/verilogA_v2/SEMLDB_veriloga_converter/outputs/NMOS/nmosva_idvg_siv_mul.txt", "r");
      for(i=0; i<400; i=i+1) count_tmp = $fscanf(fd, "%e", idvg_siv_mul[i]);
      $fclose(fd);
      fd = $fopen("C:/Users/ta688/UF Dropbox/PC/VerilogA/verilogA_v2/SEMLDB_veriloga_converter/outputs/NMOS/nmosva_idvg_siv_add.txt", "r");
      for(i=0; i<400; i=i+1) count_tmp = $fscanf(fd, "%e", idvg_siv_add[i]);
      $fclose(fd);

      // Convert nm -> um before applying the learned input scalers.
      input_x[0] = (1.0e-3 * Lg) * idvd_sx_mul[0] + idvd_sx_add[0];
      input_x[1] = (1.0e-3 * THF) * idvd_sx_mul[1] + idvd_sx_add[1];
      input_x[2] = (1.0e-3 * XjSD) * idvd_sx_mul[2] + idvd_sx_add[2];
      idvd_poly_feat[0] = 1.0;
      idvd_poly_feat[1] = pow(input_x[0], 1);
      idvd_poly_feat[2] = pow(input_x[1], 1);
      idvd_poly_feat[3] = pow(input_x[2], 1);
      idvd_poly_feat[4] = pow(input_x[0], 2);
      idvd_poly_feat[5] = pow(input_x[0], 1) * pow(input_x[1], 1);
      idvd_poly_feat[6] = pow(input_x[0], 1) * pow(input_x[2], 1);
      idvd_poly_feat[7] = pow(input_x[1], 2);
      idvd_poly_feat[8] = pow(input_x[1], 1) * pow(input_x[2], 1);
      idvd_poly_feat[9] = pow(input_x[2], 2);
      idvd_poly_feat[10] = pow(input_x[0], 3);
      idvd_poly_feat[11] = pow(input_x[0], 2) * pow(input_x[1], 1);
      idvd_poly_feat[12] = pow(input_x[0], 2) * pow(input_x[2], 1);
      idvd_poly_feat[13] = pow(input_x[0], 1) * pow(input_x[1], 2);
      idvd_poly_feat[14] = pow(input_x[0], 1) * pow(input_x[1], 1) * pow(input_x[2], 1);
      idvd_poly_feat[15] = pow(input_x[0], 1) * pow(input_x[2], 2);
      idvd_poly_feat[16] = pow(input_x[1], 3);
      idvd_poly_feat[17] = pow(input_x[1], 2) * pow(input_x[2], 1);
      idvd_poly_feat[18] = pow(input_x[1], 1) * pow(input_x[2], 2);
      idvd_poly_feat[19] = pow(input_x[2], 3);
      idvd_poly_feat[20] = pow(input_x[0], 4);
      idvd_poly_feat[21] = pow(input_x[0], 3) * pow(input_x[1], 1);
      idvd_poly_feat[22] = pow(input_x[0], 3) * pow(input_x[2], 1);
      idvd_poly_feat[23] = pow(input_x[0], 2) * pow(input_x[1], 2);
      idvd_poly_feat[24] = pow(input_x[0], 2) * pow(input_x[1], 1) * pow(input_x[2], 1);
      idvd_poly_feat[25] = pow(input_x[0], 2) * pow(input_x[2], 2);
      idvd_poly_feat[26] = pow(input_x[0], 1) * pow(input_x[1], 3);
      idvd_poly_feat[27] = pow(input_x[0], 1) * pow(input_x[1], 2) * pow(input_x[2], 1);
      idvd_poly_feat[28] = pow(input_x[0], 1) * pow(input_x[1], 1) * pow(input_x[2], 2);
      idvd_poly_feat[29] = pow(input_x[0], 1) * pow(input_x[2], 3);
      idvd_poly_feat[30] = pow(input_x[1], 4);
      idvd_poly_feat[31] = pow(input_x[1], 3) * pow(input_x[2], 1);
      idvd_poly_feat[32] = pow(input_x[1], 2) * pow(input_x[2], 2);
      idvd_poly_feat[33] = pow(input_x[1], 1) * pow(input_x[2], 3);
      idvd_poly_feat[34] = pow(input_x[2], 4);
      idvd_poly_feat[35] = pow(input_x[0], 5);
      idvd_poly_feat[36] = pow(input_x[0], 4) * pow(input_x[1], 1);
      idvd_poly_feat[37] = pow(input_x[0], 4) * pow(input_x[2], 1);
      idvd_poly_feat[38] = pow(input_x[0], 3) * pow(input_x[1], 2);
      idvd_poly_feat[39] = pow(input_x[0], 3) * pow(input_x[1], 1) * pow(input_x[2], 1);
      idvd_poly_feat[40] = pow(input_x[0], 3) * pow(input_x[2], 2);
      idvd_poly_feat[41] = pow(input_x[0], 2) * pow(input_x[1], 3);
      idvd_poly_feat[42] = pow(input_x[0], 2) * pow(input_x[1], 2) * pow(input_x[2], 1);
      idvd_poly_feat[43] = pow(input_x[0], 2) * pow(input_x[1], 1) * pow(input_x[2], 2);
      idvd_poly_feat[44] = pow(input_x[0], 2) * pow(input_x[2], 3);
      idvd_poly_feat[45] = pow(input_x[0], 1) * pow(input_x[1], 4);
      idvd_poly_feat[46] = pow(input_x[0], 1) * pow(input_x[1], 3) * pow(input_x[2], 1);
      idvd_poly_feat[47] = pow(input_x[0], 1) * pow(input_x[1], 2) * pow(input_x[2], 2);
      idvd_poly_feat[48] = pow(input_x[0], 1) * pow(input_x[1], 1) * pow(input_x[2], 3);
      idvd_poly_feat[49] = pow(input_x[0], 1) * pow(input_x[2], 4);
      idvd_poly_feat[50] = pow(input_x[1], 5);
      idvd_poly_feat[51] = pow(input_x[1], 4) * pow(input_x[2], 1);
      idvd_poly_feat[52] = pow(input_x[1], 3) * pow(input_x[2], 2);
      idvd_poly_feat[53] = pow(input_x[1], 2) * pow(input_x[2], 3);
      idvd_poly_feat[54] = pow(input_x[1], 1) * pow(input_x[2], 4);
      idvd_poly_feat[55] = pow(input_x[2], 5);
      idvd_poly_feat[56] = pow(input_x[0], 6);
      idvd_poly_feat[57] = pow(input_x[0], 5) * pow(input_x[1], 1);
      idvd_poly_feat[58] = pow(input_x[0], 5) * pow(input_x[2], 1);
      idvd_poly_feat[59] = pow(input_x[0], 4) * pow(input_x[1], 2);
      idvd_poly_feat[60] = pow(input_x[0], 4) * pow(input_x[1], 1) * pow(input_x[2], 1);
      idvd_poly_feat[61] = pow(input_x[0], 4) * pow(input_x[2], 2);
      idvd_poly_feat[62] = pow(input_x[0], 3) * pow(input_x[1], 3);
      idvd_poly_feat[63] = pow(input_x[0], 3) * pow(input_x[1], 2) * pow(input_x[2], 1);
      idvd_poly_feat[64] = pow(input_x[0], 3) * pow(input_x[1], 1) * pow(input_x[2], 2);
      idvd_poly_feat[65] = pow(input_x[0], 3) * pow(input_x[2], 3);
      idvd_poly_feat[66] = pow(input_x[0], 2) * pow(input_x[1], 4);
      idvd_poly_feat[67] = pow(input_x[0], 2) * pow(input_x[1], 3) * pow(input_x[2], 1);
      idvd_poly_feat[68] = pow(input_x[0], 2) * pow(input_x[1], 2) * pow(input_x[2], 2);
      idvd_poly_feat[69] = pow(input_x[0], 2) * pow(input_x[1], 1) * pow(input_x[2], 3);
      idvd_poly_feat[70] = pow(input_x[0], 2) * pow(input_x[2], 4);
      idvd_poly_feat[71] = pow(input_x[0], 1) * pow(input_x[1], 5);
      idvd_poly_feat[72] = pow(input_x[0], 1) * pow(input_x[1], 4) * pow(input_x[2], 1);
      idvd_poly_feat[73] = pow(input_x[0], 1) * pow(input_x[1], 3) * pow(input_x[2], 2);
      idvd_poly_feat[74] = pow(input_x[0], 1) * pow(input_x[1], 2) * pow(input_x[2], 3);
      idvd_poly_feat[75] = pow(input_x[0], 1) * pow(input_x[1], 1) * pow(input_x[2], 4);
      idvd_poly_feat[76] = pow(input_x[0], 1) * pow(input_x[2], 5);
      idvd_poly_feat[77] = pow(input_x[1], 6);
      idvd_poly_feat[78] = pow(input_x[1], 5) * pow(input_x[2], 1);
      idvd_poly_feat[79] = pow(input_x[1], 4) * pow(input_x[2], 2);
      idvd_poly_feat[80] = pow(input_x[1], 3) * pow(input_x[2], 3);
      idvd_poly_feat[81] = pow(input_x[1], 2) * pow(input_x[2], 4);
      idvd_poly_feat[82] = pow(input_x[1], 1) * pow(input_x[2], 5);
      idvd_poly_feat[83] = pow(input_x[2], 6);
      idvd_poly_feat[84] = pow(input_x[0], 7);
      idvd_poly_feat[85] = pow(input_x[0], 6) * pow(input_x[1], 1);
      idvd_poly_feat[86] = pow(input_x[0], 6) * pow(input_x[2], 1);
      idvd_poly_feat[87] = pow(input_x[0], 5) * pow(input_x[1], 2);
      idvd_poly_feat[88] = pow(input_x[0], 5) * pow(input_x[1], 1) * pow(input_x[2], 1);
      idvd_poly_feat[89] = pow(input_x[0], 5) * pow(input_x[2], 2);
      idvd_poly_feat[90] = pow(input_x[0], 4) * pow(input_x[1], 3);
      idvd_poly_feat[91] = pow(input_x[0], 4) * pow(input_x[1], 2) * pow(input_x[2], 1);
      idvd_poly_feat[92] = pow(input_x[0], 4) * pow(input_x[1], 1) * pow(input_x[2], 2);
      idvd_poly_feat[93] = pow(input_x[0], 4) * pow(input_x[2], 3);
      idvd_poly_feat[94] = pow(input_x[0], 3) * pow(input_x[1], 4);
      idvd_poly_feat[95] = pow(input_x[0], 3) * pow(input_x[1], 3) * pow(input_x[2], 1);
      idvd_poly_feat[96] = pow(input_x[0], 3) * pow(input_x[1], 2) * pow(input_x[2], 2);
      idvd_poly_feat[97] = pow(input_x[0], 3) * pow(input_x[1], 1) * pow(input_x[2], 3);
      idvd_poly_feat[98] = pow(input_x[0], 3) * pow(input_x[2], 4);
      idvd_poly_feat[99] = pow(input_x[0], 2) * pow(input_x[1], 5);
      idvd_poly_feat[100] = pow(input_x[0], 2) * pow(input_x[1], 4) * pow(input_x[2], 1);
      idvd_poly_feat[101] = pow(input_x[0], 2) * pow(input_x[1], 3) * pow(input_x[2], 2);
      idvd_poly_feat[102] = pow(input_x[0], 2) * pow(input_x[1], 2) * pow(input_x[2], 3);
      idvd_poly_feat[103] = pow(input_x[0], 2) * pow(input_x[1], 1) * pow(input_x[2], 4);
      idvd_poly_feat[104] = pow(input_x[0], 2) * pow(input_x[2], 5);
      idvd_poly_feat[105] = pow(input_x[0], 1) * pow(input_x[1], 6);
      idvd_poly_feat[106] = pow(input_x[0], 1) * pow(input_x[1], 5) * pow(input_x[2], 1);
      idvd_poly_feat[107] = pow(input_x[0], 1) * pow(input_x[1], 4) * pow(input_x[2], 2);
      idvd_poly_feat[108] = pow(input_x[0], 1) * pow(input_x[1], 3) * pow(input_x[2], 3);
      idvd_poly_feat[109] = pow(input_x[0], 1) * pow(input_x[1], 2) * pow(input_x[2], 4);
      idvd_poly_feat[110] = pow(input_x[0], 1) * pow(input_x[1], 1) * pow(input_x[2], 5);
      idvd_poly_feat[111] = pow(input_x[0], 1) * pow(input_x[2], 6);
      idvd_poly_feat[112] = pow(input_x[1], 7);
      idvd_poly_feat[113] = pow(input_x[1], 6) * pow(input_x[2], 1);
      idvd_poly_feat[114] = pow(input_x[1], 5) * pow(input_x[2], 2);
      idvd_poly_feat[115] = pow(input_x[1], 4) * pow(input_x[2], 3);
      idvd_poly_feat[116] = pow(input_x[1], 3) * pow(input_x[2], 4);
      idvd_poly_feat[117] = pow(input_x[1], 2) * pow(input_x[2], 5);
      idvd_poly_feat[118] = pow(input_x[1], 1) * pow(input_x[2], 6);
      idvd_poly_feat[119] = pow(input_x[2], 7);
      idvd_poly_feat[120] = pow(input_x[0], 8);
      idvd_poly_feat[121] = pow(input_x[0], 7) * pow(input_x[1], 1);
      idvd_poly_feat[122] = pow(input_x[0], 7) * pow(input_x[2], 1);
      idvd_poly_feat[123] = pow(input_x[0], 6) * pow(input_x[1], 2);
      idvd_poly_feat[124] = pow(input_x[0], 6) * pow(input_x[1], 1) * pow(input_x[2], 1);
      idvd_poly_feat[125] = pow(input_x[0], 6) * pow(input_x[2], 2);
      idvd_poly_feat[126] = pow(input_x[0], 5) * pow(input_x[1], 3);
      idvd_poly_feat[127] = pow(input_x[0], 5) * pow(input_x[1], 2) * pow(input_x[2], 1);
      idvd_poly_feat[128] = pow(input_x[0], 5) * pow(input_x[1], 1) * pow(input_x[2], 2);
      idvd_poly_feat[129] = pow(input_x[0], 5) * pow(input_x[2], 3);
      idvd_poly_feat[130] = pow(input_x[0], 4) * pow(input_x[1], 4);
      idvd_poly_feat[131] = pow(input_x[0], 4) * pow(input_x[1], 3) * pow(input_x[2], 1);
      idvd_poly_feat[132] = pow(input_x[0], 4) * pow(input_x[1], 2) * pow(input_x[2], 2);
      idvd_poly_feat[133] = pow(input_x[0], 4) * pow(input_x[1], 1) * pow(input_x[2], 3);
      idvd_poly_feat[134] = pow(input_x[0], 4) * pow(input_x[2], 4);
      idvd_poly_feat[135] = pow(input_x[0], 3) * pow(input_x[1], 5);
      idvd_poly_feat[136] = pow(input_x[0], 3) * pow(input_x[1], 4) * pow(input_x[2], 1);
      idvd_poly_feat[137] = pow(input_x[0], 3) * pow(input_x[1], 3) * pow(input_x[2], 2);
      idvd_poly_feat[138] = pow(input_x[0], 3) * pow(input_x[1], 2) * pow(input_x[2], 3);
      idvd_poly_feat[139] = pow(input_x[0], 3) * pow(input_x[1], 1) * pow(input_x[2], 4);
      idvd_poly_feat[140] = pow(input_x[0], 3) * pow(input_x[2], 5);
      idvd_poly_feat[141] = pow(input_x[0], 2) * pow(input_x[1], 6);
      idvd_poly_feat[142] = pow(input_x[0], 2) * pow(input_x[1], 5) * pow(input_x[2], 1);
      idvd_poly_feat[143] = pow(input_x[0], 2) * pow(input_x[1], 4) * pow(input_x[2], 2);
      idvd_poly_feat[144] = pow(input_x[0], 2) * pow(input_x[1], 3) * pow(input_x[2], 3);
      idvd_poly_feat[145] = pow(input_x[0], 2) * pow(input_x[1], 2) * pow(input_x[2], 4);
      idvd_poly_feat[146] = pow(input_x[0], 2) * pow(input_x[1], 1) * pow(input_x[2], 5);
      idvd_poly_feat[147] = pow(input_x[0], 2) * pow(input_x[2], 6);
      idvd_poly_feat[148] = pow(input_x[0], 1) * pow(input_x[1], 7);
      idvd_poly_feat[149] = pow(input_x[0], 1) * pow(input_x[1], 6) * pow(input_x[2], 1);
      idvd_poly_feat[150] = pow(input_x[0], 1) * pow(input_x[1], 5) * pow(input_x[2], 2);
      idvd_poly_feat[151] = pow(input_x[0], 1) * pow(input_x[1], 4) * pow(input_x[2], 3);
      idvd_poly_feat[152] = pow(input_x[0], 1) * pow(input_x[1], 3) * pow(input_x[2], 4);
      idvd_poly_feat[153] = pow(input_x[0], 1) * pow(input_x[1], 2) * pow(input_x[2], 5);
      idvd_poly_feat[154] = pow(input_x[0], 1) * pow(input_x[1], 1) * pow(input_x[2], 6);
      idvd_poly_feat[155] = pow(input_x[0], 1) * pow(input_x[2], 7);
      idvd_poly_feat[156] = pow(input_x[1], 8);
      idvd_poly_feat[157] = pow(input_x[1], 7) * pow(input_x[2], 1);
      idvd_poly_feat[158] = pow(input_x[1], 6) * pow(input_x[2], 2);
      idvd_poly_feat[159] = pow(input_x[1], 5) * pow(input_x[2], 3);
      idvd_poly_feat[160] = pow(input_x[1], 4) * pow(input_x[2], 4);
      idvd_poly_feat[161] = pow(input_x[1], 3) * pow(input_x[2], 5);
      idvd_poly_feat[162] = pow(input_x[1], 2) * pow(input_x[2], 6);
      idvd_poly_feat[163] = pow(input_x[1], 1) * pow(input_x[2], 7);
      idvd_poly_feat[164] = pow(input_x[2], 8);
      idvd_poly_feat[165] = pow(input_x[0], 9);
      idvd_poly_feat[166] = pow(input_x[0], 8) * pow(input_x[1], 1);
      idvd_poly_feat[167] = pow(input_x[0], 8) * pow(input_x[2], 1);
      idvd_poly_feat[168] = pow(input_x[0], 7) * pow(input_x[1], 2);
      idvd_poly_feat[169] = pow(input_x[0], 7) * pow(input_x[1], 1) * pow(input_x[2], 1);
      idvd_poly_feat[170] = pow(input_x[0], 7) * pow(input_x[2], 2);
      idvd_poly_feat[171] = pow(input_x[0], 6) * pow(input_x[1], 3);
      idvd_poly_feat[172] = pow(input_x[0], 6) * pow(input_x[1], 2) * pow(input_x[2], 1);
      idvd_poly_feat[173] = pow(input_x[0], 6) * pow(input_x[1], 1) * pow(input_x[2], 2);
      idvd_poly_feat[174] = pow(input_x[0], 6) * pow(input_x[2], 3);
      idvd_poly_feat[175] = pow(input_x[0], 5) * pow(input_x[1], 4);
      idvd_poly_feat[176] = pow(input_x[0], 5) * pow(input_x[1], 3) * pow(input_x[2], 1);
      idvd_poly_feat[177] = pow(input_x[0], 5) * pow(input_x[1], 2) * pow(input_x[2], 2);
      idvd_poly_feat[178] = pow(input_x[0], 5) * pow(input_x[1], 1) * pow(input_x[2], 3);
      idvd_poly_feat[179] = pow(input_x[0], 5) * pow(input_x[2], 4);
      idvd_poly_feat[180] = pow(input_x[0], 4) * pow(input_x[1], 5);
      idvd_poly_feat[181] = pow(input_x[0], 4) * pow(input_x[1], 4) * pow(input_x[2], 1);
      idvd_poly_feat[182] = pow(input_x[0], 4) * pow(input_x[1], 3) * pow(input_x[2], 2);
      idvd_poly_feat[183] = pow(input_x[0], 4) * pow(input_x[1], 2) * pow(input_x[2], 3);
      idvd_poly_feat[184] = pow(input_x[0], 4) * pow(input_x[1], 1) * pow(input_x[2], 4);
      idvd_poly_feat[185] = pow(input_x[0], 4) * pow(input_x[2], 5);
      idvd_poly_feat[186] = pow(input_x[0], 3) * pow(input_x[1], 6);
      idvd_poly_feat[187] = pow(input_x[0], 3) * pow(input_x[1], 5) * pow(input_x[2], 1);
      idvd_poly_feat[188] = pow(input_x[0], 3) * pow(input_x[1], 4) * pow(input_x[2], 2);
      idvd_poly_feat[189] = pow(input_x[0], 3) * pow(input_x[1], 3) * pow(input_x[2], 3);
      idvd_poly_feat[190] = pow(input_x[0], 3) * pow(input_x[1], 2) * pow(input_x[2], 4);
      idvd_poly_feat[191] = pow(input_x[0], 3) * pow(input_x[1], 1) * pow(input_x[2], 5);
      idvd_poly_feat[192] = pow(input_x[0], 3) * pow(input_x[2], 6);
      idvd_poly_feat[193] = pow(input_x[0], 2) * pow(input_x[1], 7);
      idvd_poly_feat[194] = pow(input_x[0], 2) * pow(input_x[1], 6) * pow(input_x[2], 1);
      idvd_poly_feat[195] = pow(input_x[0], 2) * pow(input_x[1], 5) * pow(input_x[2], 2);
      idvd_poly_feat[196] = pow(input_x[0], 2) * pow(input_x[1], 4) * pow(input_x[2], 3);
      idvd_poly_feat[197] = pow(input_x[0], 2) * pow(input_x[1], 3) * pow(input_x[2], 4);
      idvd_poly_feat[198] = pow(input_x[0], 2) * pow(input_x[1], 2) * pow(input_x[2], 5);
      idvd_poly_feat[199] = pow(input_x[0], 2) * pow(input_x[1], 1) * pow(input_x[2], 6);
      idvd_poly_feat[200] = pow(input_x[0], 2) * pow(input_x[2], 7);
      idvd_poly_feat[201] = pow(input_x[0], 1) * pow(input_x[1], 8);
      idvd_poly_feat[202] = pow(input_x[0], 1) * pow(input_x[1], 7) * pow(input_x[2], 1);
      idvd_poly_feat[203] = pow(input_x[0], 1) * pow(input_x[1], 6) * pow(input_x[2], 2);
      idvd_poly_feat[204] = pow(input_x[0], 1) * pow(input_x[1], 5) * pow(input_x[2], 3);
      idvd_poly_feat[205] = pow(input_x[0], 1) * pow(input_x[1], 4) * pow(input_x[2], 4);
      idvd_poly_feat[206] = pow(input_x[0], 1) * pow(input_x[1], 3) * pow(input_x[2], 5);
      idvd_poly_feat[207] = pow(input_x[0], 1) * pow(input_x[1], 2) * pow(input_x[2], 6);
      idvd_poly_feat[208] = pow(input_x[0], 1) * pow(input_x[1], 1) * pow(input_x[2], 7);
      idvd_poly_feat[209] = pow(input_x[0], 1) * pow(input_x[2], 8);
      idvd_poly_feat[210] = pow(input_x[1], 9);
      idvd_poly_feat[211] = pow(input_x[1], 8) * pow(input_x[2], 1);
      idvd_poly_feat[212] = pow(input_x[1], 7) * pow(input_x[2], 2);
      idvd_poly_feat[213] = pow(input_x[1], 6) * pow(input_x[2], 3);
      idvd_poly_feat[214] = pow(input_x[1], 5) * pow(input_x[2], 4);
      idvd_poly_feat[215] = pow(input_x[1], 4) * pow(input_x[2], 5);
      idvd_poly_feat[216] = pow(input_x[1], 3) * pow(input_x[2], 6);
      idvd_poly_feat[217] = pow(input_x[1], 2) * pow(input_x[2], 7);
      idvd_poly_feat[218] = pow(input_x[1], 1) * pow(input_x[2], 8);
      idvd_poly_feat[219] = pow(input_x[2], 9);
      idvd_poly_feat[220] = pow(input_x[0], 10);
      idvd_poly_feat[221] = pow(input_x[1], 10);
      idvd_poly_feat[222] = pow(input_x[2], 10);
      idvd_poly_feat[223] = pow(input_x[0], 11);
      idvd_poly_feat[224] = pow(input_x[1], 11);
      idvd_poly_feat[225] = pow(input_x[2], 11);
      idvd_poly_feat[226] = pow(input_x[0], 12);
      idvd_poly_feat[227] = pow(input_x[1], 12);
      idvd_poly_feat[228] = pow(input_x[2], 12);
      idvd_poly_feat[229] = pow(input_x[0], 13);
      idvd_poly_feat[230] = pow(input_x[1], 13);
      idvd_poly_feat[231] = pow(input_x[2], 13);
      idvd_poly_feat[232] = pow(input_x[0], 14);
      idvd_poly_feat[233] = pow(input_x[1], 14);
      idvd_poly_feat[234] = pow(input_x[2], 14);
      for(i=0; i<3; i=i+1) begin
        tmp = idvd_poly_b[i];
        for(j=0; j<235; j=j+1) tmp = tmp + idvd_poly_w[i*235 + j] * idvd_poly_feat[j];
        idvd_z[i] = tmp * idvd_sl_mul[i] + idvd_sl_add[i];
      end
      for(i=0; i<50; i=i+1) begin
        tmp = idvd_ae_b0[i];
        for(j=0; j<3; j=j+1) tmp = tmp + idvd_ae_w0[i*3 + j] * idvd_z[j];
        idvd_h0[i] = (tmp > 0.0) ? tmp : 0.0;
      end
      for(i=0; i<200; i=i+1) begin
        tmp = idvd_ae_b1[i];
        for(j=0; j<50; j=j+1) tmp = tmp + idvd_ae_w1[i*50 + j] * idvd_h0[j];
        idvd_h1[i] = (tmp > 0.0) ? tmp : 0.0;
      end
      for(i=0; i<400; i=i+1) begin
        tmp = idvd_ae_b2[i];
        for(j=0; j<200; j=j+1) tmp = tmp + idvd_ae_w2[i*200 + j] * idvd_h1[j];
        idvd_h2[i] = (tmp > 0.0) ? tmp : 0.0;
      end
      for(i=0; i<800; i=i+1) begin
        tmp = idvd_ae_b3[i];
        for(j=0; j<400; j=j+1) tmp = tmp + idvd_ae_w3[i*400 + j] * idvd_h2[j];
        tmp = 1.0 / (1.0 + exp(-tmp));
        idvd_out[i] = tmp * idvd_siv_mul[i] + idvd_siv_add[i];
      end

      input_x[0] = (1.0e-3 * Lg) * idvg_sx_mul[0] + idvg_sx_add[0];
      input_x[1] = (1.0e-3 * THF) * idvg_sx_mul[1] + idvg_sx_add[1];
      input_x[2] = (1.0e-3 * XjSD) * idvg_sx_mul[2] + idvg_sx_add[2];
      idvg_poly_feat[0] = 1.0;
      idvg_poly_feat[1] = pow(input_x[0], 1);
      idvg_poly_feat[2] = pow(input_x[1], 1);
      idvg_poly_feat[3] = pow(input_x[2], 1);
      idvg_poly_feat[4] = pow(input_x[0], 2);
      idvg_poly_feat[5] = pow(input_x[0], 1) * pow(input_x[1], 1);
      idvg_poly_feat[6] = pow(input_x[0], 1) * pow(input_x[2], 1);
      idvg_poly_feat[7] = pow(input_x[1], 2);
      idvg_poly_feat[8] = pow(input_x[1], 1) * pow(input_x[2], 1);
      idvg_poly_feat[9] = pow(input_x[2], 2);
      idvg_poly_feat[10] = pow(input_x[0], 3);
      idvg_poly_feat[11] = pow(input_x[0], 2) * pow(input_x[1], 1);
      idvg_poly_feat[12] = pow(input_x[0], 2) * pow(input_x[2], 1);
      idvg_poly_feat[13] = pow(input_x[0], 1) * pow(input_x[1], 2);
      idvg_poly_feat[14] = pow(input_x[0], 1) * pow(input_x[1], 1) * pow(input_x[2], 1);
      idvg_poly_feat[15] = pow(input_x[0], 1) * pow(input_x[2], 2);
      idvg_poly_feat[16] = pow(input_x[1], 3);
      idvg_poly_feat[17] = pow(input_x[1], 2) * pow(input_x[2], 1);
      idvg_poly_feat[18] = pow(input_x[1], 1) * pow(input_x[2], 2);
      idvg_poly_feat[19] = pow(input_x[2], 3);
      idvg_poly_feat[20] = pow(input_x[0], 4);
      idvg_poly_feat[21] = pow(input_x[0], 3) * pow(input_x[1], 1);
      idvg_poly_feat[22] = pow(input_x[0], 3) * pow(input_x[2], 1);
      idvg_poly_feat[23] = pow(input_x[0], 2) * pow(input_x[1], 2);
      idvg_poly_feat[24] = pow(input_x[0], 2) * pow(input_x[1], 1) * pow(input_x[2], 1);
      idvg_poly_feat[25] = pow(input_x[0], 2) * pow(input_x[2], 2);
      idvg_poly_feat[26] = pow(input_x[0], 1) * pow(input_x[1], 3);
      idvg_poly_feat[27] = pow(input_x[0], 1) * pow(input_x[1], 2) * pow(input_x[2], 1);
      idvg_poly_feat[28] = pow(input_x[0], 1) * pow(input_x[1], 1) * pow(input_x[2], 2);
      idvg_poly_feat[29] = pow(input_x[0], 1) * pow(input_x[2], 3);
      idvg_poly_feat[30] = pow(input_x[1], 4);
      idvg_poly_feat[31] = pow(input_x[1], 3) * pow(input_x[2], 1);
      idvg_poly_feat[32] = pow(input_x[1], 2) * pow(input_x[2], 2);
      idvg_poly_feat[33] = pow(input_x[1], 1) * pow(input_x[2], 3);
      idvg_poly_feat[34] = pow(input_x[2], 4);
      idvg_poly_feat[35] = pow(input_x[0], 5);
      idvg_poly_feat[36] = pow(input_x[0], 4) * pow(input_x[1], 1);
      idvg_poly_feat[37] = pow(input_x[0], 4) * pow(input_x[2], 1);
      idvg_poly_feat[38] = pow(input_x[0], 3) * pow(input_x[1], 2);
      idvg_poly_feat[39] = pow(input_x[0], 3) * pow(input_x[1], 1) * pow(input_x[2], 1);
      idvg_poly_feat[40] = pow(input_x[0], 3) * pow(input_x[2], 2);
      idvg_poly_feat[41] = pow(input_x[0], 2) * pow(input_x[1], 3);
      idvg_poly_feat[42] = pow(input_x[0], 2) * pow(input_x[1], 2) * pow(input_x[2], 1);
      idvg_poly_feat[43] = pow(input_x[0], 2) * pow(input_x[1], 1) * pow(input_x[2], 2);
      idvg_poly_feat[44] = pow(input_x[0], 2) * pow(input_x[2], 3);
      idvg_poly_feat[45] = pow(input_x[0], 1) * pow(input_x[1], 4);
      idvg_poly_feat[46] = pow(input_x[0], 1) * pow(input_x[1], 3) * pow(input_x[2], 1);
      idvg_poly_feat[47] = pow(input_x[0], 1) * pow(input_x[1], 2) * pow(input_x[2], 2);
      idvg_poly_feat[48] = pow(input_x[0], 1) * pow(input_x[1], 1) * pow(input_x[2], 3);
      idvg_poly_feat[49] = pow(input_x[0], 1) * pow(input_x[2], 4);
      idvg_poly_feat[50] = pow(input_x[1], 5);
      idvg_poly_feat[51] = pow(input_x[1], 4) * pow(input_x[2], 1);
      idvg_poly_feat[52] = pow(input_x[1], 3) * pow(input_x[2], 2);
      idvg_poly_feat[53] = pow(input_x[1], 2) * pow(input_x[2], 3);
      idvg_poly_feat[54] = pow(input_x[1], 1) * pow(input_x[2], 4);
      idvg_poly_feat[55] = pow(input_x[2], 5);
      idvg_poly_feat[56] = pow(input_x[0], 6);
      idvg_poly_feat[57] = pow(input_x[0], 5) * pow(input_x[1], 1);
      idvg_poly_feat[58] = pow(input_x[0], 5) * pow(input_x[2], 1);
      idvg_poly_feat[59] = pow(input_x[0], 4) * pow(input_x[1], 2);
      idvg_poly_feat[60] = pow(input_x[0], 4) * pow(input_x[1], 1) * pow(input_x[2], 1);
      idvg_poly_feat[61] = pow(input_x[0], 4) * pow(input_x[2], 2);
      idvg_poly_feat[62] = pow(input_x[0], 3) * pow(input_x[1], 3);
      idvg_poly_feat[63] = pow(input_x[0], 3) * pow(input_x[1], 2) * pow(input_x[2], 1);
      idvg_poly_feat[64] = pow(input_x[0], 3) * pow(input_x[1], 1) * pow(input_x[2], 2);
      idvg_poly_feat[65] = pow(input_x[0], 3) * pow(input_x[2], 3);
      idvg_poly_feat[66] = pow(input_x[0], 2) * pow(input_x[1], 4);
      idvg_poly_feat[67] = pow(input_x[0], 2) * pow(input_x[1], 3) * pow(input_x[2], 1);
      idvg_poly_feat[68] = pow(input_x[0], 2) * pow(input_x[1], 2) * pow(input_x[2], 2);
      idvg_poly_feat[69] = pow(input_x[0], 2) * pow(input_x[1], 1) * pow(input_x[2], 3);
      idvg_poly_feat[70] = pow(input_x[0], 2) * pow(input_x[2], 4);
      idvg_poly_feat[71] = pow(input_x[0], 1) * pow(input_x[1], 5);
      idvg_poly_feat[72] = pow(input_x[0], 1) * pow(input_x[1], 4) * pow(input_x[2], 1);
      idvg_poly_feat[73] = pow(input_x[0], 1) * pow(input_x[1], 3) * pow(input_x[2], 2);
      idvg_poly_feat[74] = pow(input_x[0], 1) * pow(input_x[1], 2) * pow(input_x[2], 3);
      idvg_poly_feat[75] = pow(input_x[0], 1) * pow(input_x[1], 1) * pow(input_x[2], 4);
      idvg_poly_feat[76] = pow(input_x[0], 1) * pow(input_x[2], 5);
      idvg_poly_feat[77] = pow(input_x[1], 6);
      idvg_poly_feat[78] = pow(input_x[1], 5) * pow(input_x[2], 1);
      idvg_poly_feat[79] = pow(input_x[1], 4) * pow(input_x[2], 2);
      idvg_poly_feat[80] = pow(input_x[1], 3) * pow(input_x[2], 3);
      idvg_poly_feat[81] = pow(input_x[1], 2) * pow(input_x[2], 4);
      idvg_poly_feat[82] = pow(input_x[1], 1) * pow(input_x[2], 5);
      idvg_poly_feat[83] = pow(input_x[2], 6);
      idvg_poly_feat[84] = pow(input_x[0], 7);
      idvg_poly_feat[85] = pow(input_x[0], 6) * pow(input_x[1], 1);
      idvg_poly_feat[86] = pow(input_x[0], 6) * pow(input_x[2], 1);
      idvg_poly_feat[87] = pow(input_x[0], 5) * pow(input_x[1], 2);
      idvg_poly_feat[88] = pow(input_x[0], 5) * pow(input_x[1], 1) * pow(input_x[2], 1);
      idvg_poly_feat[89] = pow(input_x[0], 5) * pow(input_x[2], 2);
      idvg_poly_feat[90] = pow(input_x[0], 4) * pow(input_x[1], 3);
      idvg_poly_feat[91] = pow(input_x[0], 4) * pow(input_x[1], 2) * pow(input_x[2], 1);
      idvg_poly_feat[92] = pow(input_x[0], 4) * pow(input_x[1], 1) * pow(input_x[2], 2);
      idvg_poly_feat[93] = pow(input_x[0], 4) * pow(input_x[2], 3);
      idvg_poly_feat[94] = pow(input_x[0], 3) * pow(input_x[1], 4);
      idvg_poly_feat[95] = pow(input_x[0], 3) * pow(input_x[1], 3) * pow(input_x[2], 1);
      idvg_poly_feat[96] = pow(input_x[0], 3) * pow(input_x[1], 2) * pow(input_x[2], 2);
      idvg_poly_feat[97] = pow(input_x[0], 3) * pow(input_x[1], 1) * pow(input_x[2], 3);
      idvg_poly_feat[98] = pow(input_x[0], 3) * pow(input_x[2], 4);
      idvg_poly_feat[99] = pow(input_x[0], 2) * pow(input_x[1], 5);
      idvg_poly_feat[100] = pow(input_x[0], 2) * pow(input_x[1], 4) * pow(input_x[2], 1);
      idvg_poly_feat[101] = pow(input_x[0], 2) * pow(input_x[1], 3) * pow(input_x[2], 2);
      idvg_poly_feat[102] = pow(input_x[0], 2) * pow(input_x[1], 2) * pow(input_x[2], 3);
      idvg_poly_feat[103] = pow(input_x[0], 2) * pow(input_x[1], 1) * pow(input_x[2], 4);
      idvg_poly_feat[104] = pow(input_x[0], 2) * pow(input_x[2], 5);
      idvg_poly_feat[105] = pow(input_x[0], 1) * pow(input_x[1], 6);
      idvg_poly_feat[106] = pow(input_x[0], 1) * pow(input_x[1], 5) * pow(input_x[2], 1);
      idvg_poly_feat[107] = pow(input_x[0], 1) * pow(input_x[1], 4) * pow(input_x[2], 2);
      idvg_poly_feat[108] = pow(input_x[0], 1) * pow(input_x[1], 3) * pow(input_x[2], 3);
      idvg_poly_feat[109] = pow(input_x[0], 1) * pow(input_x[1], 2) * pow(input_x[2], 4);
      idvg_poly_feat[110] = pow(input_x[0], 1) * pow(input_x[1], 1) * pow(input_x[2], 5);
      idvg_poly_feat[111] = pow(input_x[0], 1) * pow(input_x[2], 6);
      idvg_poly_feat[112] = pow(input_x[1], 7);
      idvg_poly_feat[113] = pow(input_x[1], 6) * pow(input_x[2], 1);
      idvg_poly_feat[114] = pow(input_x[1], 5) * pow(input_x[2], 2);
      idvg_poly_feat[115] = pow(input_x[1], 4) * pow(input_x[2], 3);
      idvg_poly_feat[116] = pow(input_x[1], 3) * pow(input_x[2], 4);
      idvg_poly_feat[117] = pow(input_x[1], 2) * pow(input_x[2], 5);
      idvg_poly_feat[118] = pow(input_x[1], 1) * pow(input_x[2], 6);
      idvg_poly_feat[119] = pow(input_x[2], 7);
      for(i=0; i<5; i=i+1) begin
        tmp = idvg_poly_b[i];
        for(j=0; j<120; j=j+1) tmp = tmp + idvg_poly_w[i*120 + j] * idvg_poly_feat[j];
        idvg_z[i] = tmp * idvg_sl_mul[i] + idvg_sl_add[i];
      end
      for(i=0; i<50; i=i+1) begin
        tmp = idvg_ae_b0[i];
        for(j=0; j<5; j=j+1) tmp = tmp + idvg_ae_w0[i*5 + j] * idvg_z[j];
        idvg_h0[i] = (tmp > 0.0) ? tmp : 0.0;
      end
      for(i=0; i<200; i=i+1) begin
        tmp = idvg_ae_b1[i];
        for(j=0; j<50; j=j+1) tmp = tmp + idvg_ae_w1[i*50 + j] * idvg_h0[j];
        idvg_h1[i] = (tmp > 0.0) ? tmp : 0.0;
      end
      for(i=0; i<400; i=i+1) begin
        tmp = idvg_ae_b2[i];
        for(j=0; j<200; j=j+1) tmp = tmp + idvg_ae_w2[i*200 + j] * idvg_h1[j];
        idvg_h2[i] = (tmp > 0.0) ? tmp : 0.0;
      end
      for(i=0; i<400; i=i+1) begin
        tmp = idvg_ae_b3[i];
        for(j=0; j<400; j=j+1) tmp = tmp + idvg_ae_w3[i*400 + j] * idvg_h2[j];
        tmp = 1.0 / (1.0 + exp(-tmp));
        idvg_out[i] = tmp * idvg_siv_mul[i] + idvg_siv_add[i];
      end
    end

    val_vg = V(g, s);
    val_vd = V(d, s);
    sign_vd = val_vd / sqrt(val_vd*val_vd + vds_sign_delta*vds_sign_delta);
    vd_mag = sqrt(val_vd*val_vd + vds_sign_delta*vds_sign_delta);

    // Id-Vd surface: 4 Vg anchors x 200 Vd samples
    if(val_vg <= 0.25) begin
      idvd_vg0_idx = 0;
      idvd_vg1_idx = 1;
      idvd_vg_frac = 0.0;
      idvd_excess = 0.25 - val_vg;
    end else if(val_vg >= 1.0) begin
      idvd_vg0_idx = 2;
      idvd_vg1_idx = 3;
      idvd_vg_frac = 1.0;
      idvd_excess = val_vg - 1.0;
    end else begin
      idvd_vg_pos = (val_vg - 0.25) / 0.25;
      idvd_vg0_idx = $rtoi(idvd_vg_pos);
      if(idvd_vg0_idx > 2) idvd_vg0_idx = 2;
      idvd_vg1_idx = idvd_vg0_idx + 1;
      idvd_vg_frac = idvd_vg_pos - idvd_vg0_idx;
      idvd_excess = 0.0;
    end

    if(vd_mag <= 0.0025) begin
      idvd_vd0_idx = 0;
      idvd_vd1_idx = 1;
      idvd_vd_frac = 0.0;
    end else if(vd_mag >= 1.0) begin
      idvd_vd0_idx = 198;
      idvd_vd1_idx = 199;
      idvd_vd_frac = 1.0;
    end else begin
      idvd_vd_pos = (vd_mag - 0.0025) / (0.9975 / 199.0);
      idvd_vd0_idx = $rtoi(idvd_vd_pos);
      if(idvd_vd0_idx > 198) idvd_vd0_idx = 198;
      idvd_vd1_idx = idvd_vd0_idx + 1;
      idvd_vd_frac = idvd_vd_pos - idvd_vd0_idx;
    end

    idvd_i00 = idvd_out[idvd_vg0_idx * 200 + idvd_vd0_idx];
    idvd_i01 = idvd_out[idvd_vg0_idx * 200 + idvd_vd1_idx];
    idvd_i10 = idvd_out[idvd_vg1_idx * 200 + idvd_vd0_idx];
    idvd_i11 = idvd_out[idvd_vg1_idx * 200 + idvd_vd1_idx];
    idvd_interp = (1.0 - idvd_vg_frac) * ((1.0 - idvd_vd_frac) * idvd_i00 + idvd_vd_frac * idvd_i01)
                + idvd_vg_frac * ((1.0 - idvd_vd_frac) * idvd_i10 + idvd_vd_frac * idvd_i11);
    if(idvd_interp < 0.0) idvd_interp = 0.0;

    // Id-Vg surface: 2 Vd anchors x 200 Vg samples
    if(val_vg <= 0.0025) begin
      idvg_vg0_idx = 0;
      idvg_vg1_idx = 1;
      idvg_vg_frac = 0.0;
    end else if(val_vg >= 1.0) begin
      idvg_vg0_idx = 198;
      idvg_vg1_idx = 199;
      idvg_vg_frac = 1.0;
    end else begin
      idvg_vg_pos = (val_vg - 0.0025) / (0.9975 / 199.0);
      idvg_vg0_idx = $rtoi(idvg_vg_pos);
      if(idvg_vg0_idx > 198) idvg_vg0_idx = 198;
      idvg_vg1_idx = idvg_vg0_idx + 1;
      idvg_vg_frac = idvg_vg_pos - idvg_vg0_idx;
    end

    if(vd_mag <= 0.05) begin
      idvg_vd0_idx = 0;
      idvg_vd1_idx = 1;
      idvg_vd_frac = 0.0;
      idvg_excess = 0.05 - vd_mag;
    end else if(vd_mag >= 1.0) begin
      idvg_vd0_idx = 0;
      idvg_vd1_idx = 1;
      idvg_vd_frac = 1.0;
      idvg_excess = vd_mag - 1.0;
    end else begin
      idvg_vd0_idx = 0;
      idvg_vd1_idx = 1;
      idvg_vd_frac = (vd_mag - 0.05) / 0.95;
      idvg_excess = 0.0;
    end

    idvg_i00 = idvg_out[idvg_vd0_idx * 200 + idvg_vg0_idx];
    idvg_i01 = idvg_out[idvg_vd0_idx * 200 + idvg_vg1_idx];
    idvg_i10 = idvg_out[idvg_vd1_idx * 200 + idvg_vg0_idx];
    idvg_i11 = idvg_out[idvg_vd1_idx * 200 + idvg_vg1_idx];
    idvg_interp = (1.0 - idvg_vd_frac) * ((1.0 - idvg_vg_frac) * idvg_i00 + idvg_vg_frac * idvg_i01)
                + idvg_vd_frac * ((1.0 - idvg_vg_frac) * idvg_i10 + idvg_vg_frac * idvg_i11);
    if(idvg_interp < 0.0) idvg_interp = 0.0;

    if(idvd_vg_frac < 0.5) idvd_vg_dist = 2.0 * idvd_vg_frac;
    else idvd_vg_dist = 2.0 * (1.0 - idvd_vg_frac);
    if(idvg_vd_frac < 0.5) idvg_vd_dist = 2.0 * idvg_vd_frac;
    else idvg_vd_dist = 2.0 * (1.0 - idvg_vd_frac);

    w_idvd = 1.0 / (0.05 + (idvd_vg_dist + 2.0 * idvd_excess) * (idvd_vg_dist + 2.0 * idvd_excess));
    w_idvg = 1.0 / (0.05 + (idvg_vd_dist + 2.0 * idvg_excess) * (idvg_vd_dist + 2.0 * idvg_excess));

    if(current_mode == 1) begin
      res_id_mag = idvd_interp;
    end else if(current_mode == 2) begin
      res_id_mag = idvg_interp;
    end else begin
      w_sum = w_idvd + w_idvg;
      if(w_sum > 0.0) res_id_mag = (w_idvd * idvd_interp + w_idvg * idvg_interp) / w_sum;
      else res_id_mag = 0.5 * (idvd_interp + idvg_interp);
    end

    if(res_id_mag < 0.0) res_id_mag = 0.0;
    I(d, s) <+ sign_vd * res_id_mag;
    I(d, s) <+ gmin_ds * V(d, s);
  end
endmodule
