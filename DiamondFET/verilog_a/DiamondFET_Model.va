// Automatically generated Verilog-A DiamondFET drain-current model
`include "constants.vams"
`include "disciplines.vams"

module DiamondFET(d, g, s);
  inout d, g, s;
  electrical d, g, s;

  // Geometry parameters follow the ML front-end convention:
  // Lg/Lgs/Tox are provided in nm, Rc in ohm*mm.
  // The backend assumes Lgd = Lgs, so only a single gate-to-contact spacing is exposed.
  parameter real Lg = 400.0;
  parameter real Lgs = 900.0;
  parameter real Tox = 17.0;
  parameter real Rc = 0.90;
  // 0: blended current, 1: Id-Vd surface only, 2: Id-Vg surface only
  parameter integer current_mode = 0;
  parameter real gmin_ds = 1e-12 from [0:inf);
  parameter real vds_sign_delta = 1e-4 from [0:inf);

  real idvd_poly_w[0:3614];
  real idvd_poly_b[0:4];
  real idvd_ae_w0[0:339];
  real idvd_ae_b0[0:67];
  real idvd_ae_w1[0:18359];
  real idvd_ae_b1[0:269];
  real idvd_ae_w2[0:145799];
  real idvd_ae_b2[0:539];
  real idvd_ae_w3[0:583199];
  real idvd_ae_b3[0:1079];
  real idvg_poly_w[0:3464];
  real idvg_poly_b[0:6];
  real idvg_ae_w0[0:1056];
  real idvg_ae_b0[0:150];
  real idvg_ae_w1[0:91052];
  real idvg_ae_b1[0:602];
  real idvg_ae_w2[0:727217];
  real idvg_ae_b2[0:1205];
  real idvg_ae_w3[0:1454435];
  real idvg_ae_b3[0:1205];
  real idvd_sx_mul[0:3];
  real idvd_sx_add[0:3];
  real idvd_sl_mul[0:4];
  real idvd_sl_add[0:4];
  real idvd_siv_mul[0:1079];
  real idvd_siv_add[0:1079];
  real idvg_sx_mul[0:3];
  real idvg_sx_add[0:3];
  real idvg_sl_mul[0:6];
  real idvg_sl_add[0:6];
  real idvg_siv_mul[0:1205];
  real idvg_siv_add[0:1205];

  // Temporary buffers
  real input_x[0:3];
  real idvd_poly_feat[0:722];
  real idvd_z[0:4];
  real idvd_h0[0:67];
  real idvd_h1[0:269];
  real idvd_h2[0:539];
  real idvd_out[0:1079];
  real idvg_poly_feat[0:494];
  real idvg_z[0:6];
  real idvg_h0[0:150];
  real idvg_h1[0:602];
  real idvg_h2[0:1205];
  real idvg_out[0:1205];
  integer i, j, fd, count_tmp;
  integer idvd_vg0_idx, idvd_vg1_idx, idvd_vd0_idx, idvd_vd1_idx;
  integer idvg_vg0_idx, idvg_vg1_idx, idvg_vd0_idx, idvg_vd1_idx;
  real tmp, val_vg, val_vd, vd_mag, sign_vd, res_id_ref;
  real idvd_vg_pos, idvd_vg_frac, idvd_vd_pos, idvd_vd_frac;
  real idvg_vg_pos, idvg_vg_frac, idvg_vd_pos, idvg_vd_frac;
  real idvd_i00, idvd_i01, idvd_i10, idvd_i11, idvd_interp;
  real idvg_i00, idvg_i01, idvg_i10, idvg_i11, idvg_interp;
  real idvd_vg_dist, idvg_vd_dist, idvd_excess, idvg_excess;
  real w_idvd, w_idvg, w_sum;

  analog begin
    @(initial_step) begin
      fd = $fopen("/home/UFAD/tanvir.ahmed/Desktop/Verilog/DiamondFET/verilog_a/diamondfet_idvd_poly_w.txt", "r");
      for(i=0; i<3615; i=i+1) count_tmp = $fscanf(fd, "%e", idvd_poly_w[i]);
      $fclose(fd);
      fd = $fopen("/home/UFAD/tanvir.ahmed/Desktop/Verilog/DiamondFET/verilog_a/diamondfet_idvd_poly_b.txt", "r");
      for(i=0; i<5; i=i+1) count_tmp = $fscanf(fd, "%e", idvd_poly_b[i]);
      $fclose(fd);
      fd = $fopen("/home/UFAD/tanvir.ahmed/Desktop/Verilog/DiamondFET/verilog_a/diamondfet_idvd_ae_w0.txt", "r");
      for(i=0; i<340; i=i+1) count_tmp = $fscanf(fd, "%e", idvd_ae_w0[i]);
      $fclose(fd);
      fd = $fopen("/home/UFAD/tanvir.ahmed/Desktop/Verilog/DiamondFET/verilog_a/diamondfet_idvd_ae_b0.txt", "r");
      for(i=0; i<68; i=i+1) count_tmp = $fscanf(fd, "%e", idvd_ae_b0[i]);
      $fclose(fd);
      fd = $fopen("/home/UFAD/tanvir.ahmed/Desktop/Verilog/DiamondFET/verilog_a/diamondfet_idvd_ae_w1.txt", "r");
      for(i=0; i<18360; i=i+1) count_tmp = $fscanf(fd, "%e", idvd_ae_w1[i]);
      $fclose(fd);
      fd = $fopen("/home/UFAD/tanvir.ahmed/Desktop/Verilog/DiamondFET/verilog_a/diamondfet_idvd_ae_b1.txt", "r");
      for(i=0; i<270; i=i+1) count_tmp = $fscanf(fd, "%e", idvd_ae_b1[i]);
      $fclose(fd);
      fd = $fopen("/home/UFAD/tanvir.ahmed/Desktop/Verilog/DiamondFET/verilog_a/diamondfet_idvd_ae_w2.txt", "r");
      for(i=0; i<145800; i=i+1) count_tmp = $fscanf(fd, "%e", idvd_ae_w2[i]);
      $fclose(fd);
      fd = $fopen("/home/UFAD/tanvir.ahmed/Desktop/Verilog/DiamondFET/verilog_a/diamondfet_idvd_ae_b2.txt", "r");
      for(i=0; i<540; i=i+1) count_tmp = $fscanf(fd, "%e", idvd_ae_b2[i]);
      $fclose(fd);
      fd = $fopen("/home/UFAD/tanvir.ahmed/Desktop/Verilog/DiamondFET/verilog_a/diamondfet_idvd_ae_w3.txt", "r");
      for(i=0; i<583200; i=i+1) count_tmp = $fscanf(fd, "%e", idvd_ae_w3[i]);
      $fclose(fd);
      fd = $fopen("/home/UFAD/tanvir.ahmed/Desktop/Verilog/DiamondFET/verilog_a/diamondfet_idvd_ae_b3.txt", "r");
      for(i=0; i<1080; i=i+1) count_tmp = $fscanf(fd, "%e", idvd_ae_b3[i]);
      $fclose(fd);
      fd = $fopen("/home/UFAD/tanvir.ahmed/Desktop/Verilog/DiamondFET/verilog_a/diamondfet_idvg_poly_w.txt", "r");
      for(i=0; i<3465; i=i+1) count_tmp = $fscanf(fd, "%e", idvg_poly_w[i]);
      $fclose(fd);
      fd = $fopen("/home/UFAD/tanvir.ahmed/Desktop/Verilog/DiamondFET/verilog_a/diamondfet_idvg_poly_b.txt", "r");
      for(i=0; i<7; i=i+1) count_tmp = $fscanf(fd, "%e", idvg_poly_b[i]);
      $fclose(fd);// Automatically generated Verilog-A DiamondFET drain-current model
      `include "constants.vams"
      `include "disciplines.vams"

      module DiamondFET(d, g, s);
        inout d, g, s;
        electrical d, g, s;

        // Geometry parameters follow the ML front-end convention:
        // Lg/Lgs/Tox are provided in nm, Rc in ohm*mm.
        // The backend assumes Lgd = Lgs, so only a single gate-to-contact spacing is exposed.
        parameter real Lg = 400.0;
        parameter real Lgs = 900.0;
        parameter real Tox = 17.0;
        parameter real Rc = 0.90;
        // 0: blended current, 1: Id-Vd surface only, 2: Id-Vg surface only
        parameter integer current_mode = 0;
        parameter real gmin_ds = 1e-12 from [0:inf);
        parameter real vds_sign_delta = 1e-4 from [0:inf);

        real idvd_poly_w[0:3614];
        real idvd_poly_b[0:4];
        real idvd_ae_w0[0:339];
        real idvd_ae_b0[0:67];
        real idvd_ae_w1[0:18359];
        real idvd_ae_b1[0:269];
        real idvd_ae_w2[0:145799];
        real idvd_ae_b2[0:539];
        real idvd_ae_w3[0:583199];
        real idvd_ae_b3[0:1079];
        real idvg_poly_w[0:3464];
        real idvg_poly_b[0:6];
        real idvg_ae_w0[0:1056];
        real idvg_ae_b0[0:150];
        real idvg_ae_w1[0:91052];
        real idvg_ae_b1[0:602];
        real idvg_ae_w2[0:727217];
        real idvg_ae_b2[0:1205];
        real idvg_ae_w3[0:1454435];
        real idvg_ae_b3[0:1205];
        real idvd_sx_mul[0:3];
        real idvd_sx_add[0:3];
        real idvd_sl_mul[0:4];
        real idvd_sl_add[0:4];
        real idvd_siv_mul[0:1079];
        real idvd_siv_add[0:1079];
        real idvg_sx_mul[0:3];
        real idvg_sx_add[0:3];
        real idvg_sl_mul[0:6];
        real idvg_sl_add[0:6];
        real idvg_siv_mul[0:1205];
        real idvg_siv_add[0:1205];

        // Temporary buffers
        real input_x[0:3];
        real idvd_poly_feat[0:722];
        real idvd_z[0:4];
        real idvd_h0[0:67];
        real idvd_h1[0:269];
        real idvd_h2[0:539];
        real idvd_out[0:1079];
        real idvg_poly_feat[0:494];
        real idvg_z[0:6];
        real idvg_h0[0:150];
        real idvg_h1[0:602];
        real idvg_h2[0:1205];
        real idvg_out[0:1205];
        integer i, j, fd, count_tmp;
        integer idvd_vg0_idx, idvd_vg1_idx, idvd_vd0_idx, idvd_vd1_idx;
        integer idvg_vg0_idx, idvg_vg1_idx, idvg_vd0_idx, idvg_vd1_idx;
        real tmp, val_vg, val_vd, vd_mag, sign_vd, res_id_ref;
        real idvd_vg_pos, idvd_vg_frac, idvd_vd_pos, idvd_vd_frac;
        real idvg_vg_pos, idvg_vg_frac, idvg_vd_pos, idvg_vd_frac;
        real idvd_i00, idvd_i01, idvd_i10, idvd_i11, idvd_interp;
        real idvg_i00, idvg_i01, idvg_i10, idvg_i11, idvg_interp;
        real idvd_vg_dist, idvg_vd_dist, idvd_excess, idvg_excess;
        real w_idvd, w_idvg, w_sum;

        analog begin
          @(initial_step) begin
            fd = $fopen("/home/UFAD/tanvir.ahmed/Desktop/Verilog/DiamondFET/verilog_a/diamondfet_idvd_poly_w.txt", "r");
            for(i=0; i<3615; i=i+1) count_tmp = $fscanf(fd, "%e", idvd_poly_w[i]);
            $fclose(fd);
            fd = $fopen("/home/UFAD/tanvir.ahmed/Desktop/Verilog/DiamondFET/verilog_a/diamondfet_idvd_poly_b.txt", "r");
            for(i=0; i<5; i=i+1) count_tmp = $fscanf(fd, "%e", idvd_poly_b[i]);
            $fclose(fd);
            fd = $fopen("/home/UFAD/tanvir.ahmed/Desktop/Verilog/DiamondFET/verilog_a/diamondfet_idvd_ae_w0.txt", "r");
            for(i=0; i<340; i=i+1) count_tmp = $fscanf(fd, "%e", idvd_ae_w0[i]);
            $fclose(fd);
            fd = $fopen("/home/UFAD/tanvir.ahmed/Desktop/Verilog/DiamondFET/verilog_a/diamondfet_idvd_ae_b0.txt", "r");
            for(i=0; i<68; i=i+1) count_tmp = $fscanf(fd, "%e", idvd_ae_b0[i]);
            $fclose(fd);
            fd = $fopen("/home/UFAD/tanvir.ahmed/Desktop/Verilog/DiamondFET/verilog_a/diamondfet_idvd_ae_w1.txt", "r");
            for(i=0; i<18360; i=i+1) count_tmp = $fscanf(fd, "%e", idvd_ae_w1[i]);
            $fclose(fd);
            fd = $fopen("/home/UFAD/tanvir.ahmed/Desktop/Verilog/DiamondFET/verilog_a/diamondfet_idvd_ae_b1.txt", "r");
            for(i=0; i<270; i=i+1) count_tmp = $fscanf(fd, "%e", idvd_ae_b1[i]);
            $fclose(fd);
            fd = $fopen("/home/UFAD/tanvir.ahmed/Desktop/Verilog/DiamondFET/verilog_a/diamondfet_idvd_ae_w2.txt", "r");
            for(i=0; i<145800; i=i+1) count_tmp = $fscanf(fd, "%e", idvd_ae_w2[i]);
            $fclose(fd);
            fd = $fopen("/home/UFAD/tanvir.ahmed/Desktop/Verilog/DiamondFET/verilog_a/diamondfet_idvd_ae_b2.txt", "r");
            for(i=0; i<540; i=i+1) count_tmp = $fscanf(fd, "%e", idvd_ae_b2[i]);
            $fclose(fd);
            fd = $fopen("/home/UFAD/tanvir.ahmed/Desktop/Verilog/DiamondFET/verilog_a/diamondfet_idvd_ae_w3.txt", "r");
            for(i=0; i<583200; i=i+1) count_tmp = $fscanf(fd, "%e", idvd_ae_w3[i]);
            $fclose(fd);
            fd = $fopen("/home/UFAD/tanvir.ahmed/Desktop/Verilog/DiamondFET/verilog_a/diamondfet_idvd_ae_b3.txt", "r");
            for(i=0; i<1080; i=i+1) count_tmp = $fscanf(fd, "%e", idvd_ae_b3[i]);
            $fclose(fd);
            fd = $fopen("/home/UFAD/tanvir.ahmed/Desktop/Verilog/DiamondFET/verilog_a/diamondfet_idvg_poly_w.txt", "r");
            for(i=0; i<3465; i=i+1) count_tmp = $fscanf(fd, "%e", idvg_poly_w[i]);
            $fclose(fd);
            fd = $fopen("/home/UFAD/tanvir.ahmed/Desktop/Verilog/DiamondFET/verilog_a/diamondfet_idvg_poly_b.txt", "r");
            for(i=0; i<7; i=i+1) count_tmp = $fscanf(fd, "%e", idvg_poly_b[i]);
            $fclose(fd);
            fd = $fopen("/home/UFAD/tanvir.ahmed/Desktop/Verilog/DiamondFET/verilog_a/diamondfet_idvg_ae_w0.txt", "r");
            for(i=0; i<1057; i=i+1) count_tmp = $fscanf(fd, "%e", idvg_ae_w0[i]);
            $fclose(fd);
            fd = $fopen("/home/UFAD/tanvir.ahmed/Desktop/Verilog/DiamondFET/verilog_a/diamondfet_idvg_ae_b0.txt", "r");
            for(i=0; i<151; i=i+1) count_tmp = $fscanf(fd, "%e", idvg_ae_b0[i]);
            $fclose(fd);
            fd = $fopen("/home/UFAD/tanvir.ahmed/Desktop/Verilog/DiamondFET/verilog_a/diamondfet_idvg_ae_w1.txt", "r");
            for(i=0; i<91053; i=i+1) count_tmp = $fscanf(fd, "%e", idvg_ae_w1[i]);
            $fclose(fd);
            fd = $fopen("/home/UFAD/tanvir.ahmed/Desktop/Verilog/DiamondFET/verilog_a/diamondfet_idvg_ae_b1.txt", "r");
            for(i=0; i<603; i=i+1) count_tmp = $fscanf(fd, "%e", idvg_ae_b1[i]);
            $fclose(fd);
            fd = $fopen("/home/UFAD/tanvir.ahmed/Desktop/Verilog/DiamondFET/verilog_a/diamondfet_idvg_ae_w2.txt", "r");
            for(i=0; i<727218; i=i+1) count_tmp = $fscanf(fd, "%e", idvg_ae_w2[i]);
            $fclose(fd);
            fd = $fopen("/home/UFAD/tanvir.ahmed/Desktop/Verilog/DiamondFET/verilog_a/diamondfet_idvg_ae_b2.txt", "r");
            for(i=0; i<1206; i=i+1) count_tmp = $fscanf(fd, "%e", idvg_ae_b2[i]);
            $fclose(fd);
            fd = $fopen("/home/UFAD/tanvir.ahmed/Desktop/Verilog/DiamondFET/verilog_a/diamondfet_idvg_ae_w3.txt", "r");
            for(i=0; i<1454436; i=i+1) count_tmp = $fscanf(fd, "%e", idvg_ae_w3[i]);
            $fclose(fd);
            fd = $fopen("/home/UFAD/tanvir.ahmed/Desktop/Verilog/DiamondFET/verilog_a/diamondfet_idvg_ae_b3.txt", "r");
            for(i=0; i<1206; i=i+1) count_tmp = $fscanf(fd, "%e", idvg_ae_b3[i]);
            $fclose(fd);
            fd = $fopen("/home/UFAD/tanvir.ahmed/Desktop/Verilog/DiamondFET/verilog_a/diamondfet_idvd_sx_mul.txt", "r");
            for(i=0; i<4; i=i+1) count_tmp = $fscanf(fd, "%e", idvd_sx_mul[i]);
            $fclose(fd);
            fd = $fopen("/home/UFAD/tanvir.ahmed/Desktop/Verilog/DiamondFET/verilog_a/diamondfet_idvd_sx_add.txt", "r");
            for(i=0; i<4; i=i+1) count_tmp = $fscanf(fd, "%e", idvd_sx_add[i]);
            $fclose(fd);
            fd = $fopen("/home/UFAD/tanvir.ahmed/Desktop/Verilog/DiamondFET/verilog_a/diamondfet_idvd_sl_mul.txt", "r");
            for(i=0; i<5; i=i+1) count_tmp = $fscanf(fd, "%e", idvd_sl_mul[i]);
            $fclose(fd);
            fd = $fopen("/home/UFAD/tanvir.ahmed/Desktop/Verilog/DiamondFET/verilog_a/diamondfet_idvd_sl_add.txt", "r");
            for(i=0; i<5; i=i+1) count_tmp = $fscanf(fd, "%e", idvd_sl_add[i]);
            $fclose(fd);
            fd = $fopen("/home/UFAD/tanvir.ahmed/Desktop/Verilog/DiamondFET/verilog_a/diamondfet_idvd_siv_mul.txt", "r");
            for(i=0; i<1080; i=i+1) count_tmp = $fscanf(fd, "%e", idvd_siv_mul[i]);
            $fclose(fd);
            fd = $fopen("/home/UFAD/tanvir.ahmed/Desktop/Verilog/DiamondFET/verilog_a/diamondfet_idvd_siv_add.txt", "r");
            for(i=0; i<1080; i=i+1) count_tmp = $fscanf(fd, "%e", idvd_siv_add[i]);
            $fclose(fd);
            fd = $fopen("/home/UFAD/tanvir.ahmed/Desktop/Verilog/DiamondFET/verilog_a/diamondfet_idvg_sx_mul.txt", "r");
            for(i=0; i<4; i=i+1) count_tmp = $fscanf(fd, "%e", idvg_sx_mul[i]);
            $fclose(fd);
            fd = $fopen("/home/UFAD/tanvir.ahmed/Desktop/Verilog/DiamondFET/verilog_a/diamondfet_idvg_sx_add.txt", "r");
            for(i=0; i<4; i=i+1) count_tmp = $fscanf(fd, "%e", idvg_sx_add[i]);
            $fclose(fd);
            fd = $fopen("/home/UFAD/tanvir.ahmed/Desktop/Verilog/DiamondFET/verilog_a/diamondfet_idvg_sl_mul.txt", "r");
            for(i=0; i<7; i=i+1) count_tmp = $fscanf(fd, "%e", idvg_sl_mul[i]);
            $fclose(fd);
            fd = $fopen("/home/UFAD/tanvir.ahmed/Desktop/Verilog/DiamondFET/verilog_a/diamondfet_idvg_sl_add.txt", "r");
            for(i=0; i<7; i=i+1) count_tmp = $fscanf(fd, "%e", idvg_sl_add[i]);
            $fclose(fd);
            fd = $fopen("/home/UFAD/tanvir.ahmed/Desktop/Verilog/DiamondFET/verilog_a/diamondfet_idvg_siv_mul.txt", "r");
            for(i=0; i<1206; i=i+1) count_tmp = $fscanf(fd, "%e", idvg_siv_mul[i]);
            $fclose(fd);
            fd = $fopen("/home/UFAD/tanvir.ahmed/Desktop/Verilog/DiamondFET/verilog_a/diamondfet_idvg_siv_add.txt", "r");
            for(i=0; i<1206; i=i+1) count_tmp = $fscanf(fd, "%e", idvg_siv_add[i]);
            $fclose(fd);

            // Convert nm -> um before applying the learned input scalers.
            input_x[0] = (1.0e-3 * Lg) * idvd_sx_mul[0] + idvd_sx_add[0];
            input_x[1] = (1.0e-3 * Lgs) * idvd_sx_mul[1] + idvd_sx_add[1];
            input_x[2] = (1.0e-3 * Tox) * idvd_sx_mul[2] + idvd_sx_add[2];
            input_x[3] = Rc * idvd_sx_mul[3] + idvd_sx_add[3];
            idvd_poly_feat[0] = 1.0;
            idvd_poly_feat[1] = pow(input_x[0], 1);
            idvd_poly_feat[2] = pow(input_x[1], 1);
            idvd_poly_feat[3] = pow(input_x[2], 1);
            idvd_poly_feat[4] = pow(input_x[3], 1);
            idvd_poly_feat[5] = pow(input_x[0], 2);
            idvd_poly_feat[6] = pow(input_x[0], 1) * pow(input_x[1], 1);
            idvd_poly_feat[7] = pow(input_x[0], 1) * pow(input_x[2], 1);
            idvd_poly_feat[8] = pow(input_x[0], 1) * pow(input_x[3], 1);
            idvd_poly_feat[9] = pow(input_x[1], 2);
            idvd_poly_feat[10] = pow(input_x[1], 1) * pow(input_x[2], 1);
            idvd_poly_feat[11] = pow(input_x[1], 1) * pow(input_x[3], 1);
            idvd_poly_feat[12] = pow(input_x[2], 2);
            idvd_poly_feat[13] = pow(input_x[2], 1) * pow(input_x[3], 1);
            idvd_poly_feat[14] = pow(input_x[3], 2);
            idvd_poly_feat[15] = pow(input_x[0], 3);
            idvd_poly_feat[16] = pow(input_x[0], 2) * pow(input_x[1], 1);
            idvd_poly_feat[17] = pow(input_x[0], 2) * pow(input_x[2], 1);
            idvd_poly_feat[18] = pow(input_x[0], 2) * pow(input_x[3], 1);
            idvd_poly_feat[19] = pow(input_x[0], 1) * pow(input_x[1], 2);
            idvd_poly_feat[20] = pow(input_x[0], 1) * pow(input_x[1], 1) * pow(input_x[2], 1);
            idvd_poly_feat[21] = pow(input_x[0], 1) * pow(input_x[1], 1) * pow(input_x[3], 1);
            idvd_poly_feat[22] = pow(input_x[0], 1) * pow(input_x[2], 2);
            idvd_poly_feat[23] = pow(input_x[0], 1) * pow(input_x[2], 1) * pow(input_x[3], 1);
            idvd_poly_feat[24] = pow(input_x[0], 1) * pow(input_x[3], 2);
            idvd_poly_feat[25] = pow(input_x[1], 3);
            idvd_poly_feat[26] = pow(input_x[1], 2) * pow(input_x[2], 1);
            idvd_poly_feat[27] = pow(input_x[1], 2) * pow(input_x[3], 1);
            idvd_poly_feat[28] = pow(input_x[1], 1) * pow(input_x[2], 2);
            idvd_poly_feat[29] = pow(input_x[1], 1) * pow(input_x[2], 1) * pow(input_x[3], 1);
            idvd_poly_feat[30] = pow(input_x[1], 1) * pow(input_x[3], 2);
            idvd_poly_feat[31] = pow(input_x[2], 3);
            idvd_poly_feat[32] = pow(input_x[2], 2) * pow(input_x[3], 1);
            idvd_poly_feat[33] = pow(input_x[2], 1) * pow(input_x[3], 2);
            idvd_poly_feat[34] = pow(input_x[3], 3);
            idvd_poly_feat[35] = pow(input_x[0], 4);
            idvd_poly_feat[36] = pow(input_x[0], 3) * pow(input_x[1], 1);
            idvd_poly_feat[37] = pow(input_x[0], 3) * pow(input_x[2], 1);
            idvd_poly_feat[38] = pow(input_x[0], 3) * pow(input_x[3], 1);
            idvd_poly_feat[39] = pow(input_x[0], 2) * pow(input_x[1], 2);
            idvd_poly_feat[40] = pow(input_x[0], 2) * pow(input_x[1], 1) * pow(input_x[2], 1);
            idvd_poly_feat[41] = pow(input_x[0], 2) * pow(input_x[1], 1) * pow(input_x[3], 1);
            idvd_poly_feat[42] = pow(input_x[0], 2) * pow(input_x[2], 2);
            idvd_poly_feat[43] = pow(input_x[0], 2) * pow(input_x[2], 1) * pow(input_x[3], 1);
            idvd_poly_feat[44] = pow(input_x[0], 2) * pow(input_x[3], 2);
            idvd_poly_feat[45] = pow(input_x[0], 1) * pow(input_x[1], 3);
            idvd_poly_feat[46] = pow(input_x[0], 1) * pow(input_x[1], 2) * pow(input_x[2], 1);
            idvd_poly_feat[47] = pow(input_x[0], 1) * pow(input_x[1], 2) * pow(input_x[3], 1);
            idvd_poly_feat[48] = pow(input_x[0], 1) * pow(input_x[1], 1) * pow(input_x[2], 2);
            idvd_poly_feat[49] = pow(input_x[0], 1) * pow(input_x[1], 1) * pow(input_x[2], 1) * pow(input_x[3], 1);
            idvd_poly_feat[50] = pow(input_x[0], 1) * pow(input_x[1], 1) * pow(input_x[3], 2);
            idvd_poly_feat[51] = pow(input_x[0], 1) * pow(input_x[2], 3);
            idvd_poly_feat[52] = pow(input_x[0], 1) * pow(input_x[2], 2) * pow(input_x[3], 1);
            idvd_poly_feat[53] = pow(input_x[0], 1) * pow(input_x[2], 1) * pow(input_x[3], 2);
            idvd_poly_feat[54] = pow(input_x[0], 1) * pow(input_x[3], 3);
            idvd_poly_feat[55] = pow(input_x[1], 4);
            idvd_poly_feat[56] = pow(input_x[1], 3) * pow(input_x[2], 1);
            idvd_poly_feat[57] = pow(input_x[1], 3) * pow(input_x[3], 1);
            idvd_poly_feat[58] = pow(input_x[1], 2) * pow(input_x[2], 2);
            idvd_poly_feat[59] = pow(input_x[1], 2) * pow(input_x[2], 1) * pow(input_x[3], 1);
            idvd_poly_feat[60] = pow(input_x[1], 2) * pow(input_x[3], 2);
            idvd_poly_feat[61] = pow(input_x[1], 1) * pow(input_x[2], 3);
            idvd_poly_feat[62] = pow(input_x[1], 1) * pow(input_x[2], 2) * pow(input_x[3], 1);
            idvd_poly_feat[63] = pow(input_x[1], 1) * pow(input_x[2], 1) * pow(input_x[3], 2);
            idvd_poly_feat[64] = pow(input_x[1], 1) * pow(input_x[3], 3);
            idvd_poly_feat[65] = pow(input_x[2], 4);
            idvd_poly_feat[66] = pow(input_x[2], 3) * pow(input_x[3], 1);
            idvd_poly_feat[67] = pow(input_x[2], 2) * pow(input_x[3], 2);
            idvd_poly_feat[68] = pow(input_x[2], 1) * pow(input_x[3], 3);
            idvd_poly_feat[69] = pow(input_x[3], 4);
            idvd_poly_feat[70] = pow(input_x[0], 5);
            idvd_poly_feat[71] = pow(input_x[0], 4) * pow(input_x[1], 1);
            idvd_poly_feat[72] = pow(input_x[0], 4) * pow(input_x[2], 1);
            idvd_poly_feat[73] = pow(input_x[0], 4) * pow(input_x[3], 1);
            idvd_poly_feat[74] = pow(input_x[0], 3) * pow(input_x[1], 2);
            idvd_poly_feat[75] = pow(input_x[0], 3) * pow(input_x[1], 1) * pow(input_x[2], 1);
            idvd_poly_feat[76] = pow(input_x[0], 3) * pow(input_x[1], 1) * pow(input_x[3], 1);
            idvd_poly_feat[77] = pow(input_x[0], 3) * pow(input_x[2], 2);
            idvd_poly_feat[78] = pow(input_x[0], 3) * pow(input_x[2], 1) * pow(input_x[3], 1);
            idvd_poly_feat[79] = pow(input_x[0], 3) * pow(input_x[3], 2);
            idvd_poly_feat[80] = pow(input_x[0], 2) * pow(input_x[1], 3);
            idvd_poly_feat[81] = pow(input_x[0], 2) * pow(input_x[1], 2) * pow(input_x[2], 1);
            idvd_poly_feat[82] = pow(input_x[0], 2) * pow(input_x[1], 2) * pow(input_x[3], 1);
            idvd_poly_feat[83] = pow(input_x[0], 2) * pow(input_x[1], 1) * pow(input_x[2], 2);
            idvd_poly_feat[84] = pow(input_x[0], 2) * pow(input_x[1], 1) * pow(input_x[2], 1) * pow(input_x[3], 1);
            idvd_poly_feat[85] = pow(input_x[0], 2) * pow(input_x[1], 1) * pow(input_x[3], 2);
            idvd_poly_feat[86] = pow(input_x[0], 2) * pow(input_x[2], 3);
            idvd_poly_feat[87] = pow(input_x[0], 2) * pow(input_x[2], 2) * pow(input_x[3], 1);
            idvd_poly_feat[88] = pow(input_x[0], 2) * pow(input_x[2], 1) * pow(input_x[3], 2);
            idvd_poly_feat[89] = pow(input_x[0], 2) * pow(input_x[3], 3);
            idvd_poly_feat[90] = pow(input_x[0], 1) * pow(input_x[1], 4);
            idvd_poly_feat[91] = pow(input_x[0], 1) * pow(input_x[1], 3) * pow(input_x[2], 1);
            idvd_poly_feat[92] = pow(input_x[0], 1) * pow(input_x[1], 3) * pow(input_x[3], 1);
            idvd_poly_feat[93] = pow(input_x[0], 1) * pow(input_x[1], 2) * pow(input_x[2], 2);
            idvd_poly_feat[94] = pow(input_x[0], 1) * pow(input_x[1], 2) * pow(input_x[2], 1) * pow(input_x[3], 1);
            idvd_poly_feat[95] = pow(input_x[0], 1) * pow(input_x[1], 2) * pow(input_x[3], 2);
            idvd_poly_feat[96] = pow(input_x[0], 1) * pow(input_x[1], 1) * pow(input_x[2], 3);
            idvd_poly_feat[97] = pow(input_x[0], 1) * pow(input_x[1], 1) * pow(input_x[2], 2) * pow(input_x[3], 1);
            idvd_poly_feat[98] = pow(input_x[0], 1) * pow(input_x[1], 1) * pow(input_x[2], 1) * pow(input_x[3], 2);
            idvd_poly_feat[99] = pow(input_x[0], 1) * pow(input_x[1], 1) * pow(input_x[3], 3);
            idvd_poly_feat[100] = pow(input_x[0], 1) * pow(input_x[2], 4);
            idvd_poly_feat[101] = pow(input_x[0], 1) * pow(input_x[2], 3) * pow(input_x[3], 1);
            idvd_poly_feat[102] = pow(input_x[0], 1) * pow(input_x[2], 2) * pow(input_x[3], 2);
            idvd_poly_feat[103] = pow(input_x[0], 1) * pow(input_x[2], 1) * pow(input_x[3], 3);
            idvd_poly_feat[104] = pow(input_x[0], 1) * pow(input_x[3], 4);
            idvd_poly_feat[105] = pow(input_x[1], 5);
            idvd_poly_feat[106] = pow(input_x[1], 4) * pow(input_x[2], 1);
            idvd_poly_feat[107] = pow(input_x[1], 4) * pow(input_x[3], 1);
            idvd_poly_feat[108] = pow(input_x[1], 3) * pow(input_x[2], 2);
            idvd_poly_feat[109] = pow(input_x[1], 3) * pow(input_x[2], 1) * pow(input_x[3], 1);
            idvd_poly_feat[110] = pow(input_x[1], 3) * pow(input_x[3], 2);
            idvd_poly_feat[111] = pow(input_x[1], 2) * pow(input_x[2], 3);
            idvd_poly_feat[112] = pow(input_x[1], 2) * pow(input_x[2], 2) * pow(input_x[3], 1);
            idvd_poly_feat[113] = pow(input_x[1], 2) * pow(input_x[2], 1) * pow(input_x[3], 2);
            idvd_poly_feat[114] = pow(input_x[1], 2) * pow(input_x[3], 3);
            idvd_poly_feat[115] = pow(input_x[1], 1) * pow(input_x[2], 4);
            idvd_poly_feat[116] = pow(input_x[1], 1) * pow(input_x[2], 3) * pow(input_x[3], 1);
            idvd_poly_feat[117] = pow(input_x[1], 1) * pow(input_x[2], 2) * pow(input_x[3], 2);
            idvd_poly_feat[118] = pow(input_x[1], 1) * pow(input_x[2], 1) * pow(input_x[3], 3);
            idvd_poly_feat[119] = pow(input_x[1], 1) * pow(input_x[3], 4);
            idvd_poly_feat[120] = pow(input_x[2], 5);
            idvd_poly_feat[121] = pow(input_x[2], 4) * pow(input_x[3], 1);
            idvd_poly_feat[122] = pow(input_x[2], 3) * pow(input_x[3], 2);
            idvd_poly_feat[123] = pow(input_x[2], 2) * pow(input_x[3], 3);
            idvd_poly_feat[124] = pow(input_x[2], 1) * pow(input_x[3], 4);
            idvd_poly_feat[125] = pow(input_x[3], 5);
            idvd_poly_feat[126] = pow(input_x[0], 6);
            idvd_poly_feat[127] = pow(input_x[0], 5) * pow(input_x[1], 1);
            idvd_poly_feat[128] = pow(input_x[0], 5) * pow(input_x[2], 1);
            idvd_poly_feat[129] = pow(input_x[0], 5) * pow(input_x[3], 1);
            idvd_poly_feat[130] = pow(input_x[0], 4) * pow(input_x[1], 2);
            idvd_poly_feat[131] = pow(input_x[0], 4) * pow(input_x[1], 1) * pow(input_x[2], 1);
            idvd_poly_feat[132] = pow(input_x[0], 4) * pow(input_x[1], 1) * pow(input_x[3], 1);
            idvd_poly_feat[133] = pow(input_x[0], 4) * pow(input_x[2], 2);
            idvd_poly_feat[134] = pow(input_x[0], 4) * pow(input_x[2], 1) * pow(input_x[3], 1);
            idvd_poly_feat[135] = pow(input_x[0], 4) * pow(input_x[3], 2);
            idvd_poly_feat[136] = pow(input_x[0], 3) * pow(input_x[1], 3);
            idvd_poly_feat[137] = pow(input_x[0], 3) * pow(input_x[1], 2) * pow(input_x[2], 1);
            idvd_poly_feat[138] = pow(input_x[0], 3) * pow(input_x[1], 2) * pow(input_x[3], 1);
            idvd_poly_feat[139] = pow(input_x[0], 3) * pow(input_x[1], 1) * pow(input_x[2], 2);
            idvd_poly_feat[140] = pow(input_x[0], 3) * pow(input_x[1], 1) * pow(input_x[2], 1) * pow(input_x[3], 1);
            idvd_poly_feat[141] = pow(input_x[0], 3) * pow(input_x[1], 1) * pow(input_x[3], 2);
            idvd_poly_feat[142] = pow(input_x[0], 3) * pow(input_x[2], 3);
            idvd_poly_feat[143] = pow(input_x[0], 3) * pow(input_x[2], 2) * pow(input_x[3], 1);
            idvd_poly_feat[144] = pow(input_x[0], 3) * pow(input_x[2], 1) * pow(input_x[3], 2);
            idvd_poly_feat[145] = pow(input_x[0], 3) * pow(input_x[3], 3);
            idvd_poly_feat[146] = pow(input_x[0], 2) * pow(input_x[1], 4);
            idvd_poly_feat[147] = pow(input_x[0], 2) * pow(input_x[1], 3) * pow(input_x[2], 1);
            idvd_poly_feat[148] = pow(input_x[0], 2) * pow(input_x[1], 3) * pow(input_x[3], 1);
            idvd_poly_feat[149] = pow(input_x[0], 2) * pow(input_x[1], 2) * pow(input_x[2], 2);
            idvd_poly_feat[150] = pow(input_x[0], 2) * pow(input_x[1], 2) * pow(input_x[2], 1) * pow(input_x[3], 1);
            idvd_poly_feat[151] = pow(input_x[0], 2) * pow(input_x[1], 2) * pow(input_x[3], 2);
            idvd_poly_feat[152] = pow(input_x[0], 2) * pow(input_x[1], 1) * pow(input_x[2], 3);
            idvd_poly_feat[153] = pow(input_x[0], 2) * pow(input_x[1], 1) * pow(input_x[2], 2) * pow(input_x[3], 1);
            idvd_poly_feat[154] = pow(input_x[0], 2) * pow(input_x[1], 1) * pow(input_x[2], 1) * pow(input_x[3], 2);
            idvd_poly_feat[155] = pow(input_x[0], 2) * pow(input_x[1], 1) * pow(input_x[3], 3);
            idvd_poly_feat[156] = pow(input_x[0], 2) * pow(input_x[2], 4);
            idvd_poly_feat[157] = pow(input_x[0], 2) * pow(input_x[2], 3) * pow(input_x[3], 1);
            idvd_poly_feat[158] = pow(input_x[0], 2) * pow(input_x[2], 2) * pow(input_x[3], 2);
            idvd_poly_feat[159] = pow(input_x[0], 2) * pow(input_x[2], 1) * pow(input_x[3], 3);
            idvd_poly_feat[160] = pow(input_x[0], 2) * pow(input_x[3], 4);
            idvd_poly_feat[161] = pow(input_x[0], 1) * pow(input_x[1], 5);
            idvd_poly_feat[162] = pow(input_x[0], 1) * pow(input_x[1], 4) * pow(input_x[2], 1);
            idvd_poly_feat[163] = pow(input_x[0], 1) * pow(input_x[1], 4) * pow(input_x[3], 1);
            idvd_poly_feat[164] = pow(input_x[0], 1) * pow(input_x[1], 3) * pow(input_x[2], 2);
            idvd_poly_feat[165] = pow(input_x[0], 1) * pow(input_x[1], 3) * pow(input_x[2], 1) * pow(input_x[3], 1);
            idvd_poly_feat[166] = pow(input_x[0], 1) * pow(input_x[1], 3) * pow(input_x[3], 2);
            idvd_poly_feat[167] = pow(input_x[0], 1) * pow(input_x[1], 2) * pow(input_x[2], 3);
            idvd_poly_feat[168] = pow(input_x[0], 1) * pow(input_x[1], 2) * pow(input_x[2], 2) * pow(input_x[3], 1);
            idvd_poly_feat[169] = pow(input_x[0], 1) * pow(input_x[1], 2) * pow(input_x[2], 1) * pow(input_x[3], 2);
            idvd_poly_feat[170] = pow(input_x[0], 1) * pow(input_x[1], 2) * pow(input_x[3], 3);
            idvd_poly_feat[171] = pow(input_x[0], 1) * pow(input_x[1], 1) * pow(input_x[2], 4);
            idvd_poly_feat[172] = pow(input_x[0], 1) * pow(input_x[1], 1) * pow(input_x[2], 3) * pow(input_x[3], 1);
            idvd_poly_feat[173] = pow(input_x[0], 1) * pow(input_x[1], 1) * pow(input_x[2], 2) * pow(input_x[3], 2);
            idvd_poly_feat[174] = pow(input_x[0], 1) * pow(input_x[1], 1) * pow(input_x[2], 1) * pow(input_x[3], 3);
            idvd_poly_feat[175] = pow(input_x[0], 1) * pow(input_x[1], 1) * pow(input_x[3], 4);
            idvd_poly_feat[176] = pow(input_x[0], 1) * pow(input_x[2], 5);
            idvd_poly_feat[177] = pow(input_x[0], 1) * pow(input_x[2], 4) * pow(input_x[3], 1);
            idvd_poly_feat[178] = pow(input_x[0], 1) * pow(input_x[2], 3) * pow(input_x[3], 2);
            idvd_poly_feat[179] = pow(input_x[0], 1) * pow(input_x[2], 2) * pow(input_x[3], 3);
            idvd_poly_feat[180] = pow(input_x[0], 1) * pow(input_x[2], 1) * pow(input_x[3], 4);
            idvd_poly_feat[181] = pow(input_x[0], 1) * pow(input_x[3], 5);
            idvd_poly_feat[182] = pow(input_x[1], 6);
            idvd_poly_feat[183] = pow(input_x[1], 5) * pow(input_x[2], 1);
            idvd_poly_feat[184] = pow(input_x[1], 5) * pow(input_x[3], 1);
            idvd_poly_feat[185] = pow(input_x[1], 4) * pow(input_x[2], 2);
            idvd_poly_feat[186] = pow(input_x[1], 4) * pow(input_x[2], 1) * pow(input_x[3], 1);
            idvd_poly_feat[187] = pow(input_x[1], 4) * pow(input_x[3], 2);
            idvd_poly_feat[188] = pow(input_x[1], 3) * pow(input_x[2], 3);
            idvd_poly_feat[189] = pow(input_x[1], 3) * pow(input_x[2], 2) * pow(input_x[3], 1);
            idvd_poly_feat[190] = pow(input_x[1], 3) * pow(input_x[2], 1) * pow(input_x[3], 2);
            idvd_poly_feat[191] = pow(input_x[1], 3) * pow(input_x[3], 3);
            idvd_poly_feat[192] = pow(input_x[1], 2) * pow(input_x[2], 4);
            idvd_poly_feat[193] = pow(input_x[1], 2) * pow(input_x[2], 3) * pow(input_x[3], 1);
            idvd_poly_feat[194] = pow(input_x[1], 2) * pow(input_x[2], 2) * pow(input_x[3], 2);
            idvd_poly_feat[195] = pow(input_x[1], 2) * pow(input_x[2], 1) * pow(input_x[3], 3);
            idvd_poly_feat[196] = pow(input_x[1], 2) * pow(input_x[3], 4);
            idvd_poly_feat[197] = pow(input_x[1], 1) * pow(input_x[2], 5);
            idvd_poly_feat[198] = pow(input_x[1], 1) * pow(input_x[2], 4) * pow(input_x[3], 1);
            idvd_poly_feat[199] = pow(input_x[1], 1) * pow(input_x[2], 3) * pow(input_x[3], 2);
            idvd_poly_feat[200] = pow(input_x[1], 1) * pow(input_x[2], 2) * pow(input_x[3], 3);
            idvd_poly_feat[201] = pow(input_x[1], 1) * pow(input_x[2], 1) * pow(input_x[3], 4);
            idvd_poly_feat[202] = pow(input_x[1], 1) * pow(input_x[3], 5);
            idvd_poly_feat[203] = pow(input_x[2], 6);
            idvd_poly_feat[204] = pow(input_x[2], 5) * pow(input_x[3], 1);
            idvd_poly_feat[205] = pow(input_x[2], 4) * pow(input_x[3], 2);
            idvd_poly_feat[206] = pow(input_x[2], 3) * pow(input_x[3], 3);
            idvd_poly_feat[207] = pow(input_x[2], 2) * pow(input_x[3], 4);
            idvd_poly_feat[208] = pow(input_x[2], 1) * pow(input_x[3], 5);
            idvd_poly_feat[209] = pow(input_x[3], 6);
            idvd_poly_feat[210] = pow(input_x[0], 7);
            idvd_poly_feat[211] = pow(input_x[0], 6) * pow(input_x[1], 1);
            idvd_poly_feat[212] = pow(input_x[0], 6) * pow(input_x[2], 1);
            idvd_poly_feat[213] = pow(input_x[0], 6) * pow(input_x[3], 1);
            idvd_poly_feat[214] = pow(input_x[0], 5) * pow(input_x[1], 2);
            idvd_poly_feat[215] = pow(input_x[0], 5) * pow(input_x[1], 1) * pow(input_x[2], 1);
            idvd_poly_feat[216] = pow(input_x[0], 5) * pow(input_x[1], 1) * pow(input_x[3], 1);
            idvd_poly_feat[217] = pow(input_x[0], 5) * pow(input_x[2], 2);
            idvd_poly_feat[218] = pow(input_x[0], 5) * pow(input_x[2], 1) * pow(input_x[3], 1);
            idvd_poly_feat[219] = pow(input_x[0], 5) * pow(input_x[3], 2);
            idvd_poly_feat[220] = pow(input_x[0], 4) * pow(input_x[1], 3);
            idvd_poly_feat[221] = pow(input_x[0], 4) * pow(input_x[1], 2) * pow(input_x[2], 1);
            idvd_poly_feat[222] = pow(input_x[0], 4) * pow(input_x[1], 2) * pow(input_x[3], 1);
            idvd_poly_feat[223] = pow(input_x[0], 4) * pow(input_x[1], 1) * pow(input_x[2], 2);
            idvd_poly_feat[224] = pow(input_x[0], 4) * pow(input_x[1], 1) * pow(input_x[2], 1) * pow(input_x[3], 1);
            idvd_poly_feat[225] = pow(input_x[0], 4) * pow(input_x[1], 1) * pow(input_x[3], 2);
            idvd_poly_feat[226] = pow(input_x[0], 4) * pow(input_x[2], 3);
            idvd_poly_feat[227] = pow(input_x[0], 4) * pow(input_x[2], 2) * pow(input_x[3], 1);
            idvd_poly_feat[228] = pow(input_x[0], 4) * pow(input_x[2], 1) * pow(input_x[3], 2);
            idvd_poly_feat[229] = pow(input_x[0], 4) * pow(input_x[3], 3);
            idvd_poly_feat[230] = pow(input_x[0], 3) * pow(input_x[1], 4);
            idvd_poly_feat[231] = pow(input_x[0], 3) * pow(input_x[1], 3) * pow(input_x[2], 1);
            idvd_poly_feat[232] = pow(input_x[0], 3) * pow(input_x[1], 3) * pow(input_x[3], 1);
            idvd_poly_feat[233] = pow(input_x[0], 3) * pow(input_x[1], 2) * pow(input_x[2], 2);
            idvd_poly_feat[234] = pow(input_x[0], 3) * pow(input_x[1], 2) * pow(input_x[2], 1) * pow(input_x[3], 1);
            idvd_poly_feat[235] = pow(input_x[0], 3) * pow(input_x[1], 2) * pow(input_x[3], 2);
            idvd_poly_feat[236] = pow(input_x[0], 3) * pow(input_x[1], 1) * pow(input_x[2], 3);
            idvd_poly_feat[237] = pow(input_x[0], 3) * pow(input_x[1], 1) * pow(input_x[2], 2) * pow(input_x[3], 1);
            idvd_poly_feat[238] = pow(input_x[0], 3) * pow(input_x[1], 1) * pow(input_x[2], 1) * pow(input_x[3], 2);
            idvd_poly_feat[239] = pow(input_x[0], 3) * pow(input_x[1], 1) * pow(input_x[3], 3);
            idvd_poly_feat[240] = pow(input_x[0], 3) * pow(input_x[2], 4);
            idvd_poly_feat[241] = pow(input_x[0], 3) * pow(input_x[2], 3) * pow(input_x[3], 1);
            idvd_poly_feat[242] = pow(input_x[0], 3) * pow(input_x[2], 2) * pow(input_x[3], 2);
            idvd_poly_feat[243] = pow(input_x[0], 3) * pow(input_x[2], 1) * pow(input_x[3], 3);
            idvd_poly_feat[244] = pow(input_x[0], 3) * pow(input_x[3], 4);
            idvd_poly_feat[245] = pow(input_x[0], 2) * pow(input_x[1], 5);
            idvd_poly_feat[246] = pow(input_x[0], 2) * pow(input_x[1], 4) * pow(input_x[2], 1);
            idvd_poly_feat[247] = pow(input_x[0], 2) * pow(input_x[1], 4) * pow(input_x[3], 1);
            idvd_poly_feat[248] = pow(input_x[0], 2) * pow(input_x[1], 3) * pow(input_x[2], 2);
            idvd_poly_feat[249] = pow(input_x[0], 2) * pow(input_x[1], 3) * pow(input_x[2], 1) * pow(input_x[3], 1);
            idvd_poly_feat[250] = pow(input_x[0], 2) * pow(input_x[1], 3) * pow(input_x[3], 2);
            idvd_poly_feat[251] = pow(input_x[0], 2) * pow(input_x[1], 2) * pow(input_x[2], 3);
            idvd_poly_feat[252] = pow(input_x[0], 2) * pow(input_x[1], 2) * pow(input_x[2], 2) * pow(input_x[3], 1);
            idvd_poly_feat[253] = pow(input_x[0], 2) * pow(input_x[1], 2) * pow(input_x[2], 1) * pow(input_x[3], 2);
            idvd_poly_feat[254] = pow(input_x[0], 2) * pow(input_x[1], 2) * pow(input_x[3], 3);
            idvd_poly_feat[255] = pow(input_x[0], 2) * pow(input_x[1], 1) * pow(input_x[2], 4);
            idvd_poly_feat[256] = pow(input_x[0], 2) * pow(input_x[1], 1) * pow(input_x[2], 3) * pow(input_x[3], 1);
            idvd_poly_feat[257] = pow(input_x[0], 2) * pow(input_x[1], 1) * pow(input_x[2], 2) * pow(input_x[3], 2);
            idvd_poly_feat[258] = pow(input_x[0], 2) * pow(input_x[1], 1) * pow(input_x[2], 1) * pow(input_x[3], 3);
            idvd_poly_feat[259] = pow(input_x[0], 2) * pow(input_x[1], 1) * pow(input_x[3], 4);
            idvd_poly_feat[260] = pow(input_x[0], 2) * pow(input_x[2], 5);
            idvd_poly_feat[261] = pow(input_x[0], 2) * pow(input_x[2], 4) * pow(input_x[3], 1);
            idvd_poly_feat[262] = pow(input_x[0], 2) * pow(input_x[2], 3) * pow(input_x[3], 2);
            idvd_poly_feat[263] = pow(input_x[0], 2) * pow(input_x[2], 2) * pow(input_x[3], 3);
            idvd_poly_feat[264] = pow(input_x[0], 2) * pow(input_x[2], 1) * pow(input_x[3], 4);
            idvd_poly_feat[265] = pow(input_x[0], 2) * pow(input_x[3], 5);
            idvd_poly_feat[266] = pow(input_x[0], 1) * pow(input_x[1], 6);
            idvd_poly_feat[267] = pow(input_x[0], 1) * pow(input_x[1], 5) * pow(input_x[2], 1);
            idvd_poly_feat[268] = pow(input_x[0], 1) * pow(input_x[1], 5) * pow(input_x[3], 1);
            idvd_poly_feat[269] = pow(input_x[0], 1) * pow(input_x[1], 4) * pow(input_x[2], 2);
            idvd_poly_feat[270] = pow(input_x[0], 1) * pow(input_x[1], 4) * pow(input_x[2], 1) * pow(input_x[3], 1);
            idvd_poly_feat[271] = pow(input_x[0], 1) * pow(input_x[1], 4) * pow(input_x[3], 2);
            idvd_poly_feat[272] = pow(input_x[0], 1) * pow(input_x[1], 3) * pow(input_x[2], 3);
            idvd_poly_feat[273] = pow(input_x[0], 1) * pow(input_x[1], 3) * pow(input_x[2], 2) * pow(input_x[3], 1);
            idvd_poly_feat[274] = pow(input_x[0], 1) * pow(input_x[1], 3) * pow(input_x[2], 1) * pow(input_x[3], 2);
            idvd_poly_feat[275] = pow(input_x[0], 1) * pow(input_x[1], 3) * pow(input_x[3], 3);
            idvd_poly_feat[276] = pow(input_x[0], 1) * pow(input_x[1], 2) * pow(input_x[2], 4);
            idvd_poly_feat[277] = pow(input_x[0], 1) * pow(input_x[1], 2) * pow(input_x[2], 3) * pow(input_x[3], 1);
            idvd_poly_feat[278] = pow(input_x[0], 1) * pow(input_x[1], 2) * pow(input_x[2], 2) * pow(input_x[3], 2);
            idvd_poly_feat[279] = pow(input_x[0], 1) * pow(input_x[1], 2) * pow(input_x[2], 1) * pow(input_x[3], 3);
            idvd_poly_feat[280] = pow(input_x[0], 1) * pow(input_x[1], 2) * pow(input_x[3], 4);
            idvd_poly_feat[281] = pow(input_x[0], 1) * pow(input_x[1], 1) * pow(input_x[2], 5);
            idvd_poly_feat[282] = pow(input_x[0], 1) * pow(input_x[1], 1) * pow(input_x[2], 4) * pow(input_x[3], 1);
            idvd_poly_feat[283] = pow(input_x[0], 1) * pow(input_x[1], 1) * pow(input_x[2], 3) * pow(input_x[3], 2);
            idvd_poly_feat[284] = pow(input_x[0], 1) * pow(input_x[1], 1) * pow(input_x[2], 2) * pow(input_x[3], 3);
            idvd_poly_feat[285] = pow(input_x[0], 1) * pow(input_x[1], 1) * pow(input_x[2], 1) * pow(input_x[3], 4);
            idvd_poly_feat[286] = pow(input_x[0], 1) * pow(input_x[1], 1) * pow(input_x[3], 5);
            idvd_poly_feat[287] = pow(input_x[0], 1) * pow(input_x[2], 6);
            idvd_poly_feat[288] = pow(input_x[0], 1) * pow(input_x[2], 5) * pow(input_x[3], 1);
            idvd_poly_feat[289] = pow(input_x[0], 1) * pow(input_x[2], 4) * pow(input_x[3], 2);
            idvd_poly_feat[290] = pow(input_x[0], 1) * pow(input_x[2], 3) * pow(input_x[3], 3);
            idvd_poly_feat[291] = pow(input_x[0], 1) * pow(input_x[2], 2) * pow(input_x[3], 4);
            idvd_poly_feat[292] = pow(input_x[0], 1) * pow(input_x[2], 1) * pow(input_x[3], 5);
            idvd_poly_feat[293] = pow(input_x[0], 1) * pow(input_x[3], 6);
            idvd_poly_feat[294] = pow(input_x[1], 7);
            idvd_poly_feat[295] = pow(input_x[1], 6) * pow(input_x[2], 1);
            idvd_poly_feat[296] = pow(input_x[1], 6) * pow(input_x[3], 1);
            idvd_poly_feat[297] = pow(input_x[1], 5) * pow(input_x[2], 2);
            idvd_poly_feat[298] = pow(input_x[1], 5) * pow(input_x[2], 1) * pow(input_x[3], 1);
            idvd_poly_feat[299] = pow(input_x[1], 5) * pow(input_x[3], 2);
            idvd_poly_feat[300] = pow(input_x[1], 4) * pow(input_x[2], 3);
            idvd_poly_feat[301] = pow(input_x[1], 4) * pow(input_x[2], 2) * pow(input_x[3], 1);
            idvd_poly_feat[302] = pow(input_x[1], 4) * pow(input_x[2], 1) * pow(input_x[3], 2);
            idvd_poly_feat[303] = pow(input_x[1], 4) * pow(input_x[3], 3);
            idvd_poly_feat[304] = pow(input_x[1], 3) * pow(input_x[2], 4);
            idvd_poly_feat[305] = pow(input_x[1], 3) * pow(input_x[2], 3) * pow(input_x[3], 1);
            idvd_poly_feat[306] = pow(input_x[1], 3) * pow(input_x[2], 2) * pow(input_x[3], 2);
            idvd_poly_feat[307] = pow(input_x[1], 3) * pow(input_x[2], 1) * pow(input_x[3], 3);
            idvd_poly_feat[308] = pow(input_x[1], 3) * pow(input_x[3], 4);
            idvd_poly_feat[309] = pow(input_x[1], 2) * pow(input_x[2], 5);
            idvd_poly_feat[310] = pow(input_x[1], 2) * pow(input_x[2], 4) * pow(input_x[3], 1);
            idvd_poly_feat[311] = pow(input_x[1], 2) * pow(input_x[2], 3) * pow(input_x[3], 2);
            idvd_poly_feat[312] = pow(input_x[1], 2) * pow(input_x[2], 2) * pow(input_x[3], 3);
            idvd_poly_feat[313] = pow(input_x[1], 2) * pow(input_x[2], 1) * pow(input_x[3], 4);
            idvd_poly_feat[314] = pow(input_x[1], 2) * pow(input_x[3], 5);
            idvd_poly_feat[315] = pow(input_x[1], 1) * pow(input_x[2], 6);
            idvd_poly_feat[316] = pow(input_x[1], 1) * pow(input_x[2], 5) * pow(input_x[3], 1);
            idvd_poly_feat[317] = pow(input_x[1], 1) * pow(input_x[2], 4) * pow(input_x[3], 2);
            idvd_poly_feat[318] = pow(input_x[1], 1) * pow(input_x[2], 3) * pow(input_x[3], 3);
            idvd_poly_feat[319] = pow(input_x[1], 1) * pow(input_x[2], 2) * pow(input_x[3], 4);
            idvd_poly_feat[320] = pow(input_x[1], 1) * pow(input_x[2], 1) * pow(input_x[3], 5);
            idvd_poly_feat[321] = pow(input_x[1], 1) * pow(input_x[3], 6);
            idvd_poly_feat[322] = pow(input_x[2], 7);
            idvd_poly_feat[323] = pow(input_x[2], 6) * pow(input_x[3], 1);
            idvd_poly_feat[324] = pow(input_x[2], 5) * pow(input_x[3], 2);
            idvd_poly_feat[325] = pow(input_x[2], 4) * pow(input_x[3], 3);
            idvd_poly_feat[326] = pow(input_x[2], 3) * pow(input_x[3], 4);
            idvd_poly_feat[327] = pow(input_x[2], 2) * pow(input_x[3], 5);
            idvd_poly_feat[328] = pow(input_x[2], 1) * pow(input_x[3], 6);
            idvd_poly_feat[329] = pow(input_x[3], 7);
            idvd_poly_feat[330] = pow(input_x[0], 8);
            idvd_poly_feat[331] = pow(input_x[0], 7) * pow(input_x[1], 1);
            idvd_poly_feat[332] = pow(input_x[0], 7) * pow(input_x[2], 1);
            idvd_poly_feat[333] = pow(input_x[0], 7) * pow(input_x[3], 1);
            idvd_poly_feat[334] = pow(input_x[0], 6) * pow(input_x[1], 2);
            idvd_poly_feat[335] = pow(input_x[0], 6) * pow(input_x[1], 1) * pow(input_x[2], 1);
            idvd_poly_feat[336] = pow(input_x[0], 6) * pow(input_x[1], 1) * pow(input_x[3], 1);
            idvd_poly_feat[337] = pow(input_x[0], 6) * pow(input_x[2], 2);
            idvd_poly_feat[338] = pow(input_x[0], 6) * pow(input_x[2], 1) * pow(input_x[3], 1);
            idvd_poly_feat[339] = pow(input_x[0], 6) * pow(input_x[3], 2);
            idvd_poly_feat[340] = pow(input_x[0], 5) * pow(input_x[1], 3);
            idvd_poly_feat[341] = pow(input_x[0], 5) * pow(input_x[1], 2) * pow(input_x[2], 1);
            idvd_poly_feat[342] = pow(input_x[0], 5) * pow(input_x[1], 2) * pow(input_x[3], 1);
            idvd_poly_feat[343] = pow(input_x[0], 5) * pow(input_x[1], 1) * pow(input_x[2], 2);
            idvd_poly_feat[344] = pow(input_x[0], 5) * pow(input_x[1], 1) * pow(input_x[2], 1) * pow(input_x[3], 1);
            idvd_poly_feat[345] = pow(input_x[0], 5) * pow(input_x[1], 1) * pow(input_x[3], 2);
            idvd_poly_feat[346] = pow(input_x[0], 5) * pow(input_x[2], 3);
            idvd_poly_feat[347] = pow(input_x[0], 5) * pow(input_x[2], 2) * pow(input_x[3], 1);
            idvd_poly_feat[348] = pow(input_x[0], 5) * pow(input_x[2], 1) * pow(input_x[3], 2);
            idvd_poly_feat[349] = pow(input_x[0], 5) * pow(input_x[3], 3);
            idvd_poly_feat[350] = pow(input_x[0], 4) * pow(input_x[1], 4);
            idvd_poly_feat[351] = pow(input_x[0], 4) * pow(input_x[1], 3) * pow(input_x[2], 1);
            idvd_poly_feat[352] = pow(input_x[0], 4) * pow(input_x[1], 3) * pow(input_x[3], 1);
            idvd_poly_feat[353] = pow(input_x[0], 4) * pow(input_x[1], 2) * pow(input_x[2], 2);
            idvd_poly_feat[354] = pow(input_x[0], 4) * pow(input_x[1], 2) * pow(input_x[2], 1) * pow(input_x[3], 1);
            idvd_poly_feat[355] = pow(input_x[0], 4) * pow(input_x[1], 2) * pow(input_x[3], 2);
            idvd_poly_feat[356] = pow(input_x[0], 4) * pow(input_x[1], 1) * pow(input_x[2], 3);
            idvd_poly_feat[357] = pow(input_x[0], 4) * pow(input_x[1], 1) * pow(input_x[2], 2) * pow(input_x[3], 1);
            idvd_poly_feat[358] = pow(input_x[0], 4) * pow(input_x[1], 1) * pow(input_x[2], 1) * pow(input_x[3], 2);
            idvd_poly_feat[359] = pow(input_x[0], 4) * pow(input_x[1], 1) * pow(input_x[3], 3);
            idvd_poly_feat[360] = pow(input_x[0], 4) * pow(input_x[2], 4);
            idvd_poly_feat[361] = pow(input_x[0], 4) * pow(input_x[2], 3) * pow(input_x[3], 1);
            idvd_poly_feat[362] = pow(input_x[0], 4) * pow(input_x[2], 2) * pow(input_x[3], 2);
            idvd_poly_feat[363] = pow(input_x[0], 4) * pow(input_x[2], 1) * pow(input_x[3], 3);
            idvd_poly_feat[364] = pow(input_x[0], 4) * pow(input_x[3], 4);
            idvd_poly_feat[365] = pow(input_x[0], 3) * pow(input_x[1], 5);
            idvd_poly_feat[366] = pow(input_x[0], 3) * pow(input_x[1], 4) * pow(input_x[2], 1);
            idvd_poly_feat[367] = pow(input_x[0], 3) * pow(input_x[1], 4) * pow(input_x[3], 1);
            idvd_poly_feat[368] = pow(input_x[0], 3) * pow(input_x[1], 3) * pow(input_x[2], 2);
            idvd_poly_feat[369] = pow(input_x[0], 3) * pow(input_x[1], 3) * pow(input_x[2], 1) * pow(input_x[3], 1);
            idvd_poly_feat[370] = pow(input_x[0], 3) * pow(input_x[1], 3) * pow(input_x[3], 2);
            idvd_poly_feat[371] = pow(input_x[0], 3) * pow(input_x[1], 2) * pow(input_x[2], 3);
            idvd_poly_feat[372] = pow(input_x[0], 3) * pow(input_x[1], 2) * pow(input_x[2], 2) * pow(input_x[3], 1);
            idvd_poly_feat[373] = pow(input_x[0], 3) * pow(input_x[1], 2) * pow(input_x[2], 1) * pow(input_x[3], 2);
            idvd_poly_feat[374] = pow(input_x[0], 3) * pow(input_x[1], 2) * pow(input_x[3], 3);
            idvd_poly_feat[375] = pow(input_x[0], 3) * pow(input_x[1], 1) * pow(input_x[2], 4);
            idvd_poly_feat[376] = pow(input_x[0], 3) * pow(input_x[1], 1) * pow(input_x[2], 3) * pow(input_x[3], 1);
            idvd_poly_feat[377] = pow(input_x[0], 3) * pow(input_x[1], 1) * pow(input_x[2], 2) * pow(input_x[3], 2);
            idvd_poly_feat[378] = pow(input_x[0], 3) * pow(input_x[1], 1) * pow(input_x[2], 1) * pow(input_x[3], 3);
            idvd_poly_feat[379] = pow(input_x[0], 3) * pow(input_x[1], 1) * pow(input_x[3], 4);
            idvd_poly_feat[380] = pow(input_x[0], 3) * pow(input_x[2], 5);
            idvd_poly_feat[381] = pow(input_x[0], 3) * pow(input_x[2], 4) * pow(input_x[3], 1);
            idvd_poly_feat[382] = pow(input_x[0], 3) * pow(input_x[2], 3) * pow(input_x[3], 2);
            idvd_poly_feat[383] = pow(input_x[0], 3) * pow(input_x[2], 2) * pow(input_x[3], 3);
            idvd_poly_feat[384] = pow(input_x[0], 3) * pow(input_x[2], 1) * pow(input_x[3], 4);
            idvd_poly_feat[385] = pow(input_x[0], 3) * pow(input_x[3], 5);
            idvd_poly_feat[386] = pow(input_x[0], 2) * pow(input_x[1], 6);
            idvd_poly_feat[387] = pow(input_x[0], 2) * pow(input_x[1], 5) * pow(input_x[2], 1);
            idvd_poly_feat[388] = pow(input_x[0], 2) * pow(input_x[1], 5) * pow(input_x[3], 1);
            idvd_poly_feat[389] = pow(input_x[0], 2) * pow(input_x[1], 4) * pow(input_x[2], 2);
            idvd_poly_feat[390] = pow(input_x[0], 2) * pow(input_x[1], 4) * pow(input_x[2], 1) * pow(input_x[3], 1);
            idvd_poly_feat[391] = pow(input_x[0], 2) * pow(input_x[1], 4) * pow(input_x[3], 2);
            idvd_poly_feat[392] = pow(input_x[0], 2) * pow(input_x[1], 3) * pow(input_x[2], 3);
            idvd_poly_feat[393] = pow(input_x[0], 2) * pow(input_x[1], 3) * pow(input_x[2], 2) * pow(input_x[3], 1);
            idvd_poly_feat[394] = pow(input_x[0], 2) * pow(input_x[1], 3) * pow(input_x[2], 1) * pow(input_x[3], 2);
            idvd_poly_feat[395] = pow(input_x[0], 2) * pow(input_x[1], 3) * pow(input_x[3], 3);
            idvd_poly_feat[396] = pow(input_x[0], 2) * pow(input_x[1], 2) * pow(input_x[2], 4);
            idvd_poly_feat[397] = pow(input_x[0], 2) * pow(input_x[1], 2) * pow(input_x[2], 3) * pow(input_x[3], 1);
            idvd_poly_feat[398] = pow(input_x[0], 2) * pow(input_x[1], 2) * pow(input_x[2], 2) * pow(input_x[3], 2);
            idvd_poly_feat[399] = pow(input_x[0], 2) * pow(input_x[1], 2) * pow(input_x[2], 1) * pow(input_x[3], 3);
            idvd_poly_feat[400] = pow(input_x[0], 2) * pow(input_x[1], 2) * pow(input_x[3], 4);
            idvd_poly_feat[401] = pow(input_x[0], 2) * pow(input_x[1], 1) * pow(input_x[2], 5);
            idvd_poly_feat[402] = pow(input_x[0], 2) * pow(input_x[1], 1) * pow(input_x[2], 4) * pow(input_x[3], 1);
            idvd_poly_feat[403] = pow(input_x[0], 2) * pow(input_x[1], 1) * pow(input_x[2], 3) * pow(input_x[3], 2);
            idvd_poly_feat[404] = pow(input_x[0], 2) * pow(input_x[1], 1) * pow(input_x[2], 2) * pow(input_x[3], 3);
            idvd_poly_feat[405] = pow(input_x[0], 2) * pow(input_x[1], 1) * pow(input_x[2], 1) * pow(input_x[3], 4);
            idvd_poly_feat[406] = pow(input_x[0], 2) * pow(input_x[1], 1) * pow(input_x[3], 5);
            idvd_poly_feat[407] = pow(input_x[0], 2) * pow(input_x[2], 6);
            idvd_poly_feat[408] = pow(input_x[0], 2) * pow(input_x[2], 5) * pow(input_x[3], 1);
            idvd_poly_feat[409] = pow(input_x[0], 2) * pow(input_x[2], 4) * pow(input_x[3], 2);
            idvd_poly_feat[410] = pow(input_x[0], 2) * pow(input_x[2], 3) * pow(input_x[3], 3);
            idvd_poly_feat[411] = pow(input_x[0], 2) * pow(input_x[2], 2) * pow(input_x[3], 4);
            idvd_poly_feat[412] = pow(input_x[0], 2) * pow(input_x[2], 1) * pow(input_x[3], 5);
            idvd_poly_feat[413] = pow(input_x[0], 2) * pow(input_x[3], 6);
            idvd_poly_feat[414] = pow(input_x[0], 1) * pow(input_x[1], 7);
            idvd_poly_feat[415] = pow(input_x[0], 1) * pow(input_x[1], 6) * pow(input_x[2], 1);
            idvd_poly_feat[416] = pow(input_x[0], 1) * pow(input_x[1], 6) * pow(input_x[3], 1);
            idvd_poly_feat[417] = pow(input_x[0], 1) * pow(input_x[1], 5) * pow(input_x[2], 2);
            idvd_poly_feat[418] = pow(input_x[0], 1) * pow(input_x[1], 5) * pow(input_x[2], 1) * pow(input_x[3], 1);
            idvd_poly_feat[419] = pow(input_x[0], 1) * pow(input_x[1], 5) * pow(input_x[3], 2);
            idvd_poly_feat[420] = pow(input_x[0], 1) * pow(input_x[1], 4) * pow(input_x[2], 3);
            idvd_poly_feat[421] = pow(input_x[0], 1) * pow(input_x[1], 4) * pow(input_x[2], 2) * pow(input_x[3], 1);
            idvd_poly_feat[422] = pow(input_x[0], 1) * pow(input_x[1], 4) * pow(input_x[2], 1) * pow(input_x[3], 2);
            idvd_poly_feat[423] = pow(input_x[0], 1) * pow(input_x[1], 4) * pow(input_x[3], 3);
            idvd_poly_feat[424] = pow(input_x[0], 1) * pow(input_x[1], 3) * pow(input_x[2], 4);
            idvd_poly_feat[425] = pow(input_x[0], 1) * pow(input_x[1], 3) * pow(input_x[2], 3) * pow(input_x[3], 1);
            idvd_poly_feat[426] = pow(input_x[0], 1) * pow(input_x[1], 3) * pow(input_x[2], 2) * pow(input_x[3], 2);
            idvd_poly_feat[427] = pow(input_x[0], 1) * pow(input_x[1], 3) * pow(input_x[2], 1) * pow(input_x[3], 3);
            idvd_poly_feat[428] = pow(input_x[0], 1) * pow(input_x[1], 3) * pow(input_x[3], 4);
            idvd_poly_feat[429] = pow(input_x[0], 1) * pow(input_x[1], 2) * pow(input_x[2], 5);
            idvd_poly_feat[430] = pow(input_x[0], 1) * pow(input_x[1], 2) * pow(input_x[2], 4) * pow(input_x[3], 1);
            idvd_poly_feat[431] = pow(input_x[0], 1) * pow(input_x[1], 2) * pow(input_x[2], 3) * pow(input_x[3], 2);
            idvd_poly_feat[432] = pow(input_x[0], 1) * pow(input_x[1], 2) * pow(input_x[2], 2) * pow(input_x[3], 3);
            idvd_poly_feat[433] = pow(input_x[0], 1) * pow(input_x[1], 2) * pow(input_x[2], 1) * pow(input_x[3], 4);
            idvd_poly_feat[434] = pow(input_x[0], 1) * pow(input_x[1], 2) * pow(input_x[3], 5);
            idvd_poly_feat[435] = pow(input_x[0], 1) * pow(input_x[1], 1) * pow(input_x[2], 6);
            idvd_poly_feat[436] = pow(input_x[0], 1) * pow(input_x[1], 1) * pow(input_x[2], 5) * pow(input_x[3], 1);
            idvd_poly_feat[437] = pow(input_x[0], 1) * pow(input_x[1], 1) * pow(input_x[2], 4) * pow(input_x[3], 2);
            idvd_poly_feat[438] = pow(input_x[0], 1) * pow(input_x[1], 1) * pow(input_x[2], 3) * pow(input_x[3], 3);
            idvd_poly_feat[439] = pow(input_x[0], 1) * pow(input_x[1], 1) * pow(input_x[2], 2) * pow(input_x[3], 4);
            idvd_poly_feat[440] = pow(input_x[0], 1) * pow(input_x[1], 1) * pow(input_x[2], 1) * pow(input_x[3], 5);
            idvd_poly_feat[441] = pow(input_x[0], 1) * pow(input_x[1], 1) * pow(input_x[3], 6);
            idvd_poly_feat[442] = pow(input_x[0], 1) * pow(input_x[2], 7);
            idvd_poly_feat[443] = pow(input_x[0], 1) * pow(input_x[2], 6) * pow(input_x[3], 1);
            idvd_poly_feat[444] = pow(input_x[0], 1) * pow(input_x[2], 5) * pow(input_x[3], 2);
            idvd_poly_feat[445] = pow(input_x[0], 1) * pow(input_x[2], 4) * pow(input_x[3], 3);
            idvd_poly_feat[446] = pow(input_x[0], 1) * pow(input_x[2], 3) * pow(input_x[3], 4);
            idvd_poly_feat[447] = pow(input_x[0], 1) * pow(input_x[2], 2) * pow(input_x[3], 5);
            idvd_poly_feat[448] = pow(input_x[0], 1) * pow(input_x[2], 1) * pow(input_x[3], 6);
            idvd_poly_feat[449] = pow(input_x[0], 1) * pow(input_x[3], 7);
            idvd_poly_feat[450] = pow(input_x[1], 8);
            idvd_poly_feat[451] = pow(input_x[1], 7) * pow(input_x[2], 1);
            idvd_poly_feat[452] = pow(input_x[1], 7) * pow(input_x[3], 1);
            idvd_poly_feat[453] = pow(input_x[1], 6) * pow(input_x[2], 2);
            idvd_poly_feat[454] = pow(input_x[1], 6) * pow(input_x[2], 1) * pow(input_x[3], 1);
            idvd_poly_feat[455] = pow(input_x[1], 6) * pow(input_x[3], 2);
            idvd_poly_feat[456] = pow(input_x[1], 5) * pow(input_x[2], 3);
            idvd_poly_feat[457] = pow(input_x[1], 5) * pow(input_x[2], 2) * pow(input_x[3], 1);
            idvd_poly_feat[458] = pow(input_x[1], 5) * pow(input_x[2], 1) * pow(input_x[3], 2);
            idvd_poly_feat[459] = pow(input_x[1], 5) * pow(input_x[3], 3);
            idvd_poly_feat[460] = pow(input_x[1], 4) * pow(input_x[2], 4);
            idvd_poly_feat[461] = pow(input_x[1], 4) * pow(input_x[2], 3) * pow(input_x[3], 1);
            idvd_poly_feat[462] = pow(input_x[1], 4) * pow(input_x[2], 2) * pow(input_x[3], 2);
            idvd_poly_feat[463] = pow(input_x[1], 4) * pow(input_x[2], 1) * pow(input_x[3], 3);
            idvd_poly_feat[464] = pow(input_x[1], 4) * pow(input_x[3], 4);
            idvd_poly_feat[465] = pow(input_x[1], 3) * pow(input_x[2], 5);
            idvd_poly_feat[466] = pow(input_x[1], 3) * pow(input_x[2], 4) * pow(input_x[3], 1);
            idvd_poly_feat[467] = pow(input_x[1], 3) * pow(input_x[2], 3) * pow(input_x[3], 2);
            idvd_poly_feat[468] = pow(input_x[1], 3) * pow(input_x[2], 2) * pow(input_x[3], 3);
            idvd_poly_feat[469] = pow(input_x[1], 3) * pow(input_x[2], 1) * pow(input_x[3], 4);
            idvd_poly_feat[470] = pow(input_x[1], 3) * pow(input_x[3], 5);
            idvd_poly_feat[471] = pow(input_x[1], 2) * pow(input_x[2], 6);
            idvd_poly_feat[472] = pow(input_x[1], 2) * pow(input_x[2], 5) * pow(input_x[3], 1);
            idvd_poly_feat[473] = pow(input_x[1], 2) * pow(input_x[2], 4) * pow(input_x[3], 2);
            idvd_poly_feat[474] = pow(input_x[1], 2) * pow(input_x[2], 3) * pow(input_x[3], 3);
            idvd_poly_feat[475] = pow(input_x[1], 2) * pow(input_x[2], 2) * pow(input_x[3], 4);
            idvd_poly_feat[476] = pow(input_x[1], 2) * pow(input_x[2], 1) * pow(input_x[3], 5);
            idvd_poly_feat[477] = pow(input_x[1], 2) * pow(input_x[3], 6);
            idvd_poly_feat[478] = pow(input_x[1], 1) * pow(input_x[2], 7);
            idvd_poly_feat[479] = pow(input_x[1], 1) * pow(input_x[2], 6) * pow(input_x[3], 1);
            idvd_poly_feat[480] = pow(input_x[1], 1) * pow(input_x[2], 5) * pow(input_x[3], 2);
            idvd_poly_feat[481] = pow(input_x[1], 1) * pow(input_x[2], 4) * pow(input_x[3], 3);
            idvd_poly_feat[482] = pow(input_x[1], 1) * pow(input_x[2], 3) * pow(input_x[3], 4);
            idvd_poly_feat[483] = pow(input_x[1], 1) * pow(input_x[2], 2) * pow(input_x[3], 5);
            idvd_poly_feat[484] = pow(input_x[1], 1) * pow(input_x[2], 1) * pow(input_x[3], 6);
            idvd_poly_feat[485] = pow(input_x[1], 1) * pow(input_x[3], 7);
            idvd_poly_feat[486] = pow(input_x[2], 8);
            idvd_poly_feat[487] = pow(input_x[2], 7) * pow(input_x[3], 1);
            idvd_poly_feat[488] = pow(input_x[2], 6) * pow(input_x[3], 2);
            idvd_poly_feat[489] = pow(input_x[2], 5) * pow(input_x[3], 3);
            idvd_poly_feat[490] = pow(input_x[2], 4) * pow(input_x[3], 4);
            idvd_poly_feat[491] = pow(input_x[2], 3) * pow(input_x[3], 5);
            idvd_poly_feat[492] = pow(input_x[2], 2) * pow(input_x[3], 6);
            idvd_poly_feat[493] = pow(input_x[2], 1) * pow(input_x[3], 7);
            idvd_poly_feat[494] = pow(input_x[3], 8);
            idvd_poly_feat[495] = pow(input_x[0], 9);
            idvd_poly_feat[496] = pow(input_x[0], 8) * pow(input_x[1], 1);
            idvd_poly_feat[497] = pow(input_x[0], 8) * pow(input_x[2], 1);
            idvd_poly_feat[498] = pow(input_x[0], 8) * pow(input_x[3], 1);
            idvd_poly_feat[499] = pow(input_x[0], 7) * pow(input_x[1], 2);
            idvd_poly_feat[500] = pow(input_x[0], 7) * pow(input_x[1], 1) * pow(input_x[2], 1);
            idvd_poly_feat[501] = pow(input_x[0], 7) * pow(input_x[1], 1) * pow(input_x[3], 1);
            idvd_poly_feat[502] = pow(input_x[0], 7) * pow(input_x[2], 2);
            idvd_poly_feat[503] = pow(input_x[0], 7) * pow(input_x[2], 1) * pow(input_x[3], 1);
            idvd_poly_feat[504] = pow(input_x[0], 7) * pow(input_x[3], 2);
            idvd_poly_feat[505] = pow(input_x[0], 6) * pow(input_x[1], 3);
            idvd_poly_feat[506] = pow(input_x[0], 6) * pow(input_x[1], 2) * pow(input_x[2], 1);
            idvd_poly_feat[507] = pow(input_x[0], 6) * pow(input_x[1], 2) * pow(input_x[3], 1);
            idvd_poly_feat[508] = pow(input_x[0], 6) * pow(input_x[1], 1) * pow(input_x[2], 2);
            idvd_poly_feat[509] = pow(input_x[0], 6) * pow(input_x[1], 1) * pow(input_x[2], 1) * pow(input_x[3], 1);
            idvd_poly_feat[510] = pow(input_x[0], 6) * pow(input_x[1], 1) * pow(input_x[3], 2);
            idvd_poly_feat[511] = pow(input_x[0], 6) * pow(input_x[2], 3);
            idvd_poly_feat[512] = pow(input_x[0], 6) * pow(input_x[2], 2) * pow(input_x[3], 1);
            idvd_poly_feat[513] = pow(input_x[0], 6) * pow(input_x[2], 1) * pow(input_x[3], 2);
            idvd_poly_feat[514] = pow(input_x[0], 6) * pow(input_x[3], 3);
            idvd_poly_feat[515] = pow(input_x[0], 5) * pow(input_x[1], 4);
            idvd_poly_feat[516] = pow(input_x[0], 5) * pow(input_x[1], 3) * pow(input_x[2], 1);
            idvd_poly_feat[517] = pow(input_x[0], 5) * pow(input_x[1], 3) * pow(input_x[3], 1);
            idvd_poly_feat[518] = pow(input_x[0], 5) * pow(input_x[1], 2) * pow(input_x[2], 2);
            idvd_poly_feat[519] = pow(input_x[0], 5) * pow(input_x[1], 2) * pow(input_x[2], 1) * pow(input_x[3], 1);
            idvd_poly_feat[520] = pow(input_x[0], 5) * pow(input_x[1], 2) * pow(input_x[3], 2);
            idvd_poly_feat[521] = pow(input_x[0], 5) * pow(input_x[1], 1) * pow(input_x[2], 3);
            idvd_poly_feat[522] = pow(input_x[0], 5) * pow(input_x[1], 1) * pow(input_x[2], 2) * pow(input_x[3], 1);
            idvd_poly_feat[523] = pow(input_x[0], 5) * pow(input_x[1], 1) * pow(input_x[2], 1) * pow(input_x[3], 2);
            idvd_poly_feat[524] = pow(input_x[0], 5) * pow(input_x[1], 1) * pow(input_x[3], 3);
            idvd_poly_feat[525] = pow(input_x[0], 5) * pow(input_x[2], 4);
            idvd_poly_feat[526] = pow(input_x[0], 5) * pow(input_x[2], 3) * pow(input_x[3], 1);
            idvd_poly_feat[527] = pow(input_x[0], 5) * pow(input_x[2], 2) * pow(input_x[3], 2);
            idvd_poly_feat[528] = pow(input_x[0], 5) * pow(input_x[2], 1) * pow(input_x[3], 3);
            idvd_poly_feat[529] = pow(input_x[0], 5) * pow(input_x[3], 4);
            idvd_poly_feat[530] = pow(input_x[0], 4) * pow(input_x[1], 5);
            idvd_poly_feat[531] = pow(input_x[0], 4) * pow(input_x[1], 4) * pow(input_x[2], 1);
            idvd_poly_feat[532] = pow(input_x[0], 4) * pow(input_x[1], 4) * pow(input_x[3], 1);
            idvd_poly_feat[533] = pow(input_x[0], 4) * pow(input_x[1], 3) * pow(input_x[2], 2);
            idvd_poly_feat[534] = pow(input_x[0], 4) * pow(input_x[1], 3) * pow(input_x[2], 1) * pow(input_x[3], 1);
            idvd_poly_feat[535] = pow(input_x[0], 4) * pow(input_x[1], 3) * pow(input_x[3], 2);
            idvd_poly_feat[536] = pow(input_x[0], 4) * pow(input_x[1], 2) * pow(input_x[2], 3);
            idvd_poly_feat[537] = pow(input_x[0], 4) * pow(input_x[1], 2) * pow(input_x[2], 2) * pow(input_x[3], 1);
            idvd_poly_feat[538] = pow(input_x[0], 4) * pow(input_x[1], 2) * pow(input_x[2], 1) * pow(input_x[3], 2);
            idvd_poly_feat[539] = pow(input_x[0], 4) * pow(input_x[1], 2) * pow(input_x[3], 3);
            idvd_poly_feat[540] = pow(input_x[0], 4) * pow(input_x[1], 1) * pow(input_x[2], 4);
            idvd_poly_feat[541] = pow(input_x[0], 4) * pow(input_x[1], 1) * pow(input_x[2], 3) * pow(input_x[3], 1);
            idvd_poly_feat[542] = pow(input_x[0], 4) * pow(input_x[1], 1) * pow(input_x[2], 2) * pow(input_x[3], 2);
            idvd_poly_feat[543] = pow(input_x[0], 4) * pow(input_x[1], 1) * pow(input_x[2], 1) * pow(input_x[3], 3);
            idvd_poly_feat[544] = pow(input_x[0], 4) * pow(input_x[1], 1) * pow(input_x[3], 4);
            idvd_poly_feat[545] = pow(input_x[0], 4) * pow(input_x[2], 5);
            idvd_poly_feat[546] = pow(input_x[0], 4) * pow(input_x[2], 4) * pow(input_x[3], 1);
            idvd_poly_feat[547] = pow(input_x[0], 4) * pow(input_x[2], 3) * pow(input_x[3], 2);
            idvd_poly_feat[548] = pow(input_x[0], 4) * pow(input_x[2], 2) * pow(input_x[3], 3);
            idvd_poly_feat[549] = pow(input_x[0], 4) * pow(input_x[2], 1) * pow(input_x[3], 4);
            idvd_poly_feat[550] = pow(input_x[0], 4) * pow(input_x[3], 5);
            idvd_poly_feat[551] = pow(input_x[0], 3) * pow(input_x[1], 6);
            idvd_poly_feat[552] = pow(input_x[0], 3) * pow(input_x[1], 5) * pow(input_x[2], 1);
            idvd_poly_feat[553] = pow(input_x[0], 3) * pow(input_x[1], 5) * pow(input_x[3], 1);
            idvd_poly_feat[554] = pow(input_x[0], 3) * pow(input_x[1], 4) * pow(input_x[2], 2);
            idvd_poly_feat[555] = pow(input_x[0], 3) * pow(input_x[1], 4) * pow(input_x[2], 1) * pow(input_x[3], 1);
            idvd_poly_feat[556] = pow(input_x[0], 3) * pow(input_x[1], 4) * pow(input_x[3], 2);
            idvd_poly_feat[557] = pow(input_x[0], 3) * pow(input_x[1], 3) * pow(input_x[2], 3);
            idvd_poly_feat[558] = pow(input_x[0], 3) * pow(input_x[1], 3) * pow(input_x[2], 2) * pow(input_x[3], 1);
            idvd_poly_feat[559] = pow(input_x[0], 3) * pow(input_x[1], 3) * pow(input_x[2], 1) * pow(input_x[3], 2);
            idvd_poly_feat[560] = pow(input_x[0], 3) * pow(input_x[1], 3) * pow(input_x[3], 3);
            idvd_poly_feat[561] = pow(input_x[0], 3) * pow(input_x[1], 2) * pow(input_x[2], 4);
            idvd_poly_feat[562] = pow(input_x[0], 3) * pow(input_x[1], 2) * pow(input_x[2], 3) * pow(input_x[3], 1);
            idvd_poly_feat[563] = pow(input_x[0], 3) * pow(input_x[1], 2) * pow(input_x[2], 2) * pow(input_x[3], 2);
            idvd_poly_feat[564] = pow(input_x[0], 3) * pow(input_x[1], 2) * pow(input_x[2], 1) * pow(input_x[3], 3);
            idvd_poly_feat[565] = pow(input_x[0], 3) * pow(input_x[1], 2) * pow(input_x[3], 4);
            idvd_poly_feat[566] = pow(input_x[0], 3) * pow(input_x[1], 1) * pow(input_x[2], 5);
            idvd_poly_feat[567] = pow(input_x[0], 3) * pow(input_x[1], 1) * pow(input_x[2], 4) * pow(input_x[3], 1);
            idvd_poly_feat[568] = pow(input_x[0], 3) * pow(input_x[1], 1) * pow(input_x[2], 3) * pow(input_x[3], 2);
            idvd_poly_feat[569] = pow(input_x[0], 3) * pow(input_x[1], 1) * pow(input_x[2], 2) * pow(input_x[3], 3);
            idvd_poly_feat[570] = pow(input_x[0], 3) * pow(input_x[1], 1) * pow(input_x[2], 1) * pow(input_x[3], 4);
            idvd_poly_feat[571] = pow(input_x[0], 3) * pow(input_x[1], 1) * pow(input_x[3], 5);
            idvd_poly_feat[572] = pow(input_x[0], 3) * pow(input_x[2], 6);
            idvd_poly_feat[573] = pow(input_x[0], 3) * pow(input_x[2], 5) * pow(input_x[3], 1);
            idvd_poly_feat[574] = pow(input_x[0], 3) * pow(input_x[2], 4) * pow(input_x[3], 2);
            idvd_poly_feat[575] = pow(input_x[0], 3) * pow(input_x[2], 3) * pow(input_x[3], 3);
            idvd_poly_feat[576] = pow(input_x[0], 3) * pow(input_x[2], 2) * pow(input_x[3], 4);
            idvd_poly_feat[577] = pow(input_x[0], 3) * pow(input_x[2], 1) * pow(input_x[3], 5);
            idvd_poly_feat[578] = pow(input_x[0], 3) * pow(input_x[3], 6);
            idvd_poly_feat[579] = pow(input_x[0], 2) * pow(input_x[1], 7);
            idvd_poly_feat[580] = pow(input_x[0], 2) * pow(input_x[1], 6) * pow(input_x[2], 1);
            idvd_poly_feat[581] = pow(input_x[0], 2) * pow(input_x[1], 6) * pow(input_x[3], 1);
            idvd_poly_feat[582] = pow(input_x[0], 2) * pow(input_x[1], 5) * pow(input_x[2], 2);
            idvd_poly_feat[583] = pow(input_x[0], 2) * pow(input_x[1], 5) * pow(input_x[2], 1) * pow(input_x[3], 1);
            idvd_poly_feat[584] = pow(input_x[0], 2) * pow(input_x[1], 5) * pow(input_x[3], 2);
            idvd_poly_feat[585] = pow(input_x[0], 2) * pow(input_x[1], 4) * pow(input_x[2], 3);
            idvd_poly_feat[586] = pow(input_x[0], 2) * pow(input_x[1], 4) * pow(input_x[2], 2) * pow(input_x[3], 1);
            idvd_poly_feat[587] = pow(input_x[0], 2) * pow(input_x[1], 4) * pow(input_x[2], 1) * pow(input_x[3], 2);
            idvd_poly_feat[588] = pow(input_x[0], 2) * pow(input_x[1], 4) * pow(input_x[3], 3);
            idvd_poly_feat[589] = pow(input_x[0], 2) * pow(input_x[1], 3) * pow(input_x[2], 4);
            idvd_poly_feat[590] = pow(input_x[0], 2) * pow(input_x[1], 3) * pow(input_x[2], 3) * pow(input_x[3], 1);
            idvd_poly_feat[591] = pow(input_x[0], 2) * pow(input_x[1], 3) * pow(input_x[2], 2) * pow(input_x[3], 2);
            idvd_poly_feat[592] = pow(input_x[0], 2) * pow(input_x[1], 3) * pow(input_x[2], 1) * pow(input_x[3], 3);
            idvd_poly_feat[593] = pow(input_x[0], 2) * pow(input_x[1], 3) * pow(input_x[3], 4);
            idvd_poly_feat[594] = pow(input_x[0], 2) * pow(input_x[1], 2) * pow(input_x[2], 5);
            idvd_poly_feat[595] = pow(input_x[0], 2) * pow(input_x[1], 2) * pow(input_x[2], 4) * pow(input_x[3], 1);
            idvd_poly_feat[596] = pow(input_x[0], 2) * pow(input_x[1], 2) * pow(input_x[2], 3) * pow(input_x[3], 2);
            idvd_poly_feat[597] = pow(input_x[0], 2) * pow(input_x[1], 2) * pow(input_x[2], 2) * pow(input_x[3], 3);
            idvd_poly_feat[598] = pow(input_x[0], 2) * pow(input_x[1], 2) * pow(input_x[2], 1) * pow(input_x[3], 4);
            idvd_poly_feat[599] = pow(input_x[0], 2) * pow(input_x[1], 2) * pow(input_x[3], 5);
            idvd_poly_feat[600] = pow(input_x[0], 2) * pow(input_x[1], 1) * pow(input_x[2], 6);
            idvd_poly_feat[601] = pow(input_x[0], 2) * pow(input_x[1], 1) * pow(input_x[2], 5) * pow(input_x[3], 1);
            idvd_poly_feat[602] = pow(input_x[0], 2) * pow(input_x[1], 1) * pow(input_x[2], 4) * pow(input_x[3], 2);
            idvd_poly_feat[603] = pow(input_x[0], 2) * pow(input_x[1], 1) * pow(input_x[2], 3) * pow(input_x[3], 3);
            idvd_poly_feat[604] = pow(input_x[0], 2) * pow(input_x[1], 1) * pow(input_x[2], 2) * pow(input_x[3], 4);
            idvd_poly_feat[605] = pow(input_x[0], 2) * pow(input_x[1], 1) * pow(input_x[2], 1) * pow(input_x[3], 5);
            idvd_poly_feat[606] = pow(input_x[0], 2) * pow(input_x[1], 1) * pow(input_x[3], 6);
            idvd_poly_feat[607] = pow(input_x[0], 2) * pow(input_x[2], 7);
            idvd_poly_feat[608] = pow(input_x[0], 2) * pow(input_x[2], 6) * pow(input_x[3], 1);
            idvd_poly_feat[609] = pow(input_x[0], 2) * pow(input_x[2], 5) * pow(input_x[3], 2);
            idvd_poly_feat[610] = pow(input_x[0], 2) * pow(input_x[2], 4) * pow(input_x[3], 3);
            idvd_poly_feat[611] = pow(input_x[0], 2) * pow(input_x[2], 3) * pow(input_x[3], 4);
            idvd_poly_feat[612] = pow(input_x[0], 2) * pow(input_x[2], 2) * pow(input_x[3], 5);
            idvd_poly_feat[613] = pow(input_x[0], 2) * pow(input_x[2], 1) * pow(input_x[3], 6);
            idvd_poly_feat[614] = pow(input_x[0], 2) * pow(input_x[3], 7);
            idvd_poly_feat[615] = pow(input_x[0], 1) * pow(input_x[1], 8);
            idvd_poly_feat[616] = pow(input_x[0], 1) * pow(input_x[1], 7) * pow(input_x[2], 1);
            idvd_poly_feat[617] = pow(input_x[0], 1) * pow(input_x[1], 7) * pow(input_x[3], 1);
            idvd_poly_feat[618] = pow(input_x[0], 1) * pow(input_x[1], 6) * pow(input_x[2], 2);
            idvd_poly_feat[619] = pow(input_x[0], 1) * pow(input_x[1], 6) * pow(input_x[2], 1) * pow(input_x[3], 1);
            idvd_poly_feat[620] = pow(input_x[0], 1) * pow(input_x[1], 6) * pow(input_x[3], 2);
            idvd_poly_feat[621] = pow(input_x[0], 1) * pow(input_x[1], 5) * pow(input_x[2], 3);
            idvd_poly_feat[622] = pow(input_x[0], 1) * pow(input_x[1], 5) * pow(input_x[2], 2) * pow(input_x[3], 1);
            idvd_poly_feat[623] = pow(input_x[0], 1) * pow(input_x[1], 5) * pow(input_x[2], 1) * pow(input_x[3], 2);
            idvd_poly_feat[624] = pow(input_x[0], 1) * pow(input_x[1], 5) * pow(input_x[3], 3);
            idvd_poly_feat[625] = pow(input_x[0], 1) * pow(input_x[1], 4) * pow(input_x[2], 4);
            idvd_poly_feat[626] = pow(input_x[0], 1) * pow(input_x[1], 4) * pow(input_x[2], 3) * pow(input_x[3], 1);
            idvd_poly_feat[627] = pow(input_x[0], 1) * pow(input_x[1], 4) * pow(input_x[2], 2) * pow(input_x[3], 2);
            idvd_poly_feat[628] = pow(input_x[0], 1) * pow(input_x[1], 4) * pow(input_x[2], 1) * pow(input_x[3], 3);
            idvd_poly_feat[629] = pow(input_x[0], 1) * pow(input_x[1], 4) * pow(input_x[3], 4);
            idvd_poly_feat[630] = pow(input_x[0], 1) * pow(input_x[1], 3) * pow(input_x[2], 5);
            idvd_poly_feat[631] = pow(input_x[0], 1) * pow(input_x[1], 3) * pow(input_x[2], 4) * pow(input_x[3], 1);
            idvd_poly_feat[632] = pow(input_x[0], 1) * pow(input_x[1], 3) * pow(input_x[2], 3) * pow(input_x[3], 2);
            idvd_poly_feat[633] = pow(input_x[0], 1) * pow(input_x[1], 3) * pow(input_x[2], 2) * pow(input_x[3], 3);
            idvd_poly_feat[634] = pow(input_x[0], 1) * pow(input_x[1], 3) * pow(input_x[2], 1) * pow(input_x[3], 4);
            idvd_poly_feat[635] = pow(input_x[0], 1) * pow(input_x[1], 3) * pow(input_x[3], 5);
            idvd_poly_feat[636] = pow(input_x[0], 1) * pow(input_x[1], 2) * pow(input_x[2], 6);
            idvd_poly_feat[637] = pow(input_x[0], 1) * pow(input_x[1], 2) * pow(input_x[2], 5) * pow(input_x[3], 1);
            idvd_poly_feat[638] = pow(input_x[0], 1) * pow(input_x[1], 2) * pow(input_x[2], 4) * pow(input_x[3], 2);
            idvd_poly_feat[639] = pow(input_x[0], 1) * pow(input_x[1], 2) * pow(input_x[2], 3) * pow(input_x[3], 3);
            idvd_poly_feat[640] = pow(input_x[0], 1) * pow(input_x[1], 2) * pow(input_x[2], 2) * pow(input_x[3], 4);
            idvd_poly_feat[641] = pow(input_x[0], 1) * pow(input_x[1], 2) * pow(input_x[2], 1) * pow(input_x[3], 5);
            idvd_poly_feat[642] = pow(input_x[0], 1) * pow(input_x[1], 2) * pow(input_x[3], 6);
            idvd_poly_feat[643] = pow(input_x[0], 1) * pow(input_x[1], 1) * pow(input_x[2], 7);
            idvd_poly_feat[644] = pow(input_x[0], 1) * pow(input_x[1], 1) * pow(input_x[2], 6) * pow(input_x[3], 1);
            idvd_poly_feat[645] = pow(input_x[0], 1) * pow(input_x[1], 1) * pow(input_x[2], 5) * pow(input_x[3], 2);
            idvd_poly_feat[646] = pow(input_x[0], 1) * pow(input_x[1], 1) * pow(input_x[2], 4) * pow(input_x[3], 3);
            idvd_poly_feat[647] = pow(input_x[0], 1) * pow(input_x[1], 1) * pow(input_x[2], 3) * pow(input_x[3], 4);
            idvd_poly_feat[648] = pow(input_x[0], 1) * pow(input_x[1], 1) * pow(input_x[2], 2) * pow(input_x[3], 5);
            idvd_poly_feat[649] = pow(input_x[0], 1) * pow(input_x[1], 1) * pow(input_x[2], 1) * pow(input_x[3], 6);
            idvd_poly_feat[650] = pow(input_x[0], 1) * pow(input_x[1], 1) * pow(input_x[3], 7);
            idvd_poly_feat[651] = pow(input_x[0], 1) * pow(input_x[2], 8);
            idvd_poly_feat[652] = pow(input_x[0], 1) * pow(input_x[2], 7) * pow(input_x[3], 1);
            idvd_poly_feat[653] = pow(input_x[0], 1) * pow(input_x[2], 6) * pow(input_x[3], 2);
            idvd_poly_feat[654] = pow(input_x[0], 1) * pow(input_x[2], 5) * pow(input_x[3], 3);
            idvd_poly_feat[655] = pow(input_x[0], 1) * pow(input_x[2], 4) * pow(input_x[3], 4);
            idvd_poly_feat[656] = pow(input_x[0], 1) * pow(input_x[2], 3) * pow(input_x[3], 5);
            idvd_poly_feat[657] = pow(input_x[0], 1) * pow(input_x[2], 2) * pow(input_x[3], 6);
            idvd_poly_feat[658] = pow(input_x[0], 1) * pow(input_x[2], 1) * pow(input_x[3], 7);
            idvd_poly_feat[659] = pow(input_x[0], 1) * pow(input_x[3], 8);
            idvd_poly_feat[660] = pow(input_x[1], 9);
            idvd_poly_feat[661] = pow(input_x[1], 8) * pow(input_x[2], 1);
            idvd_poly_feat[662] = pow(input_x[1], 8) * pow(input_x[3], 1);
            idvd_poly_feat[663] = pow(input_x[1], 7) * pow(input_x[2], 2);
            idvd_poly_feat[664] = pow(input_x[1], 7) * pow(input_x[2], 1) * pow(input_x[3], 1);
            idvd_poly_feat[665] = pow(input_x[1], 7) * pow(input_x[3], 2);
            idvd_poly_feat[666] = pow(input_x[1], 6) * pow(input_x[2], 3);
            idvd_poly_feat[667] = pow(input_x[1], 6) * pow(input_x[2], 2) * pow(input_x[3], 1);
            idvd_poly_feat[668] = pow(input_x[1], 6) * pow(input_x[2], 1) * pow(input_x[3], 2);
            idvd_poly_feat[669] = pow(input_x[1], 6) * pow(input_x[3], 3);
            idvd_poly_feat[670] = pow(input_x[1], 5) * pow(input_x[2], 4);
            idvd_poly_feat[671] = pow(input_x[1], 5) * pow(input_x[2], 3) * pow(input_x[3], 1);
            idvd_poly_feat[672] = pow(input_x[1], 5) * pow(input_x[2], 2) * pow(input_x[3], 2);
            idvd_poly_feat[673] = pow(input_x[1], 5) * pow(input_x[2], 1) * pow(input_x[3], 3);
            idvd_poly_feat[674] = pow(input_x[1], 5) * pow(input_x[3], 4);
            idvd_poly_feat[675] = pow(input_x[1], 4) * pow(input_x[2], 5);
            idvd_poly_feat[676] = pow(input_x[1], 4) * pow(input_x[2], 4) * pow(input_x[3], 1);
            idvd_poly_feat[677] = pow(input_x[1], 4) * pow(input_x[2], 3) * pow(input_x[3], 2);
            idvd_poly_feat[678] = pow(input_x[1], 4) * pow(input_x[2], 2) * pow(input_x[3], 3);
            idvd_poly_feat[679] = pow(input_x[1], 4) * pow(input_x[2], 1) * pow(input_x[3], 4);
            idvd_poly_feat[680] = pow(input_x[1], 4) * pow(input_x[3], 5);
            idvd_poly_feat[681] = pow(input_x[1], 3) * pow(input_x[2], 6);
            idvd_poly_feat[682] = pow(input_x[1], 3) * pow(input_x[2], 5) * pow(input_x[3], 1);
            idvd_poly_feat[683] = pow(input_x[1], 3) * pow(input_x[2], 4) * pow(input_x[3], 2);
            idvd_poly_feat[684] = pow(input_x[1], 3) * pow(input_x[2], 3) * pow(input_x[3], 3);
            idvd_poly_feat[685] = pow(input_x[1], 3) * pow(input_x[2], 2) * pow(input_x[3], 4);
            idvd_poly_feat[686] = pow(input_x[1], 3) * pow(input_x[2], 1) * pow(input_x[3], 5);
            idvd_poly_feat[687] = pow(input_x[1], 3) * pow(input_x[3], 6);
            idvd_poly_feat[688] = pow(input_x[1], 2) * pow(input_x[2], 7);
            idvd_poly_feat[689] = pow(input_x[1], 2) * pow(input_x[2], 6) * pow(input_x[3], 1);
            idvd_poly_feat[690] = pow(input_x[1], 2) * pow(input_x[2], 5) * pow(input_x[3], 2);
            idvd_poly_feat[691] = pow(input_x[1], 2) * pow(input_x[2], 4) * pow(input_x[3], 3);
            idvd_poly_feat[692] = pow(input_x[1], 2) * pow(input_x[2], 3) * pow(input_x[3], 4);
            idvd_poly_feat[693] = pow(input_x[1], 2) * pow(input_x[2], 2) * pow(input_x[3], 5);
            idvd_poly_feat[694] = pow(input_x[1], 2) * pow(input_x[2], 1) * pow(input_x[3], 6);
            idvd_poly_feat[695] = pow(input_x[1], 2) * pow(input_x[3], 7);
            idvd_poly_feat[696] = pow(input_x[1], 1) * pow(input_x[2], 8);
            idvd_poly_feat[697] = pow(input_x[1], 1) * pow(input_x[2], 7) * pow(input_x[3], 1);
            idvd_poly_feat[698] = pow(input_x[1], 1) * pow(input_x[2], 6) * pow(input_x[3], 2);
            idvd_poly_feat[699] = pow(input_x[1], 1) * pow(input_x[2], 5) * pow(input_x[3], 3);
            idvd_poly_feat[700] = pow(input_x[1], 1) * pow(input_x[2], 4) * pow(input_x[3], 4);
            idvd_poly_feat[701] = pow(input_x[1], 1) * pow(input_x[2], 3) * pow(input_x[3], 5);
            idvd_poly_feat[702] = pow(input_x[1], 1) * pow(input_x[2], 2) * pow(input_x[3], 6);
            idvd_poly_feat[703] = pow(input_x[1], 1) * pow(input_x[2], 1) * pow(input_x[3], 7);
            idvd_poly_feat[704] = pow(input_x[1], 1) * pow(input_x[3], 8);
            idvd_poly_feat[705] = pow(input_x[2], 9);
            idvd_poly_feat[706] = pow(input_x[2], 8) * pow(input_x[3], 1);
            idvd_poly_feat[707] = pow(input_x[2], 7) * pow(input_x[3], 2);
            idvd_poly_feat[708] = pow(input_x[2], 6) * pow(input_x[3], 3);
            idvd_poly_feat[709] = pow(input_x[2], 5) * pow(input_x[3], 4);
            idvd_poly_feat[710] = pow(input_x[2], 4) * pow(input_x[3], 5);
            idvd_poly_feat[711] = pow(input_x[2], 3) * pow(input_x[3], 6);
            idvd_poly_feat[712] = pow(input_x[2], 2) * pow(input_x[3], 7);
            idvd_poly_feat[713] = pow(input_x[2], 1) * pow(input_x[3], 8);
            idvd_poly_feat[714] = pow(input_x[3], 9);
            idvd_poly_feat[715] = pow(input_x[0], 10);
            idvd_poly_feat[716] = pow(input_x[1], 10);
            idvd_poly_feat[717] = pow(input_x[2], 10);
            idvd_poly_feat[718] = pow(input_x[3], 10);
            idvd_poly_feat[719] = pow(input_x[0], 11);
            idvd_poly_feat[720] = pow(input_x[1], 11);
            idvd_poly_feat[721] = pow(input_x[2], 11);
            idvd_poly_feat[722] = pow(input_x[3], 11);
            for(i=0; i<5; i=i+1) begin
              tmp = idvd_poly_b[i];
              for(j=0; j<723; j=j+1) tmp = tmp + idvd_poly_w[i*723 + j] * idvd_poly_feat[j];
              idvd_z[i] = tmp * idvd_sl_mul[i] + idvd_sl_add[i];
            end
            for(i=0; i<68; i=i+1) begin
              tmp = idvd_ae_b0[i];
              for(j=0; j<5; j=j+1) tmp = tmp + idvd_ae_w0[i*5 + j] * idvd_z[j];
              idvd_h0[i] = (tmp > 0.0) ? tmp : 0.0;
            end
            for(i=0; i<270; i=i+1) begin
              tmp = idvd_ae_b1[i];
              for(j=0; j<68; j=j+1) tmp = tmp + idvd_ae_w1[i*68 + j] * idvd_h0[j];
              idvd_h1[i] = (tmp > 0.0) ? tmp : 0.0;
            end
            for(i=0; i<540; i=i+1) begin
              tmp = idvd_ae_b2[i];
              for(j=0; j<270; j=j+1) tmp = tmp + idvd_ae_w2[i*270 + j] * idvd_h1[j];
              idvd_h2[i] = (tmp > 0.0) ? tmp : 0.0;
            end
            for(i=0; i<1080; i=i+1) begin
              tmp = idvd_ae_b3[i];
              for(j=0; j<540; j=j+1) tmp = tmp + idvd_ae_w3[i*540 + j] * idvd_h2[j];
              tmp = 1.0 / (1.0 + exp(-tmp));
              idvd_out[i] = -1.0 * (tmp * idvd_siv_mul[i] + idvd_siv_add[i]);
            end

            input_x[0] = (1.0e-3 * Lg) * idvg_sx_mul[0] + idvg_sx_add[0];
            input_x[1] = (1.0e-3 * Lgs) * idvg_sx_mul[1] + idvg_sx_add[1];
            input_x[2] = (1.0e-3 * Tox) * idvg_sx_mul[2] + idvg_sx_add[2];
            input_x[3] = Rc * idvg_sx_mul[3] + idvg_sx_add[3];
            idvg_poly_feat[0] = 1.0;
            idvg_poly_feat[1] = pow(input_x[0], 1);
            idvg_poly_feat[2] = pow(input_x[1], 1);
            idvg_poly_feat[3] = pow(input_x[2], 1);
            idvg_poly_feat[4] = pow(input_x[3], 1);
            idvg_poly_feat[5] = pow(input_x[0], 2);
            idvg_poly_feat[6] = pow(input_x[0], 1) * pow(input_x[1], 1);
            idvg_poly_feat[7] = pow(input_x[0], 1) * pow(input_x[2], 1);
            idvg_poly_feat[8] = pow(input_x[0], 1) * pow(input_x[3], 1);
            idvg_poly_feat[9] = pow(input_x[1], 2);
            idvg_poly_feat[10] = pow(input_x[1], 1) * pow(input_x[2], 1);
            idvg_poly_feat[11] = pow(input_x[1], 1) * pow(input_x[3], 1);
            idvg_poly_feat[12] = pow(input_x[2], 2);
            idvg_poly_feat[13] = pow(input_x[2], 1) * pow(input_x[3], 1);
            idvg_poly_feat[14] = pow(input_x[3], 2);
            idvg_poly_feat[15] = pow(input_x[0], 3);
            idvg_poly_feat[16] = pow(input_x[0], 2) * pow(input_x[1], 1);
            idvg_poly_feat[17] = pow(input_x[0], 2) * pow(input_x[2], 1);
            idvg_poly_feat[18] = pow(input_x[0], 2) * pow(input_x[3], 1);
            idvg_poly_feat[19] = pow(input_x[0], 1) * pow(input_x[1], 2);
            idvg_poly_feat[20] = pow(input_x[0], 1) * pow(input_x[1], 1) * pow(input_x[2], 1);
            idvg_poly_feat[21] = pow(input_x[0], 1) * pow(input_x[1], 1) * pow(input_x[3], 1);
            idvg_poly_feat[22] = pow(input_x[0], 1) * pow(input_x[2], 2);
            idvg_poly_feat[23] = pow(input_x[0], 1) * pow(input_x[2], 1) * pow(input_x[3], 1);
            idvg_poly_feat[24] = pow(input_x[0], 1) * pow(input_x[3], 2);
            idvg_poly_feat[25] = pow(input_x[1], 3);
            idvg_poly_feat[26] = pow(input_x[1], 2) * pow(input_x[2], 1);
            idvg_poly_feat[27] = pow(input_x[1], 2) * pow(input_x[3], 1);
            idvg_poly_feat[28] = pow(input_x[1], 1) * pow(input_x[2], 2);
            idvg_poly_feat[29] = pow(input_x[1], 1) * pow(input_x[2], 1) * pow(input_x[3], 1);
            idvg_poly_feat[30] = pow(input_x[1], 1) * pow(input_x[3], 2);
            idvg_poly_feat[31] = pow(input_x[2], 3);
            idvg_poly_feat[32] = pow(input_x[2], 2) * pow(input_x[3], 1);
            idvg_poly_feat[33] = pow(input_x[2], 1) * pow(input_x[3], 2);
            idvg_poly_feat[34] = pow(input_x[3], 3);
            idvg_poly_feat[35] = pow(input_x[0], 4);
            idvg_poly_feat[36] = pow(input_x[0], 3) * pow(input_x[1], 1);
            idvg_poly_feat[37] = pow(input_x[0], 3) * pow(input_x[2], 1);
            idvg_poly_feat[38] = pow(input_x[0], 3) * pow(input_x[3], 1);
            idvg_poly_feat[39] = pow(input_x[0], 2) * pow(input_x[1], 2);
            idvg_poly_feat[40] = pow(input_x[0], 2) * pow(input_x[1], 1) * pow(input_x[2], 1);
            idvg_poly_feat[41] = pow(input_x[0], 2) * pow(input_x[1], 1) * pow(input_x[3], 1);
            idvg_poly_feat[42] = pow(input_x[0], 2) * pow(input_x[2], 2);
            idvg_poly_feat[43] = pow(input_x[0], 2) * pow(input_x[2], 1) * pow(input_x[3], 1);
            idvg_poly_feat[44] = pow(input_x[0], 2) * pow(input_x[3], 2);
            idvg_poly_feat[45] = pow(input_x[0], 1) * pow(input_x[1], 3);
            idvg_poly_feat[46] = pow(input_x[0], 1) * pow(input_x[1], 2) * pow(input_x[2], 1);
            idvg_poly_feat[47] = pow(input_x[0], 1) * pow(input_x[1], 2) * pow(input_x[3], 1);
            idvg_poly_feat[48] = pow(input_x[0], 1) * pow(input_x[1], 1) * pow(input_x[2], 2);
            idvg_poly_feat[49] = pow(input_x[0], 1) * pow(input_x[1], 1) * pow(input_x[2], 1) * pow(input_x[3], 1);
            idvg_poly_feat[50] = pow(input_x[0], 1) * pow(input_x[1], 1) * pow(input_x[3], 2);
            idvg_poly_feat[51] = pow(input_x[0], 1) * pow(input_x[2], 3);
            idvg_poly_feat[52] = pow(input_x[0], 1) * pow(input_x[2], 2) * pow(input_x[3], 1);
            idvg_poly_feat[53] = pow(input_x[0], 1) * pow(input_x[2], 1) * pow(input_x[3], 2);
            idvg_poly_feat[54] = pow(input_x[0], 1) * pow(input_x[3], 3);
            idvg_poly_feat[55] = pow(input_x[1], 4);
            idvg_poly_feat[56] = pow(input_x[1], 3) * pow(input_x[2], 1);
            idvg_poly_feat[57] = pow(input_x[1], 3) * pow(input_x[3], 1);
            idvg_poly_feat[58] = pow(input_x[1], 2) * pow(input_x[2], 2);
            idvg_poly_feat[59] = pow(input_x[1], 2) * pow(input_x[2], 1) * pow(input_x[3], 1);
            idvg_poly_feat[60] = pow(input_x[1], 2) * pow(input_x[3], 2);
            idvg_poly_feat[61] = pow(input_x[1], 1) * pow(input_x[2], 3);
            idvg_poly_feat[62] = pow(input_x[1], 1) * pow(input_x[2], 2) * pow(input_x[3], 1);
            idvg_poly_feat[63] = pow(input_x[1], 1) * pow(input_x[2], 1) * pow(input_x[3], 2);
            idvg_poly_feat[64] = pow(input_x[1], 1) * pow(input_x[3], 3);
            idvg_poly_feat[65] = pow(input_x[2], 4);
            idvg_poly_feat[66] = pow(input_x[2], 3) * pow(input_x[3], 1);
            idvg_poly_feat[67] = pow(input_x[2], 2) * pow(input_x[3], 2);
            idvg_poly_feat[68] = pow(input_x[2], 1) * pow(input_x[3], 3);
            idvg_poly_feat[69] = pow(input_x[3], 4);
            idvg_poly_feat[70] = pow(input_x[0], 5);
            idvg_poly_feat[71] = pow(input_x[0], 4) * pow(input_x[1], 1);
            idvg_poly_feat[72] = pow(input_x[0], 4) * pow(input_x[2], 1);
            idvg_poly_feat[73] = pow(input_x[0], 4) * pow(input_x[3], 1);
            idvg_poly_feat[74] = pow(input_x[0], 3) * pow(input_x[1], 2);
            idvg_poly_feat[75] = pow(input_x[0], 3) * pow(input_x[1], 1) * pow(input_x[2], 1);
            idvg_poly_feat[76] = pow(input_x[0], 3) * pow(input_x[1], 1) * pow(input_x[3], 1);
            idvg_poly_feat[77] = pow(input_x[0], 3) * pow(input_x[2], 2);
            idvg_poly_feat[78] = pow(input_x[0], 3) * pow(input_x[2], 1) * pow(input_x[3], 1);
            idvg_poly_feat[79] = pow(input_x[0], 3) * pow(input_x[3], 2);
            idvg_poly_feat[80] = pow(input_x[0], 2) * pow(input_x[1], 3);
            idvg_poly_feat[81] = pow(input_x[0], 2) * pow(input_x[1], 2) * pow(input_x[2], 1);
            idvg_poly_feat[82] = pow(input_x[0], 2) * pow(input_x[1], 2) * pow(input_x[3], 1);
            idvg_poly_feat[83] = pow(input_x[0], 2) * pow(input_x[1], 1) * pow(input_x[2], 2);
            idvg_poly_feat[84] = pow(input_x[0], 2) * pow(input_x[1], 1) * pow(input_x[2], 1) * pow(input_x[3], 1);
            idvg_poly_feat[85] = pow(input_x[0], 2) * pow(input_x[1], 1) * pow(input_x[3], 2);
            idvg_poly_feat[86] = pow(input_x[0], 2) * pow(input_x[2], 3);
            idvg_poly_feat[87] = pow(input_x[0], 2) * pow(input_x[2], 2) * pow(input_x[3], 1);
            idvg_poly_feat[88] = pow(input_x[0], 2) * pow(input_x[2], 1) * pow(input_x[3], 2);
            idvg_poly_feat[89] = pow(input_x[0], 2) * pow(input_x[3], 3);
            idvg_poly_feat[90] = pow(input_x[0], 1) * pow(input_x[1], 4);
            idvg_poly_feat[91] = pow(input_x[0], 1) * pow(input_x[1], 3) * pow(input_x[2], 1);
            idvg_poly_feat[92] = pow(input_x[0], 1) * pow(input_x[1], 3) * pow(input_x[3], 1);
            idvg_poly_feat[93] = pow(input_x[0], 1) * pow(input_x[1], 2) * pow(input_x[2], 2);
            idvg_poly_feat[94] = pow(input_x[0], 1) * pow(input_x[1], 2) * pow(input_x[2], 1) * pow(input_x[3], 1);
            idvg_poly_feat[95] = pow(input_x[0], 1) * pow(input_x[1], 2) * pow(input_x[3], 2);
            idvg_poly_feat[96] = pow(input_x[0], 1) * pow(input_x[1], 1) * pow(input_x[2], 3);
            idvg_poly_feat[97] = pow(input_x[0], 1) * pow(input_x[1], 1) * pow(input_x[2], 2) * pow(input_x[3], 1);
            idvg_poly_feat[98] = pow(input_x[0], 1) * pow(input_x[1], 1) * pow(input_x[2], 1) * pow(input_x[3], 2);
            idvg_poly_feat[99] = pow(input_x[0], 1) * pow(input_x[1], 1) * pow(input_x[3], 3);
            idvg_poly_feat[100] = pow(input_x[0], 1) * pow(input_x[2], 4);
            idvg_poly_feat[101] = pow(input_x[0], 1) * pow(input_x[2], 3) * pow(input_x[3], 1);
            idvg_poly_feat[102] = pow(input_x[0], 1) * pow(input_x[2], 2) * pow(input_x[3], 2);
            idvg_poly_feat[103] = pow(input_x[0], 1) * pow(input_x[2], 1) * pow(input_x[3], 3);
            idvg_poly_feat[104] = pow(input_x[0], 1) * pow(input_x[3], 4);
            idvg_poly_feat[105] = pow(input_x[1], 5);
            idvg_poly_feat[106] = pow(input_x[1], 4) * pow(input_x[2], 1);
            idvg_poly_feat[107] = pow(input_x[1], 4) * pow(input_x[3], 1);
            idvg_poly_feat[108] = pow(input_x[1], 3) * pow(input_x[2], 2);
            idvg_poly_feat[109] = pow(input_x[1], 3) * pow(input_x[2], 1) * pow(input_x[3], 1);
            idvg_poly_feat[110] = pow(input_x[1], 3) * pow(input_x[3], 2);
            idvg_poly_feat[111] = pow(input_x[1], 2) * pow(input_x[2], 3);
            idvg_poly_feat[112] = pow(input_x[1], 2) * pow(input_x[2], 2) * pow(input_x[3], 1);
            idvg_poly_feat[113] = pow(input_x[1], 2) * pow(input_x[2], 1) * pow(input_x[3], 2);
            idvg_poly_feat[114] = pow(input_x[1], 2) * pow(input_x[3], 3);
            idvg_poly_feat[115] = pow(input_x[1], 1) * pow(input_x[2], 4);
            idvg_poly_feat[116] = pow(input_x[1], 1) * pow(input_x[2], 3) * pow(input_x[3], 1);
            idvg_poly_feat[117] = pow(input_x[1], 1) * pow(input_x[2], 2) * pow(input_x[3], 2);
            idvg_poly_feat[118] = pow(input_x[1], 1) * pow(input_x[2], 1) * pow(input_x[3], 3);
            idvg_poly_feat[119] = pow(input_x[1], 1) * pow(input_x[3], 4);
            idvg_poly_feat[120] = pow(input_x[2], 5);
            idvg_poly_feat[121] = pow(input_x[2], 4) * pow(input_x[3], 1);
            idvg_poly_feat[122] = pow(input_x[2], 3) * pow(input_x[3], 2);
            idvg_poly_feat[123] = pow(input_x[2], 2) * pow(input_x[3], 3);
            idvg_poly_feat[124] = pow(input_x[2], 1) * pow(input_x[3], 4);
            idvg_poly_feat[125] = pow(input_x[3], 5);
            idvg_poly_feat[126] = pow(input_x[0], 6);
            idvg_poly_feat[127] = pow(input_x[0], 5) * pow(input_x[1], 1);
            idvg_poly_feat[128] = pow(input_x[0], 5) * pow(input_x[2], 1);
            idvg_poly_feat[129] = pow(input_x[0], 5) * pow(input_x[3], 1);
            idvg_poly_feat[130] = pow(input_x[0], 4) * pow(input_x[1], 2);
            idvg_poly_feat[131] = pow(input_x[0], 4) * pow(input_x[1], 1) * pow(input_x[2], 1);
            idvg_poly_feat[132] = pow(input_x[0], 4) * pow(input_x[1], 1) * pow(input_x[3], 1);
            idvg_poly_feat[133] = pow(input_x[0], 4) * pow(input_x[2], 2);
            idvg_poly_feat[134] = pow(input_x[0], 4) * pow(input_x[2], 1) * pow(input_x[3], 1);
            idvg_poly_feat[135] = pow(input_x[0], 4) * pow(input_x[3], 2);
            idvg_poly_feat[136] = pow(input_x[0], 3) * pow(input_x[1], 3);
            idvg_poly_feat[137] = pow(input_x[0], 3) * pow(input_x[1], 2) * pow(input_x[2], 1);
            idvg_poly_feat[138] = pow(input_x[0], 3) * pow(input_x[1], 2) * pow(input_x[3], 1);
            idvg_poly_feat[139] = pow(input_x[0], 3) * pow(input_x[1], 1) * pow(input_x[2], 2);
            idvg_poly_feat[140] = pow(input_x[0], 3) * pow(input_x[1], 1) * pow(input_x[2], 1) * pow(input_x[3], 1);
            idvg_poly_feat[141] = pow(input_x[0], 3) * pow(input_x[1], 1) * pow(input_x[3], 2);
            idvg_poly_feat[142] = pow(input_x[0], 3) * pow(input_x[2], 3);
            idvg_poly_feat[143] = pow(input_x[0], 3) * pow(input_x[2], 2) * pow(input_x[3], 1);
            idvg_poly_feat[144] = pow(input_x[0], 3) * pow(input_x[2], 1) * pow(input_x[3], 2);
            idvg_poly_feat[145] = pow(input_x[0], 3) * pow(input_x[3], 3);
            idvg_poly_feat[146] = pow(input_x[0], 2) * pow(input_x[1], 4);
            idvg_poly_feat[147] = pow(input_x[0], 2) * pow(input_x[1], 3) * pow(input_x[2], 1);
            idvg_poly_feat[148] = pow(input_x[0], 2) * pow(input_x[1], 3) * pow(input_x[3], 1);
            idvg_poly_feat[149] = pow(input_x[0], 2) * pow(input_x[1], 2) * pow(input_x[2], 2);
            idvg_poly_feat[150] = pow(input_x[0], 2) * pow(input_x[1], 2) * pow(input_x[2], 1) * pow(input_x[3], 1);
            idvg_poly_feat[151] = pow(input_x[0], 2) * pow(input_x[1], 2) * pow(input_x[3], 2);
            idvg_poly_feat[152] = pow(input_x[0], 2) * pow(input_x[1], 1) * pow(input_x[2], 3);
            idvg_poly_feat[153] = pow(input_x[0], 2) * pow(input_x[1], 1) * pow(input_x[2], 2) * pow(input_x[3], 1);
            idvg_poly_feat[154] = pow(input_x[0], 2) * pow(input_x[1], 1) * pow(input_x[2], 1) * pow(input_x[3], 2);
            idvg_poly_feat[155] = pow(input_x[0], 2) * pow(input_x[1], 1) * pow(input_x[3], 3);
            idvg_poly_feat[156] = pow(input_x[0], 2) * pow(input_x[2], 4);
            idvg_poly_feat[157] = pow(input_x[0], 2) * pow(input_x[2], 3) * pow(input_x[3], 1);
            idvg_poly_feat[158] = pow(input_x[0], 2) * pow(input_x[2], 2) * pow(input_x[3], 2);
            idvg_poly_feat[159] = pow(input_x[0], 2) * pow(input_x[2], 1) * pow(input_x[3], 3);
            idvg_poly_feat[160] = pow(input_x[0], 2) * pow(input_x[3], 4);
            idvg_poly_feat[161] = pow(input_x[0], 1) * pow(input_x[1], 5);
            idvg_poly_feat[162] = pow(input_x[0], 1) * pow(input_x[1], 4) * pow(input_x[2], 1);
            idvg_poly_feat[163] = pow(input_x[0], 1) * pow(input_x[1], 4) * pow(input_x[3], 1);
            idvg_poly_feat[164] = pow(input_x[0], 1) * pow(input_x[1], 3) * pow(input_x[2], 2);
            idvg_poly_feat[165] = pow(input_x[0], 1) * pow(input_x[1], 3) * pow(input_x[2], 1) * pow(input_x[3], 1);
            idvg_poly_feat[166] = pow(input_x[0], 1) * pow(input_x[1], 3) * pow(input_x[3], 2);
            idvg_poly_feat[167] = pow(input_x[0], 1) * pow(input_x[1], 2) * pow(input_x[2], 3);
            idvg_poly_feat[168] = pow(input_x[0], 1) * pow(input_x[1], 2) * pow(input_x[2], 2) * pow(input_x[3], 1);
            idvg_poly_feat[169] = pow(input_x[0], 1) * pow(input_x[1], 2) * pow(input_x[2], 1) * pow(input_x[3], 2);
            idvg_poly_feat[170] = pow(input_x[0], 1) * pow(input_x[1], 2) * pow(input_x[3], 3);
            idvg_poly_feat[171] = pow(input_x[0], 1) * pow(input_x[1], 1) * pow(input_x[2], 4);
            idvg_poly_feat[172] = pow(input_x[0], 1) * pow(input_x[1], 1) * pow(input_x[2], 3) * pow(input_x[3], 1);
            idvg_poly_feat[173] = pow(input_x[0], 1) * pow(input_x[1], 1) * pow(input_x[2], 2) * pow(input_x[3], 2);
            idvg_poly_feat[174] = pow(input_x[0], 1) * pow(input_x[1], 1) * pow(input_x[2], 1) * pow(input_x[3], 3);
            idvg_poly_feat[175] = pow(input_x[0], 1) * pow(input_x[1], 1) * pow(input_x[3], 4);
            idvg_poly_feat[176] = pow(input_x[0], 1) * pow(input_x[2], 5);
            idvg_poly_feat[177] = pow(input_x[0], 1) * pow(input_x[2], 4) * pow(input_x[3], 1);
            idvg_poly_feat[178] = pow(input_x[0], 1) * pow(input_x[2], 3) * pow(input_x[3], 2);
            idvg_poly_feat[179] = pow(input_x[0], 1) * pow(input_x[2], 2) * pow(input_x[3], 3);
            idvg_poly_feat[180] = pow(input_x[0], 1) * pow(input_x[2], 1) * pow(input_x[3], 4);
            idvg_poly_feat[181] = pow(input_x[0], 1) * pow(input_x[3], 5);
            idvg_poly_feat[182] = pow(input_x[1], 6);
            idvg_poly_feat[183] = pow(input_x[1], 5) * pow(input_x[2], 1);
            idvg_poly_feat[184] = pow(input_x[1], 5) * pow(input_x[3], 1);
            idvg_poly_feat[185] = pow(input_x[1], 4) * pow(input_x[2], 2);
            idvg_poly_feat[186] = pow(input_x[1], 4) * pow(input_x[2], 1) * pow(input_x[3], 1);
            idvg_poly_feat[187] = pow(input_x[1], 4) * pow(input_x[3], 2);
            idvg_poly_feat[188] = pow(input_x[1], 3) * pow(input_x[2], 3);
            idvg_poly_feat[189] = pow(input_x[1], 3) * pow(input_x[2], 2) * pow(input_x[3], 1);
            idvg_poly_feat[190] = pow(input_x[1], 3) * pow(input_x[2], 1) * pow(input_x[3], 2);
            idvg_poly_feat[191] = pow(input_x[1], 3) * pow(input_x[3], 3);
            idvg_poly_feat[192] = pow(input_x[1], 2) * pow(input_x[2], 4);
            idvg_poly_feat[193] = pow(input_x[1], 2) * pow(input_x[2], 3) * pow(input_x[3], 1);
            idvg_poly_feat[194] = pow(input_x[1], 2) * pow(input_x[2], 2) * pow(input_x[3], 2);
            idvg_poly_feat[195] = pow(input_x[1], 2) * pow(input_x[2], 1) * pow(input_x[3], 3);
            idvg_poly_feat[196] = pow(input_x[1], 2) * pow(input_x[3], 4);
            idvg_poly_feat[197] = pow(input_x[1], 1) * pow(input_x[2], 5);
            idvg_poly_feat[198] = pow(input_x[1], 1) * pow(input_x[2], 4) * pow(input_x[3], 1);
            idvg_poly_feat[199] = pow(input_x[1], 1) * pow(input_x[2], 3) * pow(input_x[3], 2);
            idvg_poly_feat[200] = pow(input_x[1], 1) * pow(input_x[2], 2) * pow(input_x[3], 3);
            idvg_poly_feat[201] = pow(input_x[1], 1) * pow(input_x[2], 1) * pow(input_x[3], 4);
            idvg_poly_feat[202] = pow(input_x[1], 1) * pow(input_x[3], 5);
            idvg_poly_feat[203] = pow(input_x[2], 6);
            idvg_poly_feat[204] = pow(input_x[2], 5) * pow(input_x[3], 1);
            idvg_poly_feat[205] = pow(input_x[2], 4) * pow(input_x[3], 2);
            idvg_poly_feat[206] = pow(input_x[2], 3) * pow(input_x[3], 3);
            idvg_poly_feat[207] = pow(input_x[2], 2) * pow(input_x[3], 4);
            idvg_poly_feat[208] = pow(input_x[2], 1) * pow(input_x[3], 5);
            idvg_poly_feat[209] = pow(input_x[3], 6);
            idvg_poly_feat[210] = pow(input_x[0], 7);
            idvg_poly_feat[211] = pow(input_x[0], 6) * pow(input_x[1], 1);
            idvg_poly_feat[212] = pow(input_x[0], 6) * pow(input_x[2], 1);
            idvg_poly_feat[213] = pow(input_x[0], 6) * pow(input_x[3], 1);
            idvg_poly_feat[214] = pow(input_x[0], 5) * pow(input_x[1], 2);
            idvg_poly_feat[215] = pow(input_x[0], 5) * pow(input_x[1], 1) * pow(input_x[2], 1);
            idvg_poly_feat[216] = pow(input_x[0], 5) * pow(input_x[1], 1) * pow(input_x[3], 1);
            idvg_poly_feat[217] = pow(input_x[0], 5) * pow(input_x[2], 2);
            idvg_poly_feat[218] = pow(input_x[0], 5) * pow(input_x[2], 1) * pow(input_x[3], 1);
            idvg_poly_feat[219] = pow(input_x[0], 5) * pow(input_x[3], 2);
            idvg_poly_feat[220] = pow(input_x[0], 4) * pow(input_x[1], 3);
            idvg_poly_feat[221] = pow(input_x[0], 4) * pow(input_x[1], 2) * pow(input_x[2], 1);
            idvg_poly_feat[222] = pow(input_x[0], 4) * pow(input_x[1], 2) * pow(input_x[3], 1);
            idvg_poly_feat[223] = pow(input_x[0], 4) * pow(input_x[1], 1) * pow(input_x[2], 2);
            idvg_poly_feat[224] = pow(input_x[0], 4) * pow(input_x[1], 1) * pow(input_x[2], 1) * pow(input_x[3], 1);
            idvg_poly_feat[225] = pow(input_x[0], 4) * pow(input_x[1], 1) * pow(input_x[3], 2);
            idvg_poly_feat[226] = pow(input_x[0], 4) * pow(input_x[2], 3);
            idvg_poly_feat[227] = pow(input_x[0], 4) * pow(input_x[2], 2) * pow(input_x[3], 1);
            idvg_poly_feat[228] = pow(input_x[0], 4) * pow(input_x[2], 1) * pow(input_x[3], 2);
            idvg_poly_feat[229] = pow(input_x[0], 4) * pow(input_x[3], 3);
            idvg_poly_feat[230] = pow(input_x[0], 3) * pow(input_x[1], 4);
            idvg_poly_feat[231] = pow(input_x[0], 3) * pow(input_x[1], 3) * pow(input_x[2], 1);
            idvg_poly_feat[232] = pow(input_x[0], 3) * pow(input_x[1], 3) * pow(input_x[3], 1);
            idvg_poly_feat[233] = pow(input_x[0], 3) * pow(input_x[1], 2) * pow(input_x[2], 2);
            idvg_poly_feat[234] = pow(input_x[0], 3) * pow(input_x[1], 2) * pow(input_x[2], 1) * pow(input_x[3], 1);
            idvg_poly_feat[235] = pow(input_x[0], 3) * pow(input_x[1], 2) * pow(input_x[3], 2);
            idvg_poly_feat[236] = pow(input_x[0], 3) * pow(input_x[1], 1) * pow(input_x[2], 3);
            idvg_poly_feat[237] = pow(input_x[0], 3) * pow(input_x[1], 1) * pow(input_x[2], 2) * pow(input_x[3], 1);
            idvg_poly_feat[238] = pow(input_x[0], 3) * pow(input_x[1], 1) * pow(input_x[2], 1) * pow(input_x[3], 2);
            idvg_poly_feat[239] = pow(input_x[0], 3) * pow(input_x[1], 1) * pow(input_x[3], 3);
            idvg_poly_feat[240] = pow(input_x[0], 3) * pow(input_x[2], 4);
            idvg_poly_feat[241] = pow(input_x[0], 3) * pow(input_x[2], 3) * pow(input_x[3], 1);
            idvg_poly_feat[242] = pow(input_x[0], 3) * pow(input_x[2], 2) * pow(input_x[3], 2);
            idvg_poly_feat[243] = pow(input_x[0], 3) * pow(input_x[2], 1) * pow(input_x[3], 3);
            idvg_poly_feat[244] = pow(input_x[0], 3) * pow(input_x[3], 4);
            idvg_poly_feat[245] = pow(input_x[0], 2) * pow(input_x[1], 5);
            idvg_poly_feat[246] = pow(input_x[0], 2) * pow(input_x[1], 4) * pow(input_x[2], 1);
            idvg_poly_feat[247] = pow(input_x[0], 2) * pow(input_x[1], 4) * pow(input_x[3], 1);
            idvg_poly_feat[248] = pow(input_x[0], 2) * pow(input_x[1], 3) * pow(input_x[2], 2);
            idvg_poly_feat[249] = pow(input_x[0], 2) * pow(input_x[1], 3) * pow(input_x[2], 1) * pow(input_x[3], 1);
            idvg_poly_feat[250] = pow(input_x[0], 2) * pow(input_x[1], 3) * pow(input_x[3], 2);
            idvg_poly_feat[251] = pow(input_x[0], 2) * pow(input_x[1], 2) * pow(input_x[2], 3);
            idvg_poly_feat[252] = pow(input_x[0], 2) * pow(input_x[1], 2) * pow(input_x[2], 2) * pow(input_x[3], 1);
            idvg_poly_feat[253] = pow(input_x[0], 2) * pow(input_x[1], 2) * pow(input_x[2], 1) * pow(input_x[3], 2);
            idvg_poly_feat[254] = pow(input_x[0], 2) * pow(input_x[1], 2) * pow(input_x[3], 3);
            idvg_poly_feat[255] = pow(input_x[0], 2) * pow(input_x[1], 1) * pow(input_x[2], 4);
            idvg_poly_feat[256] = pow(input_x[0], 2) * pow(input_x[1], 1) * pow(input_x[2], 3) * pow(input_x[3], 1);
            idvg_poly_feat[257] = pow(input_x[0], 2) * pow(input_x[1], 1) * pow(input_x[2], 2) * pow(input_x[3], 2);
            idvg_poly_feat[258] = pow(input_x[0], 2) * pow(input_x[1], 1) * pow(input_x[2], 1) * pow(input_x[3], 3);
            idvg_poly_feat[259] = pow(input_x[0], 2) * pow(input_x[1], 1) * pow(input_x[3], 4);
            idvg_poly_feat[260] = pow(input_x[0], 2) * pow(input_x[2], 5);
            idvg_poly_feat[261] = pow(input_x[0], 2) * pow(input_x[2], 4) * pow(input_x[3], 1);
            idvg_poly_feat[262] = pow(input_x[0], 2) * pow(input_x[2], 3) * pow(input_x[3], 2);
            idvg_poly_feat[263] = pow(input_x[0], 2) * pow(input_x[2], 2) * pow(input_x[3], 3);
            idvg_poly_feat[264] = pow(input_x[0], 2) * pow(input_x[2], 1) * pow(input_x[3], 4);
            idvg_poly_feat[265] = pow(input_x[0], 2) * pow(input_x[3], 5);
            idvg_poly_feat[266] = pow(input_x[0], 1) * pow(input_x[1], 6);
            idvg_poly_feat[267] = pow(input_x[0], 1) * pow(input_x[1], 5) * pow(input_x[2], 1);
            idvg_poly_feat[268] = pow(input_x[0], 1) * pow(input_x[1], 5) * pow(input_x[3], 1);
            idvg_poly_feat[269] = pow(input_x[0], 1) * pow(input_x[1], 4) * pow(input_x[2], 2);
            idvg_poly_feat[270] = pow(input_x[0], 1) * pow(input_x[1], 4) * pow(input_x[2], 1) * pow(input_x[3], 1);
            idvg_poly_feat[271] = pow(input_x[0], 1) * pow(input_x[1], 4) * pow(input_x[3], 2);
            idvg_poly_feat[272] = pow(input_x[0], 1) * pow(input_x[1], 3) * pow(input_x[2], 3);
            idvg_poly_feat[273] = pow(input_x[0], 1) * pow(input_x[1], 3) * pow(input_x[2], 2) * pow(input_x[3], 1);
            idvg_poly_feat[274] = pow(input_x[0], 1) * pow(input_x[1], 3) * pow(input_x[2], 1) * pow(input_x[3], 2);
            idvg_poly_feat[275] = pow(input_x[0], 1) * pow(input_x[1], 3) * pow(input_x[3], 3);
            idvg_poly_feat[276] = pow(input_x[0], 1) * pow(input_x[1], 2) * pow(input_x[2], 4);
            idvg_poly_feat[277] = pow(input_x[0], 1) * pow(input_x[1], 2) * pow(input_x[2], 3) * pow(input_x[3], 1);
            idvg_poly_feat[278] = pow(input_x[0], 1) * pow(input_x[1], 2) * pow(input_x[2], 2) * pow(input_x[3], 2);
            idvg_poly_feat[279] = pow(input_x[0], 1) * pow(input_x[1], 2) * pow(input_x[2], 1) * pow(input_x[3], 3);
            idvg_poly_feat[280] = pow(input_x[0], 1) * pow(input_x[1], 2) * pow(input_x[3], 4);
            idvg_poly_feat[281] = pow(input_x[0], 1) * pow(input_x[1], 1) * pow(input_x[2], 5);
            idvg_poly_feat[282] = pow(input_x[0], 1) * pow(input_x[1], 1) * pow(input_x[2], 4) * pow(input_x[3], 1);
            idvg_poly_feat[283] = pow(input_x[0], 1) * pow(input_x[1], 1) * pow(input_x[2], 3) * pow(input_x[3], 2);
            idvg_poly_feat[284] = pow(input_x[0], 1) * pow(input_x[1], 1) * pow(input_x[2], 2) * pow(input_x[3], 3);
            idvg_poly_feat[285] = pow(input_x[0], 1) * pow(input_x[1], 1) * pow(input_x[2], 1) * pow(input_x[3], 4);
            idvg_poly_feat[286] = pow(input_x[0], 1) * pow(input_x[1], 1) * pow(input_x[3], 5);
            idvg_poly_feat[287] = pow(input_x[0], 1) * pow(input_x[2], 6);
            idvg_poly_feat[288] = pow(input_x[0], 1) * pow(input_x[2], 5) * pow(input_x[3], 1);
            idvg_poly_feat[289] = pow(input_x[0], 1) * pow(input_x[2], 4) * pow(input_x[3], 2);
            idvg_poly_feat[290] = pow(input_x[0], 1) * pow(input_x[2], 3) * pow(input_x[3], 3);
            idvg_poly_feat[291] = pow(input_x[0], 1) * pow(input_x[2], 2) * pow(input_x[3], 4);
            idvg_poly_feat[292] = pow(input_x[0], 1) * pow(input_x[2], 1) * pow(input_x[3], 5);
            idvg_poly_feat[293] = pow(input_x[0], 1) * pow(input_x[3], 6);
            idvg_poly_feat[294] = pow(input_x[1], 7);
            idvg_poly_feat[295] = pow(input_x[1], 6) * pow(input_x[2], 1);
            idvg_poly_feat[296] = pow(input_x[1], 6) * pow(input_x[3], 1);
            idvg_poly_feat[297] = pow(input_x[1], 5) * pow(input_x[2], 2);
            idvg_poly_feat[298] = pow(input_x[1], 5) * pow(input_x[2], 1) * pow(input_x[3], 1);
            idvg_poly_feat[299] = pow(input_x[1], 5) * pow(input_x[3], 2);
            idvg_poly_feat[300] = pow(input_x[1], 4) * pow(input_x[2], 3);
            idvg_poly_feat[301] = pow(input_x[1], 4) * pow(input_x[2], 2) * pow(input_x[3], 1);
            idvg_poly_feat[302] = pow(input_x[1], 4) * pow(input_x[2], 1) * pow(input_x[3], 2);
            idvg_poly_feat[303] = pow(input_x[1], 4) * pow(input_x[3], 3);
            idvg_poly_feat[304] = pow(input_x[1], 3) * pow(input_x[2], 4);
            idvg_poly_feat[305] = pow(input_x[1], 3) * pow(input_x[2], 3) * pow(input_x[3], 1);
            idvg_poly_feat[306] = pow(input_x[1], 3) * pow(input_x[2], 2) * pow(input_x[3], 2);
            idvg_poly_feat[307] = pow(input_x[1], 3) * pow(input_x[2], 1) * pow(input_x[3], 3);
            idvg_poly_feat[308] = pow(input_x[1], 3) * pow(input_x[3], 4);
            idvg_poly_feat[309] = pow(input_x[1], 2) * pow(input_x[2], 5);
            idvg_poly_feat[310] = pow(input_x[1], 2) * pow(input_x[2], 4) * pow(input_x[3], 1);
            idvg_poly_feat[311] = pow(input_x[1], 2) * pow(input_x[2], 3) * pow(input_x[3], 2);
            idvg_poly_feat[312] = pow(input_x[1], 2) * pow(input_x[2], 2) * pow(input_x[3], 3);
            idvg_poly_feat[313] = pow(input_x[1], 2) * pow(input_x[2], 1) * pow(input_x[3], 4);
            idvg_poly_feat[314] = pow(input_x[1], 2) * pow(input_x[3], 5);
            idvg_poly_feat[315] = pow(input_x[1], 1) * pow(input_x[2], 6);
            idvg_poly_feat[316] = pow(input_x[1], 1) * pow(input_x[2], 5) * pow(input_x[3], 1);
            idvg_poly_feat[317] = pow(input_x[1], 1) * pow(input_x[2], 4) * pow(input_x[3], 2);
            idvg_poly_feat[318] = pow(input_x[1], 1) * pow(input_x[2], 3) * pow(input_x[3], 3);
            idvg_poly_feat[319] = pow(input_x[1], 1) * pow(input_x[2], 2) * pow(input_x[3], 4);
            idvg_poly_feat[320] = pow(input_x[1], 1) * pow(input_x[2], 1) * pow(input_x[3], 5);
            idvg_poly_feat[321] = pow(input_x[1], 1) * pow(input_x[3], 6);
            idvg_poly_feat[322] = pow(input_x[2], 7);
            idvg_poly_feat[323] = pow(input_x[2], 6) * pow(input_x[3], 1);
            idvg_poly_feat[324] = pow(input_x[2], 5) * pow(input_x[3], 2);
            idvg_poly_feat[325] = pow(input_x[2], 4) * pow(input_x[3], 3);
            idvg_poly_feat[326] = pow(input_x[2], 3) * pow(input_x[3], 4);
            idvg_poly_feat[327] = pow(input_x[2], 2) * pow(input_x[3], 5);
            idvg_poly_feat[328] = pow(input_x[2], 1) * pow(input_x[3], 6);
            idvg_poly_feat[329] = pow(input_x[3], 7);
            idvg_poly_feat[330] = pow(input_x[0], 8);
            idvg_poly_feat[331] = pow(input_x[0], 7) * pow(input_x[1], 1);
            idvg_poly_feat[332] = pow(input_x[0], 7) * pow(input_x[2], 1);
            idvg_poly_feat[333] = pow(input_x[0], 7) * pow(input_x[3], 1);
            idvg_poly_feat[334] = pow(input_x[0], 6) * pow(input_x[1], 2);
            idvg_poly_feat[335] = pow(input_x[0], 6) * pow(input_x[1], 1) * pow(input_x[2], 1);
            idvg_poly_feat[336] = pow(input_x[0], 6) * pow(input_x[1], 1) * pow(input_x[3], 1);
            idvg_poly_feat[337] = pow(input_x[0], 6) * pow(input_x[2], 2);
            idvg_poly_feat[338] = pow(input_x[0], 6) * pow(input_x[2], 1) * pow(input_x[3], 1);
            idvg_poly_feat[339] = pow(input_x[0], 6) * pow(input_x[3], 2);
            idvg_poly_feat[340] = pow(input_x[0], 5) * pow(input_x[1], 3);
            idvg_poly_feat[341] = pow(input_x[0], 5) * pow(input_x[1], 2) * pow(input_x[2], 1);
            idvg_poly_feat[342] = pow(input_x[0], 5) * pow(input_x[1], 2) * pow(input_x[3], 1);
            idvg_poly_feat[343] = pow(input_x[0], 5) * pow(input_x[1], 1) * pow(input_x[2], 2);
            idvg_poly_feat[344] = pow(input_x[0], 5) * pow(input_x[1], 1) * pow(input_x[2], 1) * pow(input_x[3], 1);
            idvg_poly_feat[345] = pow(input_x[0], 5) * pow(input_x[1], 1) * pow(input_x[3], 2);
            idvg_poly_feat[346] = pow(input_x[0], 5) * pow(input_x[2], 3);
            idvg_poly_feat[347] = pow(input_x[0], 5) * pow(input_x[2], 2) * pow(input_x[3], 1);
            idvg_poly_feat[348] = pow(input_x[0], 5) * pow(input_x[2], 1) * pow(input_x[3], 2);
            idvg_poly_feat[349] = pow(input_x[0], 5) * pow(input_x[3], 3);
            idvg_poly_feat[350] = pow(input_x[0], 4) * pow(input_x[1], 4);
            idvg_poly_feat[351] = pow(input_x[0], 4) * pow(input_x[1], 3) * pow(input_x[2], 1);
            idvg_poly_feat[352] = pow(input_x[0], 4) * pow(input_x[1], 3) * pow(input_x[3], 1);
            idvg_poly_feat[353] = pow(input_x[0], 4) * pow(input_x[1], 2) * pow(input_x[2], 2);
            idvg_poly_feat[354] = pow(input_x[0], 4) * pow(input_x[1], 2) * pow(input_x[2], 1) * pow(input_x[3], 1);
            idvg_poly_feat[355] = pow(input_x[0], 4) * pow(input_x[1], 2) * pow(input_x[3], 2);
            idvg_poly_feat[356] = pow(input_x[0], 4) * pow(input_x[1], 1) * pow(input_x[2], 3);
            idvg_poly_feat[357] = pow(input_x[0], 4) * pow(input_x[1], 1) * pow(input_x[2], 2) * pow(input_x[3], 1);
            idvg_poly_feat[358] = pow(input_x[0], 4) * pow(input_x[1], 1) * pow(input_x[2], 1) * pow(input_x[3], 2);
            idvg_poly_feat[359] = pow(input_x[0], 4) * pow(input_x[1], 1) * pow(input_x[3], 3);
            idvg_poly_feat[360] = pow(input_x[0], 4) * pow(input_x[2], 4);
            idvg_poly_feat[361] = pow(input_x[0], 4) * pow(input_x[2], 3) * pow(input_x[3], 1);
            idvg_poly_feat[362] = pow(input_x[0], 4) * pow(input_x[2], 2) * pow(input_x[3], 2);
            idvg_poly_feat[363] = pow(input_x[0], 4) * pow(input_x[2], 1) * pow(input_x[3], 3);
            idvg_poly_feat[364] = pow(input_x[0], 4) * pow(input_x[3], 4);
            idvg_poly_feat[365] = pow(input_x[0], 3) * pow(input_x[1], 5);
            idvg_poly_feat[366] = pow(input_x[0], 3) * pow(input_x[1], 4) * pow(input_x[2], 1);
            idvg_poly_feat[367] = pow(input_x[0], 3) * pow(input_x[1], 4) * pow(input_x[3], 1);
            idvg_poly_feat[368] = pow(input_x[0], 3) * pow(input_x[1], 3) * pow(input_x[2], 2);
            idvg_poly_feat[369] = pow(input_x[0], 3) * pow(input_x[1], 3) * pow(input_x[2], 1) * pow(input_x[3], 1);
            idvg_poly_feat[370] = pow(input_x[0], 3) * pow(input_x[1], 3) * pow(input_x[3], 2);
            idvg_poly_feat[371] = pow(input_x[0], 3) * pow(input_x[1], 2) * pow(input_x[2], 3);
            idvg_poly_feat[372] = pow(input_x[0], 3) * pow(input_x[1], 2) * pow(input_x[2], 2) * pow(input_x[3], 1);
            idvg_poly_feat[373] = pow(input_x[0], 3) * pow(input_x[1], 2) * pow(input_x[2], 1) * pow(input_x[3], 2);
            idvg_poly_feat[374] = pow(input_x[0], 3) * pow(input_x[1], 2) * pow(input_x[3], 3);
            idvg_poly_feat[375] = pow(input_x[0], 3) * pow(input_x[1], 1) * pow(input_x[2], 4);
            idvg_poly_feat[376] = pow(input_x[0], 3) * pow(input_x[1], 1) * pow(input_x[2], 3) * pow(input_x[3], 1);
            idvg_poly_feat[377] = pow(input_x[0], 3) * pow(input_x[1], 1) * pow(input_x[2], 2) * pow(input_x[3], 2);
            idvg_poly_feat[378] = pow(input_x[0], 3) * pow(input_x[1], 1) * pow(input_x[2], 1) * pow(input_x[3], 3);
            idvg_poly_feat[379] = pow(input_x[0], 3) * pow(input_x[1], 1) * pow(input_x[3], 4);
            idvg_poly_feat[380] = pow(input_x[0], 3) * pow(input_x[2], 5);
            idvg_poly_feat[381] = pow(input_x[0], 3) * pow(input_x[2], 4) * pow(input_x[3], 1);
            idvg_poly_feat[382] = pow(input_x[0], 3) * pow(input_x[2], 3) * pow(input_x[3], 2);
            idvg_poly_feat[383] = pow(input_x[0], 3) * pow(input_x[2], 2) * pow(input_x[3], 3);
            idvg_poly_feat[384] = pow(input_x[0], 3) * pow(input_x[2], 1) * pow(input_x[3], 4);
            idvg_poly_feat[385] = pow(input_x[0], 3) * pow(input_x[3], 5);
            idvg_poly_feat[386] = pow(input_x[0], 2) * pow(input_x[1], 6);
            idvg_poly_feat[387] = pow(input_x[0], 2) * pow(input_x[1], 5) * pow(input_x[2], 1);
            idvg_poly_feat[388] = pow(input_x[0], 2) * pow(input_x[1], 5) * pow(input_x[3], 1);
            idvg_poly_feat[389] = pow(input_x[0], 2) * pow(input_x[1], 4) * pow(input_x[2], 2);
            idvg_poly_feat[390] = pow(input_x[0], 2) * pow(input_x[1], 4) * pow(input_x[2], 1) * pow(input_x[3], 1);
            idvg_poly_feat[391] = pow(input_x[0], 2) * pow(input_x[1], 4) * pow(input_x[3], 2);
            idvg_poly_feat[392] = pow(input_x[0], 2) * pow(input_x[1], 3) * pow(input_x[2], 3);
            idvg_poly_feat[393] = pow(input_x[0], 2) * pow(input_x[1], 3) * pow(input_x[2], 2) * pow(input_x[3], 1);
            idvg_poly_feat[394] = pow(input_x[0], 2) * pow(input_x[1], 3) * pow(input_x[2], 1) * pow(input_x[3], 2);
            idvg_poly_feat[395] = pow(input_x[0], 2) * pow(input_x[1], 3) * pow(input_x[3], 3);
            idvg_poly_feat[396] = pow(input_x[0], 2) * pow(input_x[1], 2) * pow(input_x[2], 4);
            idvg_poly_feat[397] = pow(input_x[0], 2) * pow(input_x[1], 2) * pow(input_x[2], 3) * pow(input_x[3], 1);
            idvg_poly_feat[398] = pow(input_x[0], 2) * pow(input_x[1], 2) * pow(input_x[2], 2) * pow(input_x[3], 2);
            idvg_poly_feat[399] = pow(input_x[0], 2) * pow(input_x[1], 2) * pow(input_x[2], 1) * pow(input_x[3], 3);
            idvg_poly_feat[400] = pow(input_x[0], 2) * pow(input_x[1], 2) * pow(input_x[3], 4);
            idvg_poly_feat[401] = pow(input_x[0], 2) * pow(input_x[1], 1) * pow(input_x[2], 5);
            idvg_poly_feat[402] = pow(input_x[0], 2) * pow(input_x[1], 1) * pow(input_x[2], 4) * pow(input_x[3], 1);
            idvg_poly_feat[403] = pow(input_x[0], 2) * pow(input_x[1], 1) * pow(input_x[2], 3) * pow(input_x[3], 2);
            idvg_poly_feat[404] = pow(input_x[0], 2) * pow(input_x[1], 1) * pow(input_x[2], 2) * pow(input_x[3], 3);
            idvg_poly_feat[405] = pow(input_x[0], 2) * pow(input_x[1], 1) * pow(input_x[2], 1) * pow(input_x[3], 4);
            idvg_poly_feat[406] = pow(input_x[0], 2) * pow(input_x[1], 1) * pow(input_x[3], 5);
            idvg_poly_feat[407] = pow(input_x[0], 2) * pow(input_x[2], 6);
            idvg_poly_feat[408] = pow(input_x[0], 2) * pow(input_x[2], 5) * pow(input_x[3], 1);
            idvg_poly_feat[409] = pow(input_x[0], 2) * pow(input_x[2], 4) * pow(input_x[3], 2);
            idvg_poly_feat[410] = pow(input_x[0], 2) * pow(input_x[2], 3) * pow(input_x[3], 3);
            idvg_poly_feat[411] = pow(input_x[0], 2) * pow(input_x[2], 2) * pow(input_x[3], 4);
            idvg_poly_feat[412] = pow(input_x[0], 2) * pow(input_x[2], 1) * pow(input_x[3], 5);
            idvg_poly_feat[413] = pow(input_x[0], 2) * pow(input_x[3], 6);
            idvg_poly_feat[414] = pow(input_x[0], 1) * pow(input_x[1], 7);
            idvg_poly_feat[415] = pow(input_x[0], 1) * pow(input_x[1], 6) * pow(input_x[2], 1);
            idvg_poly_feat[416] = pow(input_x[0], 1) * pow(input_x[1], 6) * pow(input_x[3], 1);
            idvg_poly_feat[417] = pow(input_x[0], 1) * pow(input_x[1], 5) * pow(input_x[2], 2);
            idvg_poly_feat[418] = pow(input_x[0], 1) * pow(input_x[1], 5) * pow(input_x[2], 1) * pow(input_x[3], 1);
            idvg_poly_feat[419] = pow(input_x[0], 1) * pow(input_x[1], 5) * pow(input_x[3], 2);
            idvg_poly_feat[420] = pow(input_x[0], 1) * pow(input_x[1], 4) * pow(input_x[2], 3);
            idvg_poly_feat[421] = pow(input_x[0], 1) * pow(input_x[1], 4) * pow(input_x[2], 2) * pow(input_x[3], 1);
            idvg_poly_feat[422] = pow(input_x[0], 1) * pow(input_x[1], 4) * pow(input_x[2], 1) * pow(input_x[3], 2);
            idvg_poly_feat[423] = pow(input_x[0], 1) * pow(input_x[1], 4) * pow(input_x[3], 3);
            idvg_poly_feat[424] = pow(input_x[0], 1) * pow(input_x[1], 3) * pow(input_x[2], 4);
            idvg_poly_feat[425] = pow(input_x[0], 1) * pow(input_x[1], 3) * pow(input_x[2], 3) * pow(input_x[3], 1);
            idvg_poly_feat[426] = pow(input_x[0], 1) * pow(input_x[1], 3) * pow(input_x[2], 2) * pow(input_x[3], 2);
            idvg_poly_feat[427] = pow(input_x[0], 1) * pow(input_x[1], 3) * pow(input_x[2], 1) * pow(input_x[3], 3);
            idvg_poly_feat[428] = pow(input_x[0], 1) * pow(input_x[1], 3) * pow(input_x[3], 4);
            idvg_poly_feat[429] = pow(input_x[0], 1) * pow(input_x[1], 2) * pow(input_x[2], 5);
            idvg_poly_feat[430] = pow(input_x[0], 1) * pow(input_x[1], 2) * pow(input_x[2], 4) * pow(input_x[3], 1);
            idvg_poly_feat[431] = pow(input_x[0], 1) * pow(input_x[1], 2) * pow(input_x[2], 3) * pow(input_x[3], 2);
            idvg_poly_feat[432] = pow(input_x[0], 1) * pow(input_x[1], 2) * pow(input_x[2], 2) * pow(input_x[3], 3);
            idvg_poly_feat[433] = pow(input_x[0], 1) * pow(input_x[1], 2) * pow(input_x[2], 1) * pow(input_x[3], 4);
            idvg_poly_feat[434] = pow(input_x[0], 1) * pow(input_x[1], 2) * pow(input_x[3], 5);
            idvg_poly_feat[435] = pow(input_x[0], 1) * pow(input_x[1], 1) * pow(input_x[2], 6);
            idvg_poly_feat[436] = pow(input_x[0], 1) * pow(input_x[1], 1) * pow(input_x[2], 5) * pow(input_x[3], 1);
            idvg_poly_feat[437] = pow(input_x[0], 1) * pow(input_x[1], 1) * pow(input_x[2], 4) * pow(input_x[3], 2);
            idvg_poly_feat[438] = pow(input_x[0], 1) * pow(input_x[1], 1) * pow(input_x[2], 3) * pow(input_x[3], 3);
            idvg_poly_feat[439] = pow(input_x[0], 1) * pow(input_x[1], 1) * pow(input_x[2], 2) * pow(input_x[3], 4);
            idvg_poly_feat[440] = pow(input_x[0], 1) * pow(input_x[1], 1) * pow(input_x[2], 1) * pow(input_x[3], 5);
            idvg_poly_feat[441] = pow(input_x[0], 1) * pow(input_x[1], 1) * pow(input_x[3], 6);
            idvg_poly_feat[442] = pow(input_x[0], 1) * pow(input_x[2], 7);
            idvg_poly_feat[443] = pow(input_x[0], 1) * pow(input_x[2], 6) * pow(input_x[3], 1);
            idvg_poly_feat[444] = pow(input_x[0], 1) * pow(input_x[2], 5) * pow(input_x[3], 2);
            idvg_poly_feat[445] = pow(input_x[0], 1) * pow(input_x[2], 4) * pow(input_x[3], 3);
            idvg_poly_feat[446] = pow(input_x[0], 1) * pow(input_x[2], 3) * pow(input_x[3], 4);
            idvg_poly_feat[447] = pow(input_x[0], 1) * pow(input_x[2], 2) * pow(input_x[3], 5);
            idvg_poly_feat[448] = pow(input_x[0], 1) * pow(input_x[2], 1) * pow(input_x[3], 6);
            idvg_poly_feat[449] = pow(input_x[0], 1) * pow(input_x[3], 7);
            idvg_poly_feat[450] = pow(input_x[1], 8);
            idvg_poly_feat[451] = pow(input_x[1], 7) * pow(input_x[2], 1);
            idvg_poly_feat[452] = pow(input_x[1], 7) * pow(input_x[3], 1);
            idvg_poly_feat[453] = pow(input_x[1], 6) * pow(input_x[2], 2);
            idvg_poly_feat[454] = pow(input_x[1], 6) * pow(input_x[2], 1) * pow(input_x[3], 1);
            idvg_poly_feat[455] = pow(input_x[1], 6) * pow(input_x[3], 2);
            idvg_poly_feat[456] = pow(input_x[1], 5) * pow(input_x[2], 3);
            idvg_poly_feat[457] = pow(input_x[1], 5) * pow(input_x[2], 2) * pow(input_x[3], 1);
            idvg_poly_feat[458] = pow(input_x[1], 5) * pow(input_x[2], 1) * pow(input_x[3], 2);
            idvg_poly_feat[459] = pow(input_x[1], 5) * pow(input_x[3], 3);
            idvg_poly_feat[460] = pow(input_x[1], 4) * pow(input_x[2], 4);
            idvg_poly_feat[461] = pow(input_x[1], 4) * pow(input_x[2], 3) * pow(input_x[3], 1);
            idvg_poly_feat[462] = pow(input_x[1], 4) * pow(input_x[2], 2) * pow(input_x[3], 2);
            idvg_poly_feat[463] = pow(input_x[1], 4) * pow(input_x[2], 1) * pow(input_x[3], 3);
            idvg_poly_feat[464] = pow(input_x[1], 4) * pow(input_x[3], 4);
            idvg_poly_feat[465] = pow(input_x[1], 3) * pow(input_x[2], 5);
            idvg_poly_feat[466] = pow(input_x[1], 3) * pow(input_x[2], 4) * pow(input_x[3], 1);
            idvg_poly_feat[467] = pow(input_x[1], 3) * pow(input_x[2], 3) * pow(input_x[3], 2);
            idvg_poly_feat[468] = pow(input_x[1], 3) * pow(input_x[2], 2) * pow(input_x[3], 3);
            idvg_poly_feat[469] = pow(input_x[1], 3) * pow(input_x[2], 1) * pow(input_x[3], 4);
            idvg_poly_feat[470] = pow(input_x[1], 3) * pow(input_x[3], 5);
            idvg_poly_feat[471] = pow(input_x[1], 2) * pow(input_x[2], 6);
            idvg_poly_feat[472] = pow(input_x[1], 2) * pow(input_x[2], 5) * pow(input_x[3], 1);
            idvg_poly_feat[473] = pow(input_x[1], 2) * pow(input_x[2], 4) * pow(input_x[3], 2);
            idvg_poly_feat[474] = pow(input_x[1], 2) * pow(input_x[2], 3) * pow(input_x[3], 3);
            idvg_poly_feat[475] = pow(input_x[1], 2) * pow(input_x[2], 2) * pow(input_x[3], 4);
            idvg_poly_feat[476] = pow(input_x[1], 2) * pow(input_x[2], 1) * pow(input_x[3], 5);
            idvg_poly_feat[477] = pow(input_x[1], 2) * pow(input_x[3], 6);
            idvg_poly_feat[478] = pow(input_x[1], 1) * pow(input_x[2], 7);
            idvg_poly_feat[479] = pow(input_x[1], 1) * pow(input_x[2], 6) * pow(input_x[3], 1);
            idvg_poly_feat[480] = pow(input_x[1], 1) * pow(input_x[2], 5) * pow(input_x[3], 2);
            idvg_poly_feat[481] = pow(input_x[1], 1) * pow(input_x[2], 4) * pow(input_x[3], 3);
            idvg_poly_feat[482] = pow(input_x[1], 1) * pow(input_x[2], 3) * pow(input_x[3], 4);
            idvg_poly_feat[483] = pow(input_x[1], 1) * pow(input_x[2], 2) * pow(input_x[3], 5);
            idvg_poly_feat[484] = pow(input_x[1], 1) * pow(input_x[2], 1) * pow(input_x[3], 6);
            idvg_poly_feat[485] = pow(input_x[1], 1) * pow(input_x[3], 7);
            idvg_poly_feat[486] = pow(input_x[2], 8);
            idvg_poly_feat[487] = pow(input_x[2], 7) * pow(input_x[3], 1);
            idvg_poly_feat[488] = pow(input_x[2], 6) * pow(input_x[3], 2);
            idvg_poly_feat[489] = pow(input_x[2], 5) * pow(input_x[3], 3);
            idvg_poly_feat[490] = pow(input_x[2], 4) * pow(input_x[3], 4);
            idvg_poly_feat[491] = pow(input_x[2], 3) * pow(input_x[3], 5);
            idvg_poly_feat[492] = pow(input_x[2], 2) * pow(input_x[3], 6);
            idvg_poly_feat[493] = pow(input_x[2], 1) * pow(input_x[3], 7);
            idvg_poly_feat[494] = pow(input_x[3], 8);
            for(i=0; i<7; i=i+1) begin
              tmp = idvg_poly_b[i];
              for(j=0; j<495; j=j+1) tmp = tmp + idvg_poly_w[i*495 + j] * idvg_poly_feat[j];
              idvg_z[i] = tmp * idvg_sl_mul[i] + idvg_sl_add[i];
            end
            for(i=0; i<151; i=i+1) begin
              tmp = idvg_ae_b0[i];
              for(j=0; j<7; j=j+1) tmp = tmp + idvg_ae_w0[i*7 + j] * idvg_z[j];
              idvg_h0[i] = (tmp > 0.0) ? tmp : 0.0;
            end
            for(i=0; i<603; i=i+1) begin
              tmp = idvg_ae_b1[i];
              for(j=0; j<151; j=j+1) tmp = tmp + idvg_ae_w1[i*151 + j] * idvg_h0[j];
              idvg_h1[i] = (tmp > 0.0) ? tmp : 0.0;
            end
            for(i=0; i<1206; i=i+1) begin
              tmp = idvg_ae_b2[i];
              for(j=0; j<603; j=j+1) tmp = tmp + idvg_ae_w2[i*603 + j] * idvg_h1[j];
              idvg_h2[i] = (tmp > 0.0) ? tmp : 0.0;
            end
            for(i=0; i<1206; i=i+1) begin
              tmp = idvg_ae_b3[i];
              for(j=0; j<1206; j=j+1) tmp = tmp + idvg_ae_w3[i*1206 + j] * idvg_h2[j];
              tmp = 1.0 / (1.0 + exp(-tmp));
              idvg_out[i] = -1.0 * (tmp * idvg_siv_mul[i] + idvg_siv_add[i]);
            end
          end

          val_vg = V(g, s);
          val_vd = V(d, s);
          vd_mag = sqrt(val_vd*val_vd + vds_sign_delta*vds_sign_delta);
          sign_vd = val_vd / vd_mag;

          // The ML data was trained for negative drain bias. Use |Vds| for the
          // surface lookup and apply the drain-current sign afterwards.

          // Id-Vd surface: 9 Vg anchors x 120 Vd samples
          if(val_vg <= -5.0) begin
            idvd_vg0_idx = 0;
            idvd_vg1_idx = 1;
            idvd_vg_frac = 0.0;
            idvd_excess = -5.0 - val_vg;
          end else if(val_vg >= 11.0) begin
            idvd_vg0_idx = 7;
            idvd_vg1_idx = 8;
            idvd_vg_frac = 1.0;
            idvd_excess = val_vg - 11.0;
          end else begin
            idvd_vg_pos = (val_vg + 5.0) / 2.0;
            idvd_vg0_idx = $rtoi(idvd_vg_pos);
            if(idvd_vg0_idx > 7) idvd_vg0_idx = 7;
            idvd_vg1_idx = idvd_vg0_idx + 1;
            idvd_vg_frac = idvd_vg_pos - idvd_vg0_idx;
            idvd_excess = 0.0;
          end

          if(vd_mag >= 12.0) begin
            idvd_vd0_idx = 0;
            idvd_vd1_idx = 1;
            idvd_vd_frac = 0.0;
          end else if(vd_mag > 0.02) begin
            idvd_vd_pos = (12.0 - vd_mag) / ((12.0 - 0.02) / 118.0);
            idvd_vd0_idx = $rtoi(idvd_vd_pos);
            if(idvd_vd0_idx > 117) idvd_vd0_idx = 117;
            idvd_vd1_idx = idvd_vd0_idx + 1;
            idvd_vd_frac = idvd_vd_pos - idvd_vd0_idx;
          end else begin
            idvd_vd0_idx = 118;
            idvd_vd1_idx = 119;
            idvd_vd_frac = (0.02 - vd_mag) / 0.02;
          end

          idvd_i00 = idvd_out[idvd_vg0_idx * 120 + idvd_vd0_idx];
          idvd_i01 = idvd_out[idvd_vg0_idx * 120 + idvd_vd1_idx];
          idvd_i10 = idvd_out[idvd_vg1_idx * 120 + idvd_vd0_idx];
          idvd_i11 = idvd_out[idvd_vg1_idx * 120 + idvd_vd1_idx];
          idvd_interp = (1.0 - idvd_vg_frac) * ((1.0 - idvd_vd_frac) * idvd_i00 + idvd_vd_frac * idvd_i01)
                      + idvd_vg_frac * ((1.0 - idvd_vd_frac) * idvd_i10 + idvd_vd_frac * idvd_i11);

          // Id-Vg surface: 6 Vd anchors x 201 Vg samples
          if(val_vg <= -5.0) begin
            idvg_vg0_idx = 0;
            idvg_vg1_idx = 1;
            idvg_vg_frac = 0.0;
          end else if(val_vg >= 12.0) begin
            idvg_vg0_idx = 199;
            idvg_vg1_idx = 200;
            idvg_vg_frac = 1.0;
          end else begin
            idvg_vg_pos = (val_vg + 5.0) / (17.0 / 200.0);
            idvg_vg0_idx = $rtoi(idvg_vg_pos);
            if(idvg_vg0_idx > 199) idvg_vg0_idx = 199;
            idvg_vg1_idx = idvg_vg0_idx + 1;
            idvg_vg_frac = idvg_vg_pos - idvg_vg0_idx;
          end

          if(vd_mag >= 11.0) begin
            idvg_vd0_idx = 0;
            idvg_vd1_idx = 1;
            idvg_vd_frac = 0.0;
            idvg_excess = vd_mag - 11.0;
          end else if(vd_mag <= 1.0) begin
            idvg_vd0_idx = 4;
            idvg_vd1_idx = 5;
            idvg_vd_frac = 1.0;
            idvg_excess = 1.0 - vd_mag;
          end else begin
            idvg_vd_pos = (11.0 - vd_mag) / 2.0;
            idvg_vd0_idx = $rtoi(idvg_vd_pos);
            if(idvg_vd0_idx > 4) idvg_vd0_idx = 4;
            idvg_vd1_idx = idvg_vd0_idx + 1;
            idvg_vd_frac = idvg_vd_pos - idvg_vd0_idx;
            idvg_excess = 0.0;
          end

          idvg_i00 = idvg_out[idvg_vd0_idx * 201 + idvg_vg0_idx];
          idvg_i01 = idvg_out[idvg_vd0_idx * 201 + idvg_vg1_idx];
          idvg_i10 = idvg_out[idvg_vd1_idx * 201 + idvg_vg0_idx];
          idvg_i11 = idvg_out[idvg_vd1_idx * 201 + idvg_vg1_idx];
          idvg_interp = (1.0 - idvg_vd_frac) * ((1.0 - idvg_vg_frac) * idvg_i00 + idvg_vg_frac * idvg_i01)
                      + idvg_vd_frac * ((1.0 - idvg_vg_frac) * idvg_i10 + idvg_vg_frac * idvg_i11);

          if(idvd_vg_frac < 0.5) idvd_vg_dist = 2.0 * idvd_vg_frac;
          else idvd_vg_dist = 2.0 * (1.0 - idvd_vg_frac);
          if(idvg_vd_frac < 0.5) idvg_vd_dist = 2.0 * idvg_vd_frac;
          else idvg_vd_dist = 2.0 * (1.0 - idvg_vd_frac);

          w_idvd = 1.0 / (0.05 + (idvd_vg_dist + 2.0 * idvd_excess) * (idvd_vg_dist + 2.0 * idvd_excess));
          w_idvg = 1.0 / (0.05 + (idvg_vd_dist + 2.0 * idvg_excess) * (idvg_vd_dist + 2.0 * idvg_excess));

          if(current_mode == 1) begin
            res_id_ref = idvd_interp;
          end else if(current_mode == 2) begin
            res_id_ref = idvg_interp;
          end else begin
            w_sum = w_idvd + w_idvg;
            if(w_sum > 0.0) res_id_ref = (w_idvd * idvd_interp + w_idvg * idvg_interp) / w_sum;
            else res_id_ref = 0.5 * (idvd_interp + idvg_interp);
          end

          I(d, s) <+ -sign_vd * res_id_ref;
          I(d, s) <+ gmin_ds * V(d, s);
        end
      endmodule
      fd = $fopen("/home/UFAD/tanvir.ahmed/Desktop/Verilog/DiamondFET/verilog_a/diamondfet_idvg_ae_b0.txt", "r");
      for(i=0; i<151; i=i+1) count_tmp = $fscanf(fd, "%e", idvg_ae_b0[i]);
      $fclose(fd);
      fd = $fopen("/home/UFAD/tanvir.ahmed/Desktop/Verilog/DiamondFET/verilog_a/diamondfet_idvg_ae_w1.txt", "r");
      for(i=0; i<91053; i=i+1) count_tmp = $fscanf(fd, "%e", idvg_ae_w1[i]);
      $fclose(fd);
      fd = $fopen("/home/UFAD/tanvir.ahmed/Desktop/Verilog/DiamondFET/verilog_a/diamondfet_idvg_ae_b1.txt", "r");
      for(i=0; i<603; i=i+1) count_tmp = $fscanf(fd, "%e", idvg_ae_b1[i]);
      $fclose(fd);
      fd = $fopen("/home/UFAD/tanvir.ahmed/Desktop/Verilog/DiamondFET/verilog_a/diamondfet_idvg_ae_w2.txt", "r");
      for(i=0; i<727218; i=i+1) count_tmp = $fscanf(fd, "%e", idvg_ae_w2[i]);
      $fclose(fd);
      fd = $fopen("/home/UFAD/tanvir.ahmed/Desktop/Verilog/DiamondFET/verilog_a/diamondfet_idvg_ae_b2.txt", "r");
      for(i=0; i<1206; i=i+1) count_tmp = $fscanf(fd, "%e", idvg_ae_b2[i]);
      $fclose(fd);
      fd = $fopen("/home/UFAD/tanvir.ahmed/Desktop/Verilog/DiamondFET/verilog_a/diamondfet_idvg_ae_w3.txt", "r");
      for(i=0; i<1454436; i=i+1) count_tmp = $fscanf(fd, "%e", idvg_ae_w3[i]);
      $fclose(fd);
      fd = $fopen("/home/UFAD/tanvir.ahmed/Desktop/Verilog/DiamondFET/verilog_a/diamondfet_idvg_ae_b3.txt", "r");
      for(i=0; i<1206; i=i+1) count_tmp = $fscanf(fd, "%e", idvg_ae_b3[i]);
      $fclose(fd);
      fd = $fopen("/home/UFAD/tanvir.ahmed/Desktop/Verilog/DiamondFET/verilog_a/diamondfet_idvd_sx_mul.txt", "r");
      for(i=0; i<4; i=i+1) count_tmp = $fscanf(fd, "%e", idvd_sx_mul[i]);
      $fclose(fd);
      fd = $fopen("/home/UFAD/tanvir.ahmed/Desktop/Verilog/DiamondFET/verilog_a/diamondfet_idvd_sx_add.txt", "r");
      for(i=0; i<4; i=i+1) count_tmp = $fscanf(fd, "%e", idvd_sx_add[i]);
      $fclose(fd);
      fd = $fopen("/home/UFAD/tanvir.ahmed/Desktop/Verilog/DiamondFET/verilog_a/diamondfet_idvd_sl_mul.txt", "r");
      for(i=0; i<5; i=i+1) count_tmp = $fscanf(fd, "%e", idvd_sl_mul[i]);
      $fclose(fd);
      fd = $fopen("/home/UFAD/tanvir.ahmed/Desktop/Verilog/DiamondFET/verilog_a/diamondfet_idvd_sl_add.txt", "r");
      for(i=0; i<5; i=i+1) count_tmp = $fscanf(fd, "%e", idvd_sl_add[i]);
      $fclose(fd);
      fd = $fopen("/home/UFAD/tanvir.ahmed/Desktop/Verilog/DiamondFET/verilog_a/diamondfet_idvd_siv_mul.txt", "r");
      for(i=0; i<1080; i=i+1) count_tmp = $fscanf(fd, "%e", idvd_siv_mul[i]);
      $fclose(fd);
      fd = $fopen("/home/UFAD/tanvir.ahmed/Desktop/Verilog/DiamondFET/verilog_a/diamondfet_idvd_siv_add.txt", "r");
      for(i=0; i<1080; i=i+1) count_tmp = $fscanf(fd, "%e", idvd_siv_add[i]);
      $fclose(fd);
      fd = $fopen("/home/UFAD/tanvir.ahmed/Desktop/Verilog/DiamondFET/verilog_a/diamondfet_idvg_sx_mul.txt", "r");
      for(i=0; i<4; i=i+1) count_tmp = $fscanf(fd, "%e", idvg_sx_mul[i]);
      $fclose(fd);
      fd = $fopen("/home/UFAD/tanvir.ahmed/Desktop/Verilog/DiamondFET/verilog_a/diamondfet_idvg_sx_add.txt", "r");
      for(i=0; i<4; i=i+1) count_tmp = $fscanf(fd, "%e", idvg_sx_add[i]);
      $fclose(fd);
      fd = $fopen("/home/UFAD/tanvir.ahmed/Desktop/Verilog/DiamondFET/verilog_a/diamondfet_idvg_sl_mul.txt", "r");
      for(i=0; i<7; i=i+1) count_tmp = $fscanf(fd, "%e", idvg_sl_mul[i]);
      $fclose(fd);
      fd = $fopen("/home/UFAD/tanvir.ahmed/Desktop/Verilog/DiamondFET/verilog_a/diamondfet_idvg_sl_add.txt", "r");
      for(i=0; i<7; i=i+1) count_tmp = $fscanf(fd, "%e", idvg_sl_add[i]);
      $fclose(fd);
      fd = $fopen("/home/UFAD/tanvir.ahmed/Desktop/Verilog/DiamondFET/verilog_a/diamondfet_idvg_siv_mul.txt", "r");
      for(i=0; i<1206; i=i+1) count_tmp = $fscanf(fd, "%e", idvg_siv_mul[i]);
      $fclose(fd);
      fd = $fopen("/home/UFAD/tanvir.ahmed/Desktop/Verilog/DiamondFET/verilog_a/diamondfet_idvg_siv_add.txt", "r");
      for(i=0; i<1206; i=i+1) count_tmp = $fscanf(fd, "%e", idvg_siv_add[i]);
      $fclose(fd);

      // Convert nm -> um before applying the learned input scalers.
      input_x[0] = (1.0e-3 * Lg) * idvd_sx_mul[0] + idvd_sx_add[0];
      input_x[1] = (1.0e-3 * Lgs) * idvd_sx_mul[1] + idvd_sx_add[1];
      input_x[2] = (1.0e-3 * Tox) * idvd_sx_mul[2] + idvd_sx_add[2];
      input_x[3] = Rc * idvd_sx_mul[3] + idvd_sx_add[3];
      idvd_poly_feat[0] = 1.0;
      idvd_poly_feat[1] = pow(input_x[0], 1);
      idvd_poly_feat[2] = pow(input_x[1], 1);
      idvd_poly_feat[3] = pow(input_x[2], 1);
      idvd_poly_feat[4] = pow(input_x[3], 1);
      idvd_poly_feat[5] = pow(input_x[0], 2);
      idvd_poly_feat[6] = pow(input_x[0], 1) * pow(input_x[1], 1);
      idvd_poly_feat[7] = pow(input_x[0], 1) * pow(input_x[2], 1);
      idvd_poly_feat[8] = pow(input_x[0], 1) * pow(input_x[3], 1);
      idvd_poly_feat[9] = pow(input_x[1], 2);
      idvd_poly_feat[10] = pow(input_x[1], 1) * pow(input_x[2], 1);
      idvd_poly_feat[11] = pow(input_x[1], 1) * pow(input_x[3], 1);
      idvd_poly_feat[12] = pow(input_x[2], 2);
      idvd_poly_feat[13] = pow(input_x[2], 1) * pow(input_x[3], 1);
      idvd_poly_feat[14] = pow(input_x[3], 2);
      idvd_poly_feat[15] = pow(input_x[0], 3);
      idvd_poly_feat[16] = pow(input_x[0], 2) * pow(input_x[1], 1);
      idvd_poly_feat[17] = pow(input_x[0], 2) * pow(input_x[2], 1);
      idvd_poly_feat[18] = pow(input_x[0], 2) * pow(input_x[3], 1);
      idvd_poly_feat[19] = pow(input_x[0], 1) * pow(input_x[1], 2);
      idvd_poly_feat[20] = pow(input_x[0], 1) * pow(input_x[1], 1) * pow(input_x[2], 1);
      idvd_poly_feat[21] = pow(input_x[0], 1) * pow(input_x[1], 1) * pow(input_x[3], 1);
      idvd_poly_feat[22] = pow(input_x[0], 1) * pow(input_x[2], 2);
      idvd_poly_feat[23] = pow(input_x[0], 1) * pow(input_x[2], 1) * pow(input_x[3], 1);
      idvd_poly_feat[24] = pow(input_x[0], 1) * pow(input_x[3], 2);
      idvd_poly_feat[25] = pow(input_x[1], 3);
      idvd_poly_feat[26] = pow(input_x[1], 2) * pow(input_x[2], 1);
      idvd_poly_feat[27] = pow(input_x[1], 2) * pow(input_x[3], 1);
      idvd_poly_feat[28] = pow(input_x[1], 1) * pow(input_x[2], 2);
      idvd_poly_feat[29] = pow(input_x[1], 1) * pow(input_x[2], 1) * pow(input_x[3], 1);
      idvd_poly_feat[30] = pow(input_x[1], 1) * pow(input_x[3], 2);
      idvd_poly_feat[31] = pow(input_x[2], 3);
      idvd_poly_feat[32] = pow(input_x[2], 2) * pow(input_x[3], 1);
      idvd_poly_feat[33] = pow(input_x[2], 1) * pow(input_x[3], 2);
      idvd_poly_feat[34] = pow(input_x[3], 3);
      idvd_poly_feat[35] = pow(input_x[0], 4);
      idvd_poly_feat[36] = pow(input_x[0], 3) * pow(input_x[1], 1);
      idvd_poly_feat[37] = pow(input_x[0], 3) * pow(input_x[2], 1);
      idvd_poly_feat[38] = pow(input_x[0], 3) * pow(input_x[3], 1);
      idvd_poly_feat[39] = pow(input_x[0], 2) * pow(input_x[1], 2);
      idvd_poly_feat[40] = pow(input_x[0], 2) * pow(input_x[1], 1) * pow(input_x[2], 1);
      idvd_poly_feat[41] = pow(input_x[0], 2) * pow(input_x[1], 1) * pow(input_x[3], 1);
      idvd_poly_feat[42] = pow(input_x[0], 2) * pow(input_x[2], 2);
      idvd_poly_feat[43] = pow(input_x[0], 2) * pow(input_x[2], 1) * pow(input_x[3], 1);
      idvd_poly_feat[44] = pow(input_x[0], 2) * pow(input_x[3], 2);
      idvd_poly_feat[45] = pow(input_x[0], 1) * pow(input_x[1], 3);
      idvd_poly_feat[46] = pow(input_x[0], 1) * pow(input_x[1], 2) * pow(input_x[2], 1);
      idvd_poly_feat[47] = pow(input_x[0], 1) * pow(input_x[1], 2) * pow(input_x[3], 1);
      idvd_poly_feat[48] = pow(input_x[0], 1) * pow(input_x[1], 1) * pow(input_x[2], 2);
      idvd_poly_feat[49] = pow(input_x[0], 1) * pow(input_x[1], 1) * pow(input_x[2], 1) * pow(input_x[3], 1);
      idvd_poly_feat[50] = pow(input_x[0], 1) * pow(input_x[1], 1) * pow(input_x[3], 2);
      idvd_poly_feat[51] = pow(input_x[0], 1) * pow(input_x[2], 3);
      idvd_poly_feat[52] = pow(input_x[0], 1) * pow(input_x[2], 2) * pow(input_x[3], 1);
      idvd_poly_feat[53] = pow(input_x[0], 1) * pow(input_x[2], 1) * pow(input_x[3], 2);
      idvd_poly_feat[54] = pow(input_x[0], 1) * pow(input_x[3], 3);
      idvd_poly_feat[55] = pow(input_x[1], 4);
      idvd_poly_feat[56] = pow(input_x[1], 3) * pow(input_x[2], 1);
      idvd_poly_feat[57] = pow(input_x[1], 3) * pow(input_x[3], 1);
      idvd_poly_feat[58] = pow(input_x[1], 2) * pow(input_x[2], 2);
      idvd_poly_feat[59] = pow(input_x[1], 2) * pow(input_x[2], 1) * pow(input_x[3], 1);
      idvd_poly_feat[60] = pow(input_x[1], 2) * pow(input_x[3], 2);
      idvd_poly_feat[61] = pow(input_x[1], 1) * pow(input_x[2], 3);
      idvd_poly_feat[62] = pow(input_x[1], 1) * pow(input_x[2], 2) * pow(input_x[3], 1);
      idvd_poly_feat[63] = pow(input_x[1], 1) * pow(input_x[2], 1) * pow(input_x[3], 2);
      idvd_poly_feat[64] = pow(input_x[1], 1) * pow(input_x[3], 3);
      idvd_poly_feat[65] = pow(input_x[2], 4);
      idvd_poly_feat[66] = pow(input_x[2], 3) * pow(input_x[3], 1);
      idvd_poly_feat[67] = pow(input_x[2], 2) * pow(input_x[3], 2);
      idvd_poly_feat[68] = pow(input_x[2], 1) * pow(input_x[3], 3);
      idvd_poly_feat[69] = pow(input_x[3], 4);
      idvd_poly_feat[70] = pow(input_x[0], 5);
      idvd_poly_feat[71] = pow(input_x[0], 4) * pow(input_x[1], 1);
      idvd_poly_feat[72] = pow(input_x[0], 4) * pow(input_x[2], 1);
      idvd_poly_feat[73] = pow(input_x[0], 4) * pow(input_x[3], 1);
      idvd_poly_feat[74] = pow(input_x[0], 3) * pow(input_x[1], 2);
      idvd_poly_feat[75] = pow(input_x[0], 3) * pow(input_x[1], 1) * pow(input_x[2], 1);
      idvd_poly_feat[76] = pow(input_x[0], 3) * pow(input_x[1], 1) * pow(input_x[3], 1);
      idvd_poly_feat[77] = pow(input_x[0], 3) * pow(input_x[2], 2);
      idvd_poly_feat[78] = pow(input_x[0], 3) * pow(input_x[2], 1) * pow(input_x[3], 1);
      idvd_poly_feat[79] = pow(input_x[0], 3) * pow(input_x[3], 2);
      idvd_poly_feat[80] = pow(input_x[0], 2) * pow(input_x[1], 3);
      idvd_poly_feat[81] = pow(input_x[0], 2) * pow(input_x[1], 2) * pow(input_x[2], 1);
      idvd_poly_feat[82] = pow(input_x[0], 2) * pow(input_x[1], 2) * pow(input_x[3], 1);
      idvd_poly_feat[83] = pow(input_x[0], 2) * pow(input_x[1], 1) * pow(input_x[2], 2);
      idvd_poly_feat[84] = pow(input_x[0], 2) * pow(input_x[1], 1) * pow(input_x[2], 1) * pow(input_x[3], 1);
      idvd_poly_feat[85] = pow(input_x[0], 2) * pow(input_x[1], 1) * pow(input_x[3], 2);
      idvd_poly_feat[86] = pow(input_x[0], 2) * pow(input_x[2], 3);
      idvd_poly_feat[87] = pow(input_x[0], 2) * pow(input_x[2], 2) * pow(input_x[3], 1);
      idvd_poly_feat[88] = pow(input_x[0], 2) * pow(input_x[2], 1) * pow(input_x[3], 2);
      idvd_poly_feat[89] = pow(input_x[0], 2) * pow(input_x[3], 3);
      idvd_poly_feat[90] = pow(input_x[0], 1) * pow(input_x[1], 4);
      idvd_poly_feat[91] = pow(input_x[0], 1) * pow(input_x[1], 3) * pow(input_x[2], 1);
      idvd_poly_feat[92] = pow(input_x[0], 1) * pow(input_x[1], 3) * pow(input_x[3], 1);
      idvd_poly_feat[93] = pow(input_x[0], 1) * pow(input_x[1], 2) * pow(input_x[2], 2);
      idvd_poly_feat[94] = pow(input_x[0], 1) * pow(input_x[1], 2) * pow(input_x[2], 1) * pow(input_x[3], 1);
      idvd_poly_feat[95] = pow(input_x[0], 1) * pow(input_x[1], 2) * pow(input_x[3], 2);
      idvd_poly_feat[96] = pow(input_x[0], 1) * pow(input_x[1], 1) * pow(input_x[2], 3);
      idvd_poly_feat[97] = pow(input_x[0], 1) * pow(input_x[1], 1) * pow(input_x[2], 2) * pow(input_x[3], 1);
      idvd_poly_feat[98] = pow(input_x[0], 1) * pow(input_x[1], 1) * pow(input_x[2], 1) * pow(input_x[3], 2);
      idvd_poly_feat[99] = pow(input_x[0], 1) * pow(input_x[1], 1) * pow(input_x[3], 3);
      idvd_poly_feat[100] = pow(input_x[0], 1) * pow(input_x[2], 4);
      idvd_poly_feat[101] = pow(input_x[0], 1) * pow(input_x[2], 3) * pow(input_x[3], 1);
      idvd_poly_feat[102] = pow(input_x[0], 1) * pow(input_x[2], 2) * pow(input_x[3], 2);
      idvd_poly_feat[103] = pow(input_x[0], 1) * pow(input_x[2], 1) * pow(input_x[3], 3);
      idvd_poly_feat[104] = pow(input_x[0], 1) * pow(input_x[3], 4);
      idvd_poly_feat[105] = pow(input_x[1], 5);
      idvd_poly_feat[106] = pow(input_x[1], 4) * pow(input_x[2], 1);
      idvd_poly_feat[107] = pow(input_x[1], 4) * pow(input_x[3], 1);
      idvd_poly_feat[108] = pow(input_x[1], 3) * pow(input_x[2], 2);
      idvd_poly_feat[109] = pow(input_x[1], 3) * pow(input_x[2], 1) * pow(input_x[3], 1);
      idvd_poly_feat[110] = pow(input_x[1], 3) * pow(input_x[3], 2);
      idvd_poly_feat[111] = pow(input_x[1], 2) * pow(input_x[2], 3);
      idvd_poly_feat[112] = pow(input_x[1], 2) * pow(input_x[2], 2) * pow(input_x[3], 1);
      idvd_poly_feat[113] = pow(input_x[1], 2) * pow(input_x[2], 1) * pow(input_x[3], 2);
      idvd_poly_feat[114] = pow(input_x[1], 2) * pow(input_x[3], 3);
      idvd_poly_feat[115] = pow(input_x[1], 1) * pow(input_x[2], 4);
      idvd_poly_feat[116] = pow(input_x[1], 1) * pow(input_x[2], 3) * pow(input_x[3], 1);
      idvd_poly_feat[117] = pow(input_x[1], 1) * pow(input_x[2], 2) * pow(input_x[3], 2);
      idvd_poly_feat[118] = pow(input_x[1], 1) * pow(input_x[2], 1) * pow(input_x[3], 3);
      idvd_poly_feat[119] = pow(input_x[1], 1) * pow(input_x[3], 4);
      idvd_poly_feat[120] = pow(input_x[2], 5);
      idvd_poly_feat[121] = pow(input_x[2], 4) * pow(input_x[3], 1);
      idvd_poly_feat[122] = pow(input_x[2], 3) * pow(input_x[3], 2);
      idvd_poly_feat[123] = pow(input_x[2], 2) * pow(input_x[3], 3);
      idvd_poly_feat[124] = pow(input_x[2], 1) * pow(input_x[3], 4);
      idvd_poly_feat[125] = pow(input_x[3], 5);
      idvd_poly_feat[126] = pow(input_x[0], 6);
      idvd_poly_feat[127] = pow(input_x[0], 5) * pow(input_x[1], 1);
      idvd_poly_feat[128] = pow(input_x[0], 5) * pow(input_x[2], 1);
      idvd_poly_feat[129] = pow(input_x[0], 5) * pow(input_x[3], 1);
      idvd_poly_feat[130] = pow(input_x[0], 4) * pow(input_x[1], 2);
      idvd_poly_feat[131] = pow(input_x[0], 4) * pow(input_x[1], 1) * pow(input_x[2], 1);
      idvd_poly_feat[132] = pow(input_x[0], 4) * pow(input_x[1], 1) * pow(input_x[3], 1);
      idvd_poly_feat[133] = pow(input_x[0], 4) * pow(input_x[2], 2);
      idvd_poly_feat[134] = pow(input_x[0], 4) * pow(input_x[2], 1) * pow(input_x[3], 1);
      idvd_poly_feat[135] = pow(input_x[0], 4) * pow(input_x[3], 2);
      idvd_poly_feat[136] = pow(input_x[0], 3) * pow(input_x[1], 3);
      idvd_poly_feat[137] = pow(input_x[0], 3) * pow(input_x[1], 2) * pow(input_x[2], 1);
      idvd_poly_feat[138] = pow(input_x[0], 3) * pow(input_x[1], 2) * pow(input_x[3], 1);
      idvd_poly_feat[139] = pow(input_x[0], 3) * pow(input_x[1], 1) * pow(input_x[2], 2);
      idvd_poly_feat[140] = pow(input_x[0], 3) * pow(input_x[1], 1) * pow(input_x[2], 1) * pow(input_x[3], 1);
      idvd_poly_feat[141] = pow(input_x[0], 3) * pow(input_x[1], 1) * pow(input_x[3], 2);
      idvd_poly_feat[142] = pow(input_x[0], 3) * pow(input_x[2], 3);
      idvd_poly_feat[143] = pow(input_x[0], 3) * pow(input_x[2], 2) * pow(input_x[3], 1);
      idvd_poly_feat[144] = pow(input_x[0], 3) * pow(input_x[2], 1) * pow(input_x[3], 2);
      idvd_poly_feat[145] = pow(input_x[0], 3) * pow(input_x[3], 3);
      idvd_poly_feat[146] = pow(input_x[0], 2) * pow(input_x[1], 4);
      idvd_poly_feat[147] = pow(input_x[0], 2) * pow(input_x[1], 3) * pow(input_x[2], 1);
      idvd_poly_feat[148] = pow(input_x[0], 2) * pow(input_x[1], 3) * pow(input_x[3], 1);
      idvd_poly_feat[149] = pow(input_x[0], 2) * pow(input_x[1], 2) * pow(input_x[2], 2);
      idvd_poly_feat[150] = pow(input_x[0], 2) * pow(input_x[1], 2) * pow(input_x[2], 1) * pow(input_x[3], 1);
      idvd_poly_feat[151] = pow(input_x[0], 2) * pow(input_x[1], 2) * pow(input_x[3], 2);
      idvd_poly_feat[152] = pow(input_x[0], 2) * pow(input_x[1], 1) * pow(input_x[2], 3);
      idvd_poly_feat[153] = pow(input_x[0], 2) * pow(input_x[1], 1) * pow(input_x[2], 2) * pow(input_x[3], 1);
      idvd_poly_feat[154] = pow(input_x[0], 2) * pow(input_x[1], 1) * pow(input_x[2], 1) * pow(input_x[3], 2);
      idvd_poly_feat[155] = pow(input_x[0], 2) * pow(input_x[1], 1) * pow(input_x[3], 3);
      idvd_poly_feat[156] = pow(input_x[0], 2) * pow(input_x[2], 4);
      idvd_poly_feat[157] = pow(input_x[0], 2) * pow(input_x[2], 3) * pow(input_x[3], 1);
      idvd_poly_feat[158] = pow(input_x[0], 2) * pow(input_x[2], 2) * pow(input_x[3], 2);
      idvd_poly_feat[159] = pow(input_x[0], 2) * pow(input_x[2], 1) * pow(input_x[3], 3);
      idvd_poly_feat[160] = pow(input_x[0], 2) * pow(input_x[3], 4);
      idvd_poly_feat[161] = pow(input_x[0], 1) * pow(input_x[1], 5);
      idvd_poly_feat[162] = pow(input_x[0], 1) * pow(input_x[1], 4) * pow(input_x[2], 1);
      idvd_poly_feat[163] = pow(input_x[0], 1) * pow(input_x[1], 4) * pow(input_x[3], 1);
      idvd_poly_feat[164] = pow(input_x[0], 1) * pow(input_x[1], 3) * pow(input_x[2], 2);
      idvd_poly_feat[165] = pow(input_x[0], 1) * pow(input_x[1], 3) * pow(input_x[2], 1) * pow(input_x[3], 1);
      idvd_poly_feat[166] = pow(input_x[0], 1) * pow(input_x[1], 3) * pow(input_x[3], 2);
      idvd_poly_feat[167] = pow(input_x[0], 1) * pow(input_x[1], 2) * pow(input_x[2], 3);
      idvd_poly_feat[168] = pow(input_x[0], 1) * pow(input_x[1], 2) * pow(input_x[2], 2) * pow(input_x[3], 1);
      idvd_poly_feat[169] = pow(input_x[0], 1) * pow(input_x[1], 2) * pow(input_x[2], 1) * pow(input_x[3], 2);
      idvd_poly_feat[170] = pow(input_x[0], 1) * pow(input_x[1], 2) * pow(input_x[3], 3);
      idvd_poly_feat[171] = pow(input_x[0], 1) * pow(input_x[1], 1) * pow(input_x[2], 4);
      idvd_poly_feat[172] = pow(input_x[0], 1) * pow(input_x[1], 1) * pow(input_x[2], 3) * pow(input_x[3], 1);
      idvd_poly_feat[173] = pow(input_x[0], 1) * pow(input_x[1], 1) * pow(input_x[2], 2) * pow(input_x[3], 2);
      idvd_poly_feat[174] = pow(input_x[0], 1) * pow(input_x[1], 1) * pow(input_x[2], 1) * pow(input_x[3], 3);
      idvd_poly_feat[175] = pow(input_x[0], 1) * pow(input_x[1], 1) * pow(input_x[3], 4);
      idvd_poly_feat[176] = pow(input_x[0], 1) * pow(input_x[2], 5);
      idvd_poly_feat[177] = pow(input_x[0], 1) * pow(input_x[2], 4) * pow(input_x[3], 1);
      idvd_poly_feat[178] = pow(input_x[0], 1) * pow(input_x[2], 3) * pow(input_x[3], 2);
      idvd_poly_feat[179] = pow(input_x[0], 1) * pow(input_x[2], 2) * pow(input_x[3], 3);
      idvd_poly_feat[180] = pow(input_x[0], 1) * pow(input_x[2], 1) * pow(input_x[3], 4);
      idvd_poly_feat[181] = pow(input_x[0], 1) * pow(input_x[3], 5);
      idvd_poly_feat[182] = pow(input_x[1], 6);
      idvd_poly_feat[183] = pow(input_x[1], 5) * pow(input_x[2], 1);
      idvd_poly_feat[184] = pow(input_x[1], 5) * pow(input_x[3], 1);
      idvd_poly_feat[185] = pow(input_x[1], 4) * pow(input_x[2], 2);
      idvd_poly_feat[186] = pow(input_x[1], 4) * pow(input_x[2], 1) * pow(input_x[3], 1);
      idvd_poly_feat[187] = pow(input_x[1], 4) * pow(input_x[3], 2);
      idvd_poly_feat[188] = pow(input_x[1], 3) * pow(input_x[2], 3);
      idvd_poly_feat[189] = pow(input_x[1], 3) * pow(input_x[2], 2) * pow(input_x[3], 1);
      idvd_poly_feat[190] = pow(input_x[1], 3) * pow(input_x[2], 1) * pow(input_x[3], 2);
      idvd_poly_feat[191] = pow(input_x[1], 3) * pow(input_x[3], 3);
      idvd_poly_feat[192] = pow(input_x[1], 2) * pow(input_x[2], 4);
      idvd_poly_feat[193] = pow(input_x[1], 2) * pow(input_x[2], 3) * pow(input_x[3], 1);
      idvd_poly_feat[194] = pow(input_x[1], 2) * pow(input_x[2], 2) * pow(input_x[3], 2);
      idvd_poly_feat[195] = pow(input_x[1], 2) * pow(input_x[2], 1) * pow(input_x[3], 3);
      idvd_poly_feat[196] = pow(input_x[1], 2) * pow(input_x[3], 4);
      idvd_poly_feat[197] = pow(input_x[1], 1) * pow(input_x[2], 5);
      idvd_poly_feat[198] = pow(input_x[1], 1) * pow(input_x[2], 4) * pow(input_x[3], 1);
      idvd_poly_feat[199] = pow(input_x[1], 1) * pow(input_x[2], 3) * pow(input_x[3], 2);
      idvd_poly_feat[200] = pow(input_x[1], 1) * pow(input_x[2], 2) * pow(input_x[3], 3);
      idvd_poly_feat[201] = pow(input_x[1], 1) * pow(input_x[2], 1) * pow(input_x[3], 4);
      idvd_poly_feat[202] = pow(input_x[1], 1) * pow(input_x[3], 5);
      idvd_poly_feat[203] = pow(input_x[2], 6);
      idvd_poly_feat[204] = pow(input_x[2], 5) * pow(input_x[3], 1);
      idvd_poly_feat[205] = pow(input_x[2], 4) * pow(input_x[3], 2);
      idvd_poly_feat[206] = pow(input_x[2], 3) * pow(input_x[3], 3);
      idvd_poly_feat[207] = pow(input_x[2], 2) * pow(input_x[3], 4);
      idvd_poly_feat[208] = pow(input_x[2], 1) * pow(input_x[3], 5);
      idvd_poly_feat[209] = pow(input_x[3], 6);
      idvd_poly_feat[210] = pow(input_x[0], 7);
      idvd_poly_feat[211] = pow(input_x[0], 6) * pow(input_x[1], 1);
      idvd_poly_feat[212] = pow(input_x[0], 6) * pow(input_x[2], 1);
      idvd_poly_feat[213] = pow(input_x[0], 6) * pow(input_x[3], 1);
      idvd_poly_feat[214] = pow(input_x[0], 5) * pow(input_x[1], 2);
      idvd_poly_feat[215] = pow(input_x[0], 5) * pow(input_x[1], 1) * pow(input_x[2], 1);
      idvd_poly_feat[216] = pow(input_x[0], 5) * pow(input_x[1], 1) * pow(input_x[3], 1);
      idvd_poly_feat[217] = pow(input_x[0], 5) * pow(input_x[2], 2);
      idvd_poly_feat[218] = pow(input_x[0], 5) * pow(input_x[2], 1) * pow(input_x[3], 1);
      idvd_poly_feat[219] = pow(input_x[0], 5) * pow(input_x[3], 2);
      idvd_poly_feat[220] = pow(input_x[0], 4) * pow(input_x[1], 3);
      idvd_poly_feat[221] = pow(input_x[0], 4) * pow(input_x[1], 2) * pow(input_x[2], 1);
      idvd_poly_feat[222] = pow(input_x[0], 4) * pow(input_x[1], 2) * pow(input_x[3], 1);
      idvd_poly_feat[223] = pow(input_x[0], 4) * pow(input_x[1], 1) * pow(input_x[2], 2);
      idvd_poly_feat[224] = pow(input_x[0], 4) * pow(input_x[1], 1) * pow(input_x[2], 1) * pow(input_x[3], 1);
      idvd_poly_feat[225] = pow(input_x[0], 4) * pow(input_x[1], 1) * pow(input_x[3], 2);
      idvd_poly_feat[226] = pow(input_x[0], 4) * pow(input_x[2], 3);
      idvd_poly_feat[227] = pow(input_x[0], 4) * pow(input_x[2], 2) * pow(input_x[3], 1);
      idvd_poly_feat[228] = pow(input_x[0], 4) * pow(input_x[2], 1) * pow(input_x[3], 2);
      idvd_poly_feat[229] = pow(input_x[0], 4) * pow(input_x[3], 3);
      idvd_poly_feat[230] = pow(input_x[0], 3) * pow(input_x[1], 4);
      idvd_poly_feat[231] = pow(input_x[0], 3) * pow(input_x[1], 3) * pow(input_x[2], 1);
      idvd_poly_feat[232] = pow(input_x[0], 3) * pow(input_x[1], 3) * pow(input_x[3], 1);
      idvd_poly_feat[233] = pow(input_x[0], 3) * pow(input_x[1], 2) * pow(input_x[2], 2);
      idvd_poly_feat[234] = pow(input_x[0], 3) * pow(input_x[1], 2) * pow(input_x[2], 1) * pow(input_x[3], 1);
      idvd_poly_feat[235] = pow(input_x[0], 3) * pow(input_x[1], 2) * pow(input_x[3], 2);
      idvd_poly_feat[236] = pow(input_x[0], 3) * pow(input_x[1], 1) * pow(input_x[2], 3);
      idvd_poly_feat[237] = pow(input_x[0], 3) * pow(input_x[1], 1) * pow(input_x[2], 2) * pow(input_x[3], 1);
      idvd_poly_feat[238] = pow(input_x[0], 3) * pow(input_x[1], 1) * pow(input_x[2], 1) * pow(input_x[3], 2);
      idvd_poly_feat[239] = pow(input_x[0], 3) * pow(input_x[1], 1) * pow(input_x[3], 3);
      idvd_poly_feat[240] = pow(input_x[0], 3) * pow(input_x[2], 4);
      idvd_poly_feat[241] = pow(input_x[0], 3) * pow(input_x[2], 3) * pow(input_x[3], 1);
      idvd_poly_feat[242] = pow(input_x[0], 3) * pow(input_x[2], 2) * pow(input_x[3], 2);
      idvd_poly_feat[243] = pow(input_x[0], 3) * pow(input_x[2], 1) * pow(input_x[3], 3);
      idvd_poly_feat[244] = pow(input_x[0], 3) * pow(input_x[3], 4);
      idvd_poly_feat[245] = pow(input_x[0], 2) * pow(input_x[1], 5);
      idvd_poly_feat[246] = pow(input_x[0], 2) * pow(input_x[1], 4) * pow(input_x[2], 1);
      idvd_poly_feat[247] = pow(input_x[0], 2) * pow(input_x[1], 4) * pow(input_x[3], 1);
      idvd_poly_feat[248] = pow(input_x[0], 2) * pow(input_x[1], 3) * pow(input_x[2], 2);
      idvd_poly_feat[249] = pow(input_x[0], 2) * pow(input_x[1], 3) * pow(input_x[2], 1) * pow(input_x[3], 1);
      idvd_poly_feat[250] = pow(input_x[0], 2) * pow(input_x[1], 3) * pow(input_x[3], 2);
      idvd_poly_feat[251] = pow(input_x[0], 2) * pow(input_x[1], 2) * pow(input_x[2], 3);
      idvd_poly_feat[252] = pow(input_x[0], 2) * pow(input_x[1], 2) * pow(input_x[2], 2) * pow(input_x[3], 1);
      idvd_poly_feat[253] = pow(input_x[0], 2) * pow(input_x[1], 2) * pow(input_x[2], 1) * pow(input_x[3], 2);
      idvd_poly_feat[254] = pow(input_x[0], 2) * pow(input_x[1], 2) * pow(input_x[3], 3);
      idvd_poly_feat[255] = pow(input_x[0], 2) * pow(input_x[1], 1) * pow(input_x[2], 4);
      idvd_poly_feat[256] = pow(input_x[0], 2) * pow(input_x[1], 1) * pow(input_x[2], 3) * pow(input_x[3], 1);
      idvd_poly_feat[257] = pow(input_x[0], 2) * pow(input_x[1], 1) * pow(input_x[2], 2) * pow(input_x[3], 2);
      idvd_poly_feat[258] = pow(input_x[0], 2) * pow(input_x[1], 1) * pow(input_x[2], 1) * pow(input_x[3], 3);
      idvd_poly_feat[259] = pow(input_x[0], 2) * pow(input_x[1], 1) * pow(input_x[3], 4);
      idvd_poly_feat[260] = pow(input_x[0], 2) * pow(input_x[2], 5);
      idvd_poly_feat[261] = pow(input_x[0], 2) * pow(input_x[2], 4) * pow(input_x[3], 1);
      idvd_poly_feat[262] = pow(input_x[0], 2) * pow(input_x[2], 3) * pow(input_x[3], 2);
      idvd_poly_feat[263] = pow(input_x[0], 2) * pow(input_x[2], 2) * pow(input_x[3], 3);
      idvd_poly_feat[264] = pow(input_x[0], 2) * pow(input_x[2], 1) * pow(input_x[3], 4);
      idvd_poly_feat[265] = pow(input_x[0], 2) * pow(input_x[3], 5);
      idvd_poly_feat[266] = pow(input_x[0], 1) * pow(input_x[1], 6);
      idvd_poly_feat[267] = pow(input_x[0], 1) * pow(input_x[1], 5) * pow(input_x[2], 1);
      idvd_poly_feat[268] = pow(input_x[0], 1) * pow(input_x[1], 5) * pow(input_x[3], 1);
      idvd_poly_feat[269] = pow(input_x[0], 1) * pow(input_x[1], 4) * pow(input_x[2], 2);
      idvd_poly_feat[270] = pow(input_x[0], 1) * pow(input_x[1], 4) * pow(input_x[2], 1) * pow(input_x[3], 1);
      idvd_poly_feat[271] = pow(input_x[0], 1) * pow(input_x[1], 4) * pow(input_x[3], 2);
      idvd_poly_feat[272] = pow(input_x[0], 1) * pow(input_x[1], 3) * pow(input_x[2], 3);
      idvd_poly_feat[273] = pow(input_x[0], 1) * pow(input_x[1], 3) * pow(input_x[2], 2) * pow(input_x[3], 1);
      idvd_poly_feat[274] = pow(input_x[0], 1) * pow(input_x[1], 3) * pow(input_x[2], 1) * pow(input_x[3], 2);
      idvd_poly_feat[275] = pow(input_x[0], 1) * pow(input_x[1], 3) * pow(input_x[3], 3);
      idvd_poly_feat[276] = pow(input_x[0], 1) * pow(input_x[1], 2) * pow(input_x[2], 4);
      idvd_poly_feat[277] = pow(input_x[0], 1) * pow(input_x[1], 2) * pow(input_x[2], 3) * pow(input_x[3], 1);
      idvd_poly_feat[278] = pow(input_x[0], 1) * pow(input_x[1], 2) * pow(input_x[2], 2) * pow(input_x[3], 2);
      idvd_poly_feat[279] = pow(input_x[0], 1) * pow(input_x[1], 2) * pow(input_x[2], 1) * pow(input_x[3], 3);
      idvd_poly_feat[280] = pow(input_x[0], 1) * pow(input_x[1], 2) * pow(input_x[3], 4);
      idvd_poly_feat[281] = pow(input_x[0], 1) * pow(input_x[1], 1) * pow(input_x[2], 5);
      idvd_poly_feat[282] = pow(input_x[0], 1) * pow(input_x[1], 1) * pow(input_x[2], 4) * pow(input_x[3], 1);
      idvd_poly_feat[283] = pow(input_x[0], 1) * pow(input_x[1], 1) * pow(input_x[2], 3) * pow(input_x[3], 2);
      idvd_poly_feat[284] = pow(input_x[0], 1) * pow(input_x[1], 1) * pow(input_x[2], 2) * pow(input_x[3], 3);
      idvd_poly_feat[285] = pow(input_x[0], 1) * pow(input_x[1], 1) * pow(input_x[2], 1) * pow(input_x[3], 4);
      idvd_poly_feat[286] = pow(input_x[0], 1) * pow(input_x[1], 1) * pow(input_x[3], 5);
      idvd_poly_feat[287] = pow(input_x[0], 1) * pow(input_x[2], 6);
      idvd_poly_feat[288] = pow(input_x[0], 1) * pow(input_x[2], 5) * pow(input_x[3], 1);
      idvd_poly_feat[289] = pow(input_x[0], 1) * pow(input_x[2], 4) * pow(input_x[3], 2);
      idvd_poly_feat[290] = pow(input_x[0], 1) * pow(input_x[2], 3) * pow(input_x[3], 3);
      idvd_poly_feat[291] = pow(input_x[0], 1) * pow(input_x[2], 2) * pow(input_x[3], 4);
      idvd_poly_feat[292] = pow(input_x[0], 1) * pow(input_x[2], 1) * pow(input_x[3], 5);
      idvd_poly_feat[293] = pow(input_x[0], 1) * pow(input_x[3], 6);
      idvd_poly_feat[294] = pow(input_x[1], 7);
      idvd_poly_feat[295] = pow(input_x[1], 6) * pow(input_x[2], 1);
      idvd_poly_feat[296] = pow(input_x[1], 6) * pow(input_x[3], 1);
      idvd_poly_feat[297] = pow(input_x[1], 5) * pow(input_x[2], 2);
      idvd_poly_feat[298] = pow(input_x[1], 5) * pow(input_x[2], 1) * pow(input_x[3], 1);
      idvd_poly_feat[299] = pow(input_x[1], 5) * pow(input_x[3], 2);
      idvd_poly_feat[300] = pow(input_x[1], 4) * pow(input_x[2], 3);
      idvd_poly_feat[301] = pow(input_x[1], 4) * pow(input_x[2], 2) * pow(input_x[3], 1);
      idvd_poly_feat[302] = pow(input_x[1], 4) * pow(input_x[2], 1) * pow(input_x[3], 2);
      idvd_poly_feat[303] = pow(input_x[1], 4) * pow(input_x[3], 3);
      idvd_poly_feat[304] = pow(input_x[1], 3) * pow(input_x[2], 4);
      idvd_poly_feat[305] = pow(input_x[1], 3) * pow(input_x[2], 3) * pow(input_x[3], 1);
      idvd_poly_feat[306] = pow(input_x[1], 3) * pow(input_x[2], 2) * pow(input_x[3], 2);
      idvd_poly_feat[307] = pow(input_x[1], 3) * pow(input_x[2], 1) * pow(input_x[3], 3);
      idvd_poly_feat[308] = pow(input_x[1], 3) * pow(input_x[3], 4);
      idvd_poly_feat[309] = pow(input_x[1], 2) * pow(input_x[2], 5);
      idvd_poly_feat[310] = pow(input_x[1], 2) * pow(input_x[2], 4) * pow(input_x[3], 1);
      idvd_poly_feat[311] = pow(input_x[1], 2) * pow(input_x[2], 3) * pow(input_x[3], 2);
      idvd_poly_feat[312] = pow(input_x[1], 2) * pow(input_x[2], 2) * pow(input_x[3], 3);
      idvd_poly_feat[313] = pow(input_x[1], 2) * pow(input_x[2], 1) * pow(input_x[3], 4);
      idvd_poly_feat[314] = pow(input_x[1], 2) * pow(input_x[3], 5);
      idvd_poly_feat[315] = pow(input_x[1], 1) * pow(input_x[2], 6);
      idvd_poly_feat[316] = pow(input_x[1], 1) * pow(input_x[2], 5) * pow(input_x[3], 1);
      idvd_poly_feat[317] = pow(input_x[1], 1) * pow(input_x[2], 4) * pow(input_x[3], 2);
      idvd_poly_feat[318] = pow(input_x[1], 1) * pow(input_x[2], 3) * pow(input_x[3], 3);
      idvd_poly_feat[319] = pow(input_x[1], 1) * pow(input_x[2], 2) * pow(input_x[3], 4);
      idvd_poly_feat[320] = pow(input_x[1], 1) * pow(input_x[2], 1) * pow(input_x[3], 5);
      idvd_poly_feat[321] = pow(input_x[1], 1) * pow(input_x[3], 6);
      idvd_poly_feat[322] = pow(input_x[2], 7);
      idvd_poly_feat[323] = pow(input_x[2], 6) * pow(input_x[3], 1);
      idvd_poly_feat[324] = pow(input_x[2], 5) * pow(input_x[3], 2);
      idvd_poly_feat[325] = pow(input_x[2], 4) * pow(input_x[3], 3);
      idvd_poly_feat[326] = pow(input_x[2], 3) * pow(input_x[3], 4);
      idvd_poly_feat[327] = pow(input_x[2], 2) * pow(input_x[3], 5);
      idvd_poly_feat[328] = pow(input_x[2], 1) * pow(input_x[3], 6);
      idvd_poly_feat[329] = pow(input_x[3], 7);
      idvd_poly_feat[330] = pow(input_x[0], 8);
      idvd_poly_feat[331] = pow(input_x[0], 7) * pow(input_x[1], 1);
      idvd_poly_feat[332] = pow(input_x[0], 7) * pow(input_x[2], 1);
      idvd_poly_feat[333] = pow(input_x[0], 7) * pow(input_x[3], 1);
      idvd_poly_feat[334] = pow(input_x[0], 6) * pow(input_x[1], 2);
      idvd_poly_feat[335] = pow(input_x[0], 6) * pow(input_x[1], 1) * pow(input_x[2], 1);
      idvd_poly_feat[336] = pow(input_x[0], 6) * pow(input_x[1], 1) * pow(input_x[3], 1);
      idvd_poly_feat[337] = pow(input_x[0], 6) * pow(input_x[2], 2);
      idvd_poly_feat[338] = pow(input_x[0], 6) * pow(input_x[2], 1) * pow(input_x[3], 1);
      idvd_poly_feat[339] = pow(input_x[0], 6) * pow(input_x[3], 2);
      idvd_poly_feat[340] = pow(input_x[0], 5) * pow(input_x[1], 3);
      idvd_poly_feat[341] = pow(input_x[0], 5) * pow(input_x[1], 2) * pow(input_x[2], 1);
      idvd_poly_feat[342] = pow(input_x[0], 5) * pow(input_x[1], 2) * pow(input_x[3], 1);
      idvd_poly_feat[343] = pow(input_x[0], 5) * pow(input_x[1], 1) * pow(input_x[2], 2);
      idvd_poly_feat[344] = pow(input_x[0], 5) * pow(input_x[1], 1) * pow(input_x[2], 1) * pow(input_x[3], 1);
      idvd_poly_feat[345] = pow(input_x[0], 5) * pow(input_x[1], 1) * pow(input_x[3], 2);
      idvd_poly_feat[346] = pow(input_x[0], 5) * pow(input_x[2], 3);
      idvd_poly_feat[347] = pow(input_x[0], 5) * pow(input_x[2], 2) * pow(input_x[3], 1);
      idvd_poly_feat[348] = pow(input_x[0], 5) * pow(input_x[2], 1) * pow(input_x[3], 2);
      idvd_poly_feat[349] = pow(input_x[0], 5) * pow(input_x[3], 3);
      idvd_poly_feat[350] = pow(input_x[0], 4) * pow(input_x[1], 4);
      idvd_poly_feat[351] = pow(input_x[0], 4) * pow(input_x[1], 3) * pow(input_x[2], 1);
      idvd_poly_feat[352] = pow(input_x[0], 4) * pow(input_x[1], 3) * pow(input_x[3], 1);
      idvd_poly_feat[353] = pow(input_x[0], 4) * pow(input_x[1], 2) * pow(input_x[2], 2);
      idvd_poly_feat[354] = pow(input_x[0], 4) * pow(input_x[1], 2) * pow(input_x[2], 1) * pow(input_x[3], 1);
      idvd_poly_feat[355] = pow(input_x[0], 4) * pow(input_x[1], 2) * pow(input_x[3], 2);
      idvd_poly_feat[356] = pow(input_x[0], 4) * pow(input_x[1], 1) * pow(input_x[2], 3);
      idvd_poly_feat[357] = pow(input_x[0], 4) * pow(input_x[1], 1) * pow(input_x[2], 2) * pow(input_x[3], 1);
      idvd_poly_feat[358] = pow(input_x[0], 4) * pow(input_x[1], 1) * pow(input_x[2], 1) * pow(input_x[3], 2);
      idvd_poly_feat[359] = pow(input_x[0], 4) * pow(input_x[1], 1) * pow(input_x[3], 3);
      idvd_poly_feat[360] = pow(input_x[0], 4) * pow(input_x[2], 4);
      idvd_poly_feat[361] = pow(input_x[0], 4) * pow(input_x[2], 3) * pow(input_x[3], 1);
      idvd_poly_feat[362] = pow(input_x[0], 4) * pow(input_x[2], 2) * pow(input_x[3], 2);
      idvd_poly_feat[363] = pow(input_x[0], 4) * pow(input_x[2], 1) * pow(input_x[3], 3);
      idvd_poly_feat[364] = pow(input_x[0], 4) * pow(input_x[3], 4);
      idvd_poly_feat[365] = pow(input_x[0], 3) * pow(input_x[1], 5);
      idvd_poly_feat[366] = pow(input_x[0], 3) * pow(input_x[1], 4) * pow(input_x[2], 1);
      idvd_poly_feat[367] = pow(input_x[0], 3) * pow(input_x[1], 4) * pow(input_x[3], 1);
      idvd_poly_feat[368] = pow(input_x[0], 3) * pow(input_x[1], 3) * pow(input_x[2], 2);
      idvd_poly_feat[369] = pow(input_x[0], 3) * pow(input_x[1], 3) * pow(input_x[2], 1) * pow(input_x[3], 1);
      idvd_poly_feat[370] = pow(input_x[0], 3) * pow(input_x[1], 3) * pow(input_x[3], 2);
      idvd_poly_feat[371] = pow(input_x[0], 3) * pow(input_x[1], 2) * pow(input_x[2], 3);
      idvd_poly_feat[372] = pow(input_x[0], 3) * pow(input_x[1], 2) * pow(input_x[2], 2) * pow(input_x[3], 1);
      idvd_poly_feat[373] = pow(input_x[0], 3) * pow(input_x[1], 2) * pow(input_x[2], 1) * pow(input_x[3], 2);
      idvd_poly_feat[374] = pow(input_x[0], 3) * pow(input_x[1], 2) * pow(input_x[3], 3);
      idvd_poly_feat[375] = pow(input_x[0], 3) * pow(input_x[1], 1) * pow(input_x[2], 4);
      idvd_poly_feat[376] = pow(input_x[0], 3) * pow(input_x[1], 1) * pow(input_x[2], 3) * pow(input_x[3], 1);
      idvd_poly_feat[377] = pow(input_x[0], 3) * pow(input_x[1], 1) * pow(input_x[2], 2) * pow(input_x[3], 2);
      idvd_poly_feat[378] = pow(input_x[0], 3) * pow(input_x[1], 1) * pow(input_x[2], 1) * pow(input_x[3], 3);
      idvd_poly_feat[379] = pow(input_x[0], 3) * pow(input_x[1], 1) * pow(input_x[3], 4);
      idvd_poly_feat[380] = pow(input_x[0], 3) * pow(input_x[2], 5);
      idvd_poly_feat[381] = pow(input_x[0], 3) * pow(input_x[2], 4) * pow(input_x[3], 1);
      idvd_poly_feat[382] = pow(input_x[0], 3) * pow(input_x[2], 3) * pow(input_x[3], 2);
      idvd_poly_feat[383] = pow(input_x[0], 3) * pow(input_x[2], 2) * pow(input_x[3], 3);
      idvd_poly_feat[384] = pow(input_x[0], 3) * pow(input_x[2], 1) * pow(input_x[3], 4);
      idvd_poly_feat[385] = pow(input_x[0], 3) * pow(input_x[3], 5);
      idvd_poly_feat[386] = pow(input_x[0], 2) * pow(input_x[1], 6);
      idvd_poly_feat[387] = pow(input_x[0], 2) * pow(input_x[1], 5) * pow(input_x[2], 1);
      idvd_poly_feat[388] = pow(input_x[0], 2) * pow(input_x[1], 5) * pow(input_x[3], 1);
      idvd_poly_feat[389] = pow(input_x[0], 2) * pow(input_x[1], 4) * pow(input_x[2], 2);
      idvd_poly_feat[390] = pow(input_x[0], 2) * pow(input_x[1], 4) * pow(input_x[2], 1) * pow(input_x[3], 1);
      idvd_poly_feat[391] = pow(input_x[0], 2) * pow(input_x[1], 4) * pow(input_x[3], 2);
      idvd_poly_feat[392] = pow(input_x[0], 2) * pow(input_x[1], 3) * pow(input_x[2], 3);
      idvd_poly_feat[393] = pow(input_x[0], 2) * pow(input_x[1], 3) * pow(input_x[2], 2) * pow(input_x[3], 1);
      idvd_poly_feat[394] = pow(input_x[0], 2) * pow(input_x[1], 3) * pow(input_x[2], 1) * pow(input_x[3], 2);
      idvd_poly_feat[395] = pow(input_x[0], 2) * pow(input_x[1], 3) * pow(input_x[3], 3);
      idvd_poly_feat[396] = pow(input_x[0], 2) * pow(input_x[1], 2) * pow(input_x[2], 4);
      idvd_poly_feat[397] = pow(input_x[0], 2) * pow(input_x[1], 2) * pow(input_x[2], 3) * pow(input_x[3], 1);
      idvd_poly_feat[398] = pow(input_x[0], 2) * pow(input_x[1], 2) * pow(input_x[2], 2) * pow(input_x[3], 2);
      idvd_poly_feat[399] = pow(input_x[0], 2) * pow(input_x[1], 2) * pow(input_x[2], 1) * pow(input_x[3], 3);
      idvd_poly_feat[400] = pow(input_x[0], 2) * pow(input_x[1], 2) * pow(input_x[3], 4);
      idvd_poly_feat[401] = pow(input_x[0], 2) * pow(input_x[1], 1) * pow(input_x[2], 5);
      idvd_poly_feat[402] = pow(input_x[0], 2) * pow(input_x[1], 1) * pow(input_x[2], 4) * pow(input_x[3], 1);
      idvd_poly_feat[403] = pow(input_x[0], 2) * pow(input_x[1], 1) * pow(input_x[2], 3) * pow(input_x[3], 2);
      idvd_poly_feat[404] = pow(input_x[0], 2) * pow(input_x[1], 1) * pow(input_x[2], 2) * pow(input_x[3], 3);
      idvd_poly_feat[405] = pow(input_x[0], 2) * pow(input_x[1], 1) * pow(input_x[2], 1) * pow(input_x[3], 4);
      idvd_poly_feat[406] = pow(input_x[0], 2) * pow(input_x[1], 1) * pow(input_x[3], 5);
      idvd_poly_feat[407] = pow(input_x[0], 2) * pow(input_x[2], 6);
      idvd_poly_feat[408] = pow(input_x[0], 2) * pow(input_x[2], 5) * pow(input_x[3], 1);
      idvd_poly_feat[409] = pow(input_x[0], 2) * pow(input_x[2], 4) * pow(input_x[3], 2);
      idvd_poly_feat[410] = pow(input_x[0], 2) * pow(input_x[2], 3) * pow(input_x[3], 3);
      idvd_poly_feat[411] = pow(input_x[0], 2) * pow(input_x[2], 2) * pow(input_x[3], 4);
      idvd_poly_feat[412] = pow(input_x[0], 2) * pow(input_x[2], 1) * pow(input_x[3], 5);
      idvd_poly_feat[413] = pow(input_x[0], 2) * pow(input_x[3], 6);
      idvd_poly_feat[414] = pow(input_x[0], 1) * pow(input_x[1], 7);
      idvd_poly_feat[415] = pow(input_x[0], 1) * pow(input_x[1], 6) * pow(input_x[2], 1);
      idvd_poly_feat[416] = pow(input_x[0], 1) * pow(input_x[1], 6) * pow(input_x[3], 1);
      idvd_poly_feat[417] = pow(input_x[0], 1) * pow(input_x[1], 5) * pow(input_x[2], 2);
      idvd_poly_feat[418] = pow(input_x[0], 1) * pow(input_x[1], 5) * pow(input_x[2], 1) * pow(input_x[3], 1);
      idvd_poly_feat[419] = pow(input_x[0], 1) * pow(input_x[1], 5) * pow(input_x[3], 2);
      idvd_poly_feat[420] = pow(input_x[0], 1) * pow(input_x[1], 4) * pow(input_x[2], 3);
      idvd_poly_feat[421] = pow(input_x[0], 1) * pow(input_x[1], 4) * pow(input_x[2], 2) * pow(input_x[3], 1);
      idvd_poly_feat[422] = pow(input_x[0], 1) * pow(input_x[1], 4) * pow(input_x[2], 1) * pow(input_x[3], 2);
      idvd_poly_feat[423] = pow(input_x[0], 1) * pow(input_x[1], 4) * pow(input_x[3], 3);
      idvd_poly_feat[424] = pow(input_x[0], 1) * pow(input_x[1], 3) * pow(input_x[2], 4);
      idvd_poly_feat[425] = pow(input_x[0], 1) * pow(input_x[1], 3) * pow(input_x[2], 3) * pow(input_x[3], 1);
      idvd_poly_feat[426] = pow(input_x[0], 1) * pow(input_x[1], 3) * pow(input_x[2], 2) * pow(input_x[3], 2);
      idvd_poly_feat[427] = pow(input_x[0], 1) * pow(input_x[1], 3) * pow(input_x[2], 1) * pow(input_x[3], 3);
      idvd_poly_feat[428] = pow(input_x[0], 1) * pow(input_x[1], 3) * pow(input_x[3], 4);
      idvd_poly_feat[429] = pow(input_x[0], 1) * pow(input_x[1], 2) * pow(input_x[2], 5);
      idvd_poly_feat[430] = pow(input_x[0], 1) * pow(input_x[1], 2) * pow(input_x[2], 4) * pow(input_x[3], 1);
      idvd_poly_feat[431] = pow(input_x[0], 1) * pow(input_x[1], 2) * pow(input_x[2], 3) * pow(input_x[3], 2);
      idvd_poly_feat[432] = pow(input_x[0], 1) * pow(input_x[1], 2) * pow(input_x[2], 2) * pow(input_x[3], 3);
      idvd_poly_feat[433] = pow(input_x[0], 1) * pow(input_x[1], 2) * pow(input_x[2], 1) * pow(input_x[3], 4);
      idvd_poly_feat[434] = pow(input_x[0], 1) * pow(input_x[1], 2) * pow(input_x[3], 5);
      idvd_poly_feat[435] = pow(input_x[0], 1) * pow(input_x[1], 1) * pow(input_x[2], 6);
      idvd_poly_feat[436] = pow(input_x[0], 1) * pow(input_x[1], 1) * pow(input_x[2], 5) * pow(input_x[3], 1);
      idvd_poly_feat[437] = pow(input_x[0], 1) * pow(input_x[1], 1) * pow(input_x[2], 4) * pow(input_x[3], 2);
      idvd_poly_feat[438] = pow(input_x[0], 1) * pow(input_x[1], 1) * pow(input_x[2], 3) * pow(input_x[3], 3);
      idvd_poly_feat[439] = pow(input_x[0], 1) * pow(input_x[1], 1) * pow(input_x[2], 2) * pow(input_x[3], 4);
      idvd_poly_feat[440] = pow(input_x[0], 1) * pow(input_x[1], 1) * pow(input_x[2], 1) * pow(input_x[3], 5);
      idvd_poly_feat[441] = pow(input_x[0], 1) * pow(input_x[1], 1) * pow(input_x[3], 6);
      idvd_poly_feat[442] = pow(input_x[0], 1) * pow(input_x[2], 7);
      idvd_poly_feat[443] = pow(input_x[0], 1) * pow(input_x[2], 6) * pow(input_x[3], 1);
      idvd_poly_feat[444] = pow(input_x[0], 1) * pow(input_x[2], 5) * pow(input_x[3], 2);
      idvd_poly_feat[445] = pow(input_x[0], 1) * pow(input_x[2], 4) * pow(input_x[3], 3);
      idvd_poly_feat[446] = pow(input_x[0], 1) * pow(input_x[2], 3) * pow(input_x[3], 4);
      idvd_poly_feat[447] = pow(input_x[0], 1) * pow(input_x[2], 2) * pow(input_x[3], 5);
      idvd_poly_feat[448] = pow(input_x[0], 1) * pow(input_x[2], 1) * pow(input_x[3], 6);
      idvd_poly_feat[449] = pow(input_x[0], 1) * pow(input_x[3], 7);
      idvd_poly_feat[450] = pow(input_x[1], 8);
      idvd_poly_feat[451] = pow(input_x[1], 7) * pow(input_x[2], 1);
      idvd_poly_feat[452] = pow(input_x[1], 7) * pow(input_x[3], 1);
      idvd_poly_feat[453] = pow(input_x[1], 6) * pow(input_x[2], 2);
      idvd_poly_feat[454] = pow(input_x[1], 6) * pow(input_x[2], 1) * pow(input_x[3], 1);
      idvd_poly_feat[455] = pow(input_x[1], 6) * pow(input_x[3], 2);
      idvd_poly_feat[456] = pow(input_x[1], 5) * pow(input_x[2], 3);
      idvd_poly_feat[457] = pow(input_x[1], 5) * pow(input_x[2], 2) * pow(input_x[3], 1);
      idvd_poly_feat[458] = pow(input_x[1], 5) * pow(input_x[2], 1) * pow(input_x[3], 2);
      idvd_poly_feat[459] = pow(input_x[1], 5) * pow(input_x[3], 3);
      idvd_poly_feat[460] = pow(input_x[1], 4) * pow(input_x[2], 4);
      idvd_poly_feat[461] = pow(input_x[1], 4) * pow(input_x[2], 3) * pow(input_x[3], 1);
      idvd_poly_feat[462] = pow(input_x[1], 4) * pow(input_x[2], 2) * pow(input_x[3], 2);
      idvd_poly_feat[463] = pow(input_x[1], 4) * pow(input_x[2], 1) * pow(input_x[3], 3);
      idvd_poly_feat[464] = pow(input_x[1], 4) * pow(input_x[3], 4);
      idvd_poly_feat[465] = pow(input_x[1], 3) * pow(input_x[2], 5);
      idvd_poly_feat[466] = pow(input_x[1], 3) * pow(input_x[2], 4) * pow(input_x[3], 1);
      idvd_poly_feat[467] = pow(input_x[1], 3) * pow(input_x[2], 3) * pow(input_x[3], 2);
      idvd_poly_feat[468] = pow(input_x[1], 3) * pow(input_x[2], 2) * pow(input_x[3], 3);
      idvd_poly_feat[469] = pow(input_x[1], 3) * pow(input_x[2], 1) * pow(input_x[3], 4);
      idvd_poly_feat[470] = pow(input_x[1], 3) * pow(input_x[3], 5);
      idvd_poly_feat[471] = pow(input_x[1], 2) * pow(input_x[2], 6);
      idvd_poly_feat[472] = pow(input_x[1], 2) * pow(input_x[2], 5) * pow(input_x[3], 1);
      idvd_poly_feat[473] = pow(input_x[1], 2) * pow(input_x[2], 4) * pow(input_x[3], 2);
      idvd_poly_feat[474] = pow(input_x[1], 2) * pow(input_x[2], 3) * pow(input_x[3], 3);
      idvd_poly_feat[475] = pow(input_x[1], 2) * pow(input_x[2], 2) * pow(input_x[3], 4);
      idvd_poly_feat[476] = pow(input_x[1], 2) * pow(input_x[2], 1) * pow(input_x[3], 5);
      idvd_poly_feat[477] = pow(input_x[1], 2) * pow(input_x[3], 6);
      idvd_poly_feat[478] = pow(input_x[1], 1) * pow(input_x[2], 7);
      idvd_poly_feat[479] = pow(input_x[1], 1) * pow(input_x[2], 6) * pow(input_x[3], 1);
      idvd_poly_feat[480] = pow(input_x[1], 1) * pow(input_x[2], 5) * pow(input_x[3], 2);
      idvd_poly_feat[481] = pow(input_x[1], 1) * pow(input_x[2], 4) * pow(input_x[3], 3);
      idvd_poly_feat[482] = pow(input_x[1], 1) * pow(input_x[2], 3) * pow(input_x[3], 4);
      idvd_poly_feat[483] = pow(input_x[1], 1) * pow(input_x[2], 2) * pow(input_x[3], 5);
      idvd_poly_feat[484] = pow(input_x[1], 1) * pow(input_x[2], 1) * pow(input_x[3], 6);
      idvd_poly_feat[485] = pow(input_x[1], 1) * pow(input_x[3], 7);
      idvd_poly_feat[486] = pow(input_x[2], 8);
      idvd_poly_feat[487] = pow(input_x[2], 7) * pow(input_x[3], 1);
      idvd_poly_feat[488] = pow(input_x[2], 6) * pow(input_x[3], 2);
      idvd_poly_feat[489] = pow(input_x[2], 5) * pow(input_x[3], 3);
      idvd_poly_feat[490] = pow(input_x[2], 4) * pow(input_x[3], 4);
      idvd_poly_feat[491] = pow(input_x[2], 3) * pow(input_x[3], 5);
      idvd_poly_feat[492] = pow(input_x[2], 2) * pow(input_x[3], 6);
      idvd_poly_feat[493] = pow(input_x[2], 1) * pow(input_x[3], 7);
      idvd_poly_feat[494] = pow(input_x[3], 8);
      idvd_poly_feat[495] = pow(input_x[0], 9);
      idvd_poly_feat[496] = pow(input_x[0], 8) * pow(input_x[1], 1);
      idvd_poly_feat[497] = pow(input_x[0], 8) * pow(input_x[2], 1);
      idvd_poly_feat[498] = pow(input_x[0], 8) * pow(input_x[3], 1);
      idvd_poly_feat[499] = pow(input_x[0], 7) * pow(input_x[1], 2);
      idvd_poly_feat[500] = pow(input_x[0], 7) * pow(input_x[1], 1) * pow(input_x[2], 1);
      idvd_poly_feat[501] = pow(input_x[0], 7) * pow(input_x[1], 1) * pow(input_x[3], 1);
      idvd_poly_feat[502] = pow(input_x[0], 7) * pow(input_x[2], 2);
      idvd_poly_feat[503] = pow(input_x[0], 7) * pow(input_x[2], 1) * pow(input_x[3], 1);
      idvd_poly_feat[504] = pow(input_x[0], 7) * pow(input_x[3], 2);
      idvd_poly_feat[505] = pow(input_x[0], 6) * pow(input_x[1], 3);
      idvd_poly_feat[506] = pow(input_x[0], 6) * pow(input_x[1], 2) * pow(input_x[2], 1);
      idvd_poly_feat[507] = pow(input_x[0], 6) * pow(input_x[1], 2) * pow(input_x[3], 1);
      idvd_poly_feat[508] = pow(input_x[0], 6) * pow(input_x[1], 1) * pow(input_x[2], 2);
      idvd_poly_feat[509] = pow(input_x[0], 6) * pow(input_x[1], 1) * pow(input_x[2], 1) * pow(input_x[3], 1);
      idvd_poly_feat[510] = pow(input_x[0], 6) * pow(input_x[1], 1) * pow(input_x[3], 2);
      idvd_poly_feat[511] = pow(input_x[0], 6) * pow(input_x[2], 3);
      idvd_poly_feat[512] = pow(input_x[0], 6) * pow(input_x[2], 2) * pow(input_x[3], 1);
      idvd_poly_feat[513] = pow(input_x[0], 6) * pow(input_x[2], 1) * pow(input_x[3], 2);
      idvd_poly_feat[514] = pow(input_x[0], 6) * pow(input_x[3], 3);
      idvd_poly_feat[515] = pow(input_x[0], 5) * pow(input_x[1], 4);
      idvd_poly_feat[516] = pow(input_x[0], 5) * pow(input_x[1], 3) * pow(input_x[2], 1);
      idvd_poly_feat[517] = pow(input_x[0], 5) * pow(input_x[1], 3) * pow(input_x[3], 1);
      idvd_poly_feat[518] = pow(input_x[0], 5) * pow(input_x[1], 2) * pow(input_x[2], 2);
      idvd_poly_feat[519] = pow(input_x[0], 5) * pow(input_x[1], 2) * pow(input_x[2], 1) * pow(input_x[3], 1);
      idvd_poly_feat[520] = pow(input_x[0], 5) * pow(input_x[1], 2) * pow(input_x[3], 2);
      idvd_poly_feat[521] = pow(input_x[0], 5) * pow(input_x[1], 1) * pow(input_x[2], 3);
      idvd_poly_feat[522] = pow(input_x[0], 5) * pow(input_x[1], 1) * pow(input_x[2], 2) * pow(input_x[3], 1);
      idvd_poly_feat[523] = pow(input_x[0], 5) * pow(input_x[1], 1) * pow(input_x[2], 1) * pow(input_x[3], 2);
      idvd_poly_feat[524] = pow(input_x[0], 5) * pow(input_x[1], 1) * pow(input_x[3], 3);
      idvd_poly_feat[525] = pow(input_x[0], 5) * pow(input_x[2], 4);
      idvd_poly_feat[526] = pow(input_x[0], 5) * pow(input_x[2], 3) * pow(input_x[3], 1);
      idvd_poly_feat[527] = pow(input_x[0], 5) * pow(input_x[2], 2) * pow(input_x[3], 2);
      idvd_poly_feat[528] = pow(input_x[0], 5) * pow(input_x[2], 1) * pow(input_x[3], 3);
      idvd_poly_feat[529] = pow(input_x[0], 5) * pow(input_x[3], 4);
      idvd_poly_feat[530] = pow(input_x[0], 4) * pow(input_x[1], 5);
      idvd_poly_feat[531] = pow(input_x[0], 4) * pow(input_x[1], 4) * pow(input_x[2], 1);
      idvd_poly_feat[532] = pow(input_x[0], 4) * pow(input_x[1], 4) * pow(input_x[3], 1);
      idvd_poly_feat[533] = pow(input_x[0], 4) * pow(input_x[1], 3) * pow(input_x[2], 2);
      idvd_poly_feat[534] = pow(input_x[0], 4) * pow(input_x[1], 3) * pow(input_x[2], 1) * pow(input_x[3], 1);
      idvd_poly_feat[535] = pow(input_x[0], 4) * pow(input_x[1], 3) * pow(input_x[3], 2);
      idvd_poly_feat[536] = pow(input_x[0], 4) * pow(input_x[1], 2) * pow(input_x[2], 3);
      idvd_poly_feat[537] = pow(input_x[0], 4) * pow(input_x[1], 2) * pow(input_x[2], 2) * pow(input_x[3], 1);
      idvd_poly_feat[538] = pow(input_x[0], 4) * pow(input_x[1], 2) * pow(input_x[2], 1) * pow(input_x[3], 2);
      idvd_poly_feat[539] = pow(input_x[0], 4) * pow(input_x[1], 2) * pow(input_x[3], 3);
      idvd_poly_feat[540] = pow(input_x[0], 4) * pow(input_x[1], 1) * pow(input_x[2], 4);
      idvd_poly_feat[541] = pow(input_x[0], 4) * pow(input_x[1], 1) * pow(input_x[2], 3) * pow(input_x[3], 1);
      idvd_poly_feat[542] = pow(input_x[0], 4) * pow(input_x[1], 1) * pow(input_x[2], 2) * pow(input_x[3], 2);
      idvd_poly_feat[543] = pow(input_x[0], 4) * pow(input_x[1], 1) * pow(input_x[2], 1) * pow(input_x[3], 3);
      idvd_poly_feat[544] = pow(input_x[0], 4) * pow(input_x[1], 1) * pow(input_x[3], 4);
      idvd_poly_feat[545] = pow(input_x[0], 4) * pow(input_x[2], 5);
      idvd_poly_feat[546] = pow(input_x[0], 4) * pow(input_x[2], 4) * pow(input_x[3], 1);
      idvd_poly_feat[547] = pow(input_x[0], 4) * pow(input_x[2], 3) * pow(input_x[3], 2);
      idvd_poly_feat[548] = pow(input_x[0], 4) * pow(input_x[2], 2) * pow(input_x[3], 3);
      idvd_poly_feat[549] = pow(input_x[0], 4) * pow(input_x[2], 1) * pow(input_x[3], 4);
      idvd_poly_feat[550] = pow(input_x[0], 4) * pow(input_x[3], 5);
      idvd_poly_feat[551] = pow(input_x[0], 3) * pow(input_x[1], 6);
      idvd_poly_feat[552] = pow(input_x[0], 3) * pow(input_x[1], 5) * pow(input_x[2], 1);
      idvd_poly_feat[553] = pow(input_x[0], 3) * pow(input_x[1], 5) * pow(input_x[3], 1);
      idvd_poly_feat[554] = pow(input_x[0], 3) * pow(input_x[1], 4) * pow(input_x[2], 2);
      idvd_poly_feat[555] = pow(input_x[0], 3) * pow(input_x[1], 4) * pow(input_x[2], 1) * pow(input_x[3], 1);
      idvd_poly_feat[556] = pow(input_x[0], 3) * pow(input_x[1], 4) * pow(input_x[3], 2);
      idvd_poly_feat[557] = pow(input_x[0], 3) * pow(input_x[1], 3) * pow(input_x[2], 3);
      idvd_poly_feat[558] = pow(input_x[0], 3) * pow(input_x[1], 3) * pow(input_x[2], 2) * pow(input_x[3], 1);
      idvd_poly_feat[559] = pow(input_x[0], 3) * pow(input_x[1], 3) * pow(input_x[2], 1) * pow(input_x[3], 2);
      idvd_poly_feat[560] = pow(input_x[0], 3) * pow(input_x[1], 3) * pow(input_x[3], 3);
      idvd_poly_feat[561] = pow(input_x[0], 3) * pow(input_x[1], 2) * pow(input_x[2], 4);
      idvd_poly_feat[562] = pow(input_x[0], 3) * pow(input_x[1], 2) * pow(input_x[2], 3) * pow(input_x[3], 1);
      idvd_poly_feat[563] = pow(input_x[0], 3) * pow(input_x[1], 2) * pow(input_x[2], 2) * pow(input_x[3], 2);
      idvd_poly_feat[564] = pow(input_x[0], 3) * pow(input_x[1], 2) * pow(input_x[2], 1) * pow(input_x[3], 3);
      idvd_poly_feat[565] = pow(input_x[0], 3) * pow(input_x[1], 2) * pow(input_x[3], 4);
      idvd_poly_feat[566] = pow(input_x[0], 3) * pow(input_x[1], 1) * pow(input_x[2], 5);
      idvd_poly_feat[567] = pow(input_x[0], 3) * pow(input_x[1], 1) * pow(input_x[2], 4) * pow(input_x[3], 1);
      idvd_poly_feat[568] = pow(input_x[0], 3) * pow(input_x[1], 1) * pow(input_x[2], 3) * pow(input_x[3], 2);
      idvd_poly_feat[569] = pow(input_x[0], 3) * pow(input_x[1], 1) * pow(input_x[2], 2) * pow(input_x[3], 3);
      idvd_poly_feat[570] = pow(input_x[0], 3) * pow(input_x[1], 1) * pow(input_x[2], 1) * pow(input_x[3], 4);
      idvd_poly_feat[571] = pow(input_x[0], 3) * pow(input_x[1], 1) * pow(input_x[3], 5);
      idvd_poly_feat[572] = pow(input_x[0], 3) * pow(input_x[2], 6);
      idvd_poly_feat[573] = pow(input_x[0], 3) * pow(input_x[2], 5) * pow(input_x[3], 1);
      idvd_poly_feat[574] = pow(input_x[0], 3) * pow(input_x[2], 4) * pow(input_x[3], 2);
      idvd_poly_feat[575] = pow(input_x[0], 3) * pow(input_x[2], 3) * pow(input_x[3], 3);
      idvd_poly_feat[576] = pow(input_x[0], 3) * pow(input_x[2], 2) * pow(input_x[3], 4);
      idvd_poly_feat[577] = pow(input_x[0], 3) * pow(input_x[2], 1) * pow(input_x[3], 5);
      idvd_poly_feat[578] = pow(input_x[0], 3) * pow(input_x[3], 6);
      idvd_poly_feat[579] = pow(input_x[0], 2) * pow(input_x[1], 7);
      idvd_poly_feat[580] = pow(input_x[0], 2) * pow(input_x[1], 6) * pow(input_x[2], 1);
      idvd_poly_feat[581] = pow(input_x[0], 2) * pow(input_x[1], 6) * pow(input_x[3], 1);
      idvd_poly_feat[582] = pow(input_x[0], 2) * pow(input_x[1], 5) * pow(input_x[2], 2);
      idvd_poly_feat[583] = pow(input_x[0], 2) * pow(input_x[1], 5) * pow(input_x[2], 1) * pow(input_x[3], 1);
      idvd_poly_feat[584] = pow(input_x[0], 2) * pow(input_x[1], 5) * pow(input_x[3], 2);
      idvd_poly_feat[585] = pow(input_x[0], 2) * pow(input_x[1], 4) * pow(input_x[2], 3);
      idvd_poly_feat[586] = pow(input_x[0], 2) * pow(input_x[1], 4) * pow(input_x[2], 2) * pow(input_x[3], 1);
      idvd_poly_feat[587] = pow(input_x[0], 2) * pow(input_x[1], 4) * pow(input_x[2], 1) * pow(input_x[3], 2);
      idvd_poly_feat[588] = pow(input_x[0], 2) * pow(input_x[1], 4) * pow(input_x[3], 3);
      idvd_poly_feat[589] = pow(input_x[0], 2) * pow(input_x[1], 3) * pow(input_x[2], 4);
      idvd_poly_feat[590] = pow(input_x[0], 2) * pow(input_x[1], 3) * pow(input_x[2], 3) * pow(input_x[3], 1);
      idvd_poly_feat[591] = pow(input_x[0], 2) * pow(input_x[1], 3) * pow(input_x[2], 2) * pow(input_x[3], 2);
      idvd_poly_feat[592] = pow(input_x[0], 2) * pow(input_x[1], 3) * pow(input_x[2], 1) * pow(input_x[3], 3);
      idvd_poly_feat[593] = pow(input_x[0], 2) * pow(input_x[1], 3) * pow(input_x[3], 4);
      idvd_poly_feat[594] = pow(input_x[0], 2) * pow(input_x[1], 2) * pow(input_x[2], 5);
      idvd_poly_feat[595] = pow(input_x[0], 2) * pow(input_x[1], 2) * pow(input_x[2], 4) * pow(input_x[3], 1);
      idvd_poly_feat[596] = pow(input_x[0], 2) * pow(input_x[1], 2) * pow(input_x[2], 3) * pow(input_x[3], 2);
      idvd_poly_feat[597] = pow(input_x[0], 2) * pow(input_x[1], 2) * pow(input_x[2], 2) * pow(input_x[3], 3);
      idvd_poly_feat[598] = pow(input_x[0], 2) * pow(input_x[1], 2) * pow(input_x[2], 1) * pow(input_x[3], 4);
      idvd_poly_feat[599] = pow(input_x[0], 2) * pow(input_x[1], 2) * pow(input_x[3], 5);
      idvd_poly_feat[600] = pow(input_x[0], 2) * pow(input_x[1], 1) * pow(input_x[2], 6);
      idvd_poly_feat[601] = pow(input_x[0], 2) * pow(input_x[1], 1) * pow(input_x[2], 5) * pow(input_x[3], 1);
      idvd_poly_feat[602] = pow(input_x[0], 2) * pow(input_x[1], 1) * pow(input_x[2], 4) * pow(input_x[3], 2);
      idvd_poly_feat[603] = pow(input_x[0], 2) * pow(input_x[1], 1) * pow(input_x[2], 3) * pow(input_x[3], 3);
      idvd_poly_feat[604] = pow(input_x[0], 2) * pow(input_x[1], 1) * pow(input_x[2], 2) * pow(input_x[3], 4);
      idvd_poly_feat[605] = pow(input_x[0], 2) * pow(input_x[1], 1) * pow(input_x[2], 1) * pow(input_x[3], 5);
      idvd_poly_feat[606] = pow(input_x[0], 2) * pow(input_x[1], 1) * pow(input_x[3], 6);
      idvd_poly_feat[607] = pow(input_x[0], 2) * pow(input_x[2], 7);
      idvd_poly_feat[608] = pow(input_x[0], 2) * pow(input_x[2], 6) * pow(input_x[3], 1);
      idvd_poly_feat[609] = pow(input_x[0], 2) * pow(input_x[2], 5) * pow(input_x[3], 2);
      idvd_poly_feat[610] = pow(input_x[0], 2) * pow(input_x[2], 4) * pow(input_x[3], 3);
      idvd_poly_feat[611] = pow(input_x[0], 2) * pow(input_x[2], 3) * pow(input_x[3], 4);
      idvd_poly_feat[612] = pow(input_x[0], 2) * pow(input_x[2], 2) * pow(input_x[3], 5);
      idvd_poly_feat[613] = pow(input_x[0], 2) * pow(input_x[2], 1) * pow(input_x[3], 6);
      idvd_poly_feat[614] = pow(input_x[0], 2) * pow(input_x[3], 7);
      idvd_poly_feat[615] = pow(input_x[0], 1) * pow(input_x[1], 8);
      idvd_poly_feat[616] = pow(input_x[0], 1) * pow(input_x[1], 7) * pow(input_x[2], 1);
      idvd_poly_feat[617] = pow(input_x[0], 1) * pow(input_x[1], 7) * pow(input_x[3], 1);
      idvd_poly_feat[618] = pow(input_x[0], 1) * pow(input_x[1], 6) * pow(input_x[2], 2);
      idvd_poly_feat[619] = pow(input_x[0], 1) * pow(input_x[1], 6) * pow(input_x[2], 1) * pow(input_x[3], 1);
      idvd_poly_feat[620] = pow(input_x[0], 1) * pow(input_x[1], 6) * pow(input_x[3], 2);
      idvd_poly_feat[621] = pow(input_x[0], 1) * pow(input_x[1], 5) * pow(input_x[2], 3);
      idvd_poly_feat[622] = pow(input_x[0], 1) * pow(input_x[1], 5) * pow(input_x[2], 2) * pow(input_x[3], 1);
      idvd_poly_feat[623] = pow(input_x[0], 1) * pow(input_x[1], 5) * pow(input_x[2], 1) * pow(input_x[3], 2);
      idvd_poly_feat[624] = pow(input_x[0], 1) * pow(input_x[1], 5) * pow(input_x[3], 3);
      idvd_poly_feat[625] = pow(input_x[0], 1) * pow(input_x[1], 4) * pow(input_x[2], 4);
      idvd_poly_feat[626] = pow(input_x[0], 1) * pow(input_x[1], 4) * pow(input_x[2], 3) * pow(input_x[3], 1);
      idvd_poly_feat[627] = pow(input_x[0], 1) * pow(input_x[1], 4) * pow(input_x[2], 2) * pow(input_x[3], 2);
      idvd_poly_feat[628] = pow(input_x[0], 1) * pow(input_x[1], 4) * pow(input_x[2], 1) * pow(input_x[3], 3);
      idvd_poly_feat[629] = pow(input_x[0], 1) * pow(input_x[1], 4) * pow(input_x[3], 4);
      idvd_poly_feat[630] = pow(input_x[0], 1) * pow(input_x[1], 3) * pow(input_x[2], 5);
      idvd_poly_feat[631] = pow(input_x[0], 1) * pow(input_x[1], 3) * pow(input_x[2], 4) * pow(input_x[3], 1);
      idvd_poly_feat[632] = pow(input_x[0], 1) * pow(input_x[1], 3) * pow(input_x[2], 3) * pow(input_x[3], 2);
      idvd_poly_feat[633] = pow(input_x[0], 1) * pow(input_x[1], 3) * pow(input_x[2], 2) * pow(input_x[3], 3);
      idvd_poly_feat[634] = pow(input_x[0], 1) * pow(input_x[1], 3) * pow(input_x[2], 1) * pow(input_x[3], 4);
      idvd_poly_feat[635] = pow(input_x[0], 1) * pow(input_x[1], 3) * pow(input_x[3], 5);
      idvd_poly_feat[636] = pow(input_x[0], 1) * pow(input_x[1], 2) * pow(input_x[2], 6);
      idvd_poly_feat[637] = pow(input_x[0], 1) * pow(input_x[1], 2) * pow(input_x[2], 5) * pow(input_x[3], 1);
      idvd_poly_feat[638] = pow(input_x[0], 1) * pow(input_x[1], 2) * pow(input_x[2], 4) * pow(input_x[3], 2);
      idvd_poly_feat[639] = pow(input_x[0], 1) * pow(input_x[1], 2) * pow(input_x[2], 3) * pow(input_x[3], 3);
      idvd_poly_feat[640] = pow(input_x[0], 1) * pow(input_x[1], 2) * pow(input_x[2], 2) * pow(input_x[3], 4);
      idvd_poly_feat[641] = pow(input_x[0], 1) * pow(input_x[1], 2) * pow(input_x[2], 1) * pow(input_x[3], 5);
      idvd_poly_feat[642] = pow(input_x[0], 1) * pow(input_x[1], 2) * pow(input_x[3], 6);
      idvd_poly_feat[643] = pow(input_x[0], 1) * pow(input_x[1], 1) * pow(input_x[2], 7);
      idvd_poly_feat[644] = pow(input_x[0], 1) * pow(input_x[1], 1) * pow(input_x[2], 6) * pow(input_x[3], 1);
      idvd_poly_feat[645] = pow(input_x[0], 1) * pow(input_x[1], 1) * pow(input_x[2], 5) * pow(input_x[3], 2);
      idvd_poly_feat[646] = pow(input_x[0], 1) * pow(input_x[1], 1) * pow(input_x[2], 4) * pow(input_x[3], 3);
      idvd_poly_feat[647] = pow(input_x[0], 1) * pow(input_x[1], 1) * pow(input_x[2], 3) * pow(input_x[3], 4);
      idvd_poly_feat[648] = pow(input_x[0], 1) * pow(input_x[1], 1) * pow(input_x[2], 2) * pow(input_x[3], 5);
      idvd_poly_feat[649] = pow(input_x[0], 1) * pow(input_x[1], 1) * pow(input_x[2], 1) * pow(input_x[3], 6);
      idvd_poly_feat[650] = pow(input_x[0], 1) * pow(input_x[1], 1) * pow(input_x[3], 7);
      idvd_poly_feat[651] = pow(input_x[0], 1) * pow(input_x[2], 8);
      idvd_poly_feat[652] = pow(input_x[0], 1) * pow(input_x[2], 7) * pow(input_x[3], 1);
      idvd_poly_feat[653] = pow(input_x[0], 1) * pow(input_x[2], 6) * pow(input_x[3], 2);
      idvd_poly_feat[654] = pow(input_x[0], 1) * pow(input_x[2], 5) * pow(input_x[3], 3);
      idvd_poly_feat[655] = pow(input_x[0], 1) * pow(input_x[2], 4) * pow(input_x[3], 4);
      idvd_poly_feat[656] = pow(input_x[0], 1) * pow(input_x[2], 3) * pow(input_x[3], 5);
      idvd_poly_feat[657] = pow(input_x[0], 1) * pow(input_x[2], 2) * pow(input_x[3], 6);
      idvd_poly_feat[658] = pow(input_x[0], 1) * pow(input_x[2], 1) * pow(input_x[3], 7);
      idvd_poly_feat[659] = pow(input_x[0], 1) * pow(input_x[3], 8);
      idvd_poly_feat[660] = pow(input_x[1], 9);
      idvd_poly_feat[661] = pow(input_x[1], 8) * pow(input_x[2], 1);
      idvd_poly_feat[662] = pow(input_x[1], 8) * pow(input_x[3], 1);
      idvd_poly_feat[663] = pow(input_x[1], 7) * pow(input_x[2], 2);
      idvd_poly_feat[664] = pow(input_x[1], 7) * pow(input_x[2], 1) * pow(input_x[3], 1);
      idvd_poly_feat[665] = pow(input_x[1], 7) * pow(input_x[3], 2);
      idvd_poly_feat[666] = pow(input_x[1], 6) * pow(input_x[2], 3);
      idvd_poly_feat[667] = pow(input_x[1], 6) * pow(input_x[2], 2) * pow(input_x[3], 1);
      idvd_poly_feat[668] = pow(input_x[1], 6) * pow(input_x[2], 1) * pow(input_x[3], 2);
      idvd_poly_feat[669] = pow(input_x[1], 6) * pow(input_x[3], 3);
      idvd_poly_feat[670] = pow(input_x[1], 5) * pow(input_x[2], 4);
      idvd_poly_feat[671] = pow(input_x[1], 5) * pow(input_x[2], 3) * pow(input_x[3], 1);
      idvd_poly_feat[672] = pow(input_x[1], 5) * pow(input_x[2], 2) * pow(input_x[3], 2);
      idvd_poly_feat[673] = pow(input_x[1], 5) * pow(input_x[2], 1) * pow(input_x[3], 3);
      idvd_poly_feat[674] = pow(input_x[1], 5) * pow(input_x[3], 4);
      idvd_poly_feat[675] = pow(input_x[1], 4) * pow(input_x[2], 5);
      idvd_poly_feat[676] = pow(input_x[1], 4) * pow(input_x[2], 4) * pow(input_x[3], 1);
      idvd_poly_feat[677] = pow(input_x[1], 4) * pow(input_x[2], 3) * pow(input_x[3], 2);
      idvd_poly_feat[678] = pow(input_x[1], 4) * pow(input_x[2], 2) * pow(input_x[3], 3);
      idvd_poly_feat[679] = pow(input_x[1], 4) * pow(input_x[2], 1) * pow(input_x[3], 4);
      idvd_poly_feat[680] = pow(input_x[1], 4) * pow(input_x[3], 5);
      idvd_poly_feat[681] = pow(input_x[1], 3) * pow(input_x[2], 6);
      idvd_poly_feat[682] = pow(input_x[1], 3) * pow(input_x[2], 5) * pow(input_x[3], 1);
      idvd_poly_feat[683] = pow(input_x[1], 3) * pow(input_x[2], 4) * pow(input_x[3], 2);
      idvd_poly_feat[684] = pow(input_x[1], 3) * pow(input_x[2], 3) * pow(input_x[3], 3);
      idvd_poly_feat[685] = pow(input_x[1], 3) * pow(input_x[2], 2) * pow(input_x[3], 4);
      idvd_poly_feat[686] = pow(input_x[1], 3) * pow(input_x[2], 1) * pow(input_x[3], 5);
      idvd_poly_feat[687] = pow(input_x[1], 3) * pow(input_x[3], 6);
      idvd_poly_feat[688] = pow(input_x[1], 2) * pow(input_x[2], 7);
      idvd_poly_feat[689] = pow(input_x[1], 2) * pow(input_x[2], 6) * pow(input_x[3], 1);
      idvd_poly_feat[690] = pow(input_x[1], 2) * pow(input_x[2], 5) * pow(input_x[3], 2);
      idvd_poly_feat[691] = pow(input_x[1], 2) * pow(input_x[2], 4) * pow(input_x[3], 3);
      idvd_poly_feat[692] = pow(input_x[1], 2) * pow(input_x[2], 3) * pow(input_x[3], 4);
      idvd_poly_feat[693] = pow(input_x[1], 2) * pow(input_x[2], 2) * pow(input_x[3], 5);
      idvd_poly_feat[694] = pow(input_x[1], 2) * pow(input_x[2], 1) * pow(input_x[3], 6);
      idvd_poly_feat[695] = pow(input_x[1], 2) * pow(input_x[3], 7);
      idvd_poly_feat[696] = pow(input_x[1], 1) * pow(input_x[2], 8);
      idvd_poly_feat[697] = pow(input_x[1], 1) * pow(input_x[2], 7) * pow(input_x[3], 1);
      idvd_poly_feat[698] = pow(input_x[1], 1) * pow(input_x[2], 6) * pow(input_x[3], 2);
      idvd_poly_feat[699] = pow(input_x[1], 1) * pow(input_x[2], 5) * pow(input_x[3], 3);
      idvd_poly_feat[700] = pow(input_x[1], 1) * pow(input_x[2], 4) * pow(input_x[3], 4);
      idvd_poly_feat[701] = pow(input_x[1], 1) * pow(input_x[2], 3) * pow(input_x[3], 5);
      idvd_poly_feat[702] = pow(input_x[1], 1) * pow(input_x[2], 2) * pow(input_x[3], 6);
      idvd_poly_feat[703] = pow(input_x[1], 1) * pow(input_x[2], 1) * pow(input_x[3], 7);
      idvd_poly_feat[704] = pow(input_x[1], 1) * pow(input_x[3], 8);
      idvd_poly_feat[705] = pow(input_x[2], 9);
      idvd_poly_feat[706] = pow(input_x[2], 8) * pow(input_x[3], 1);
      idvd_poly_feat[707] = pow(input_x[2], 7) * pow(input_x[3], 2);
      idvd_poly_feat[708] = pow(input_x[2], 6) * pow(input_x[3], 3);
      idvd_poly_feat[709] = pow(input_x[2], 5) * pow(input_x[3], 4);
      idvd_poly_feat[710] = pow(input_x[2], 4) * pow(input_x[3], 5);
      idvd_poly_feat[711] = pow(input_x[2], 3) * pow(input_x[3], 6);
      idvd_poly_feat[712] = pow(input_x[2], 2) * pow(input_x[3], 7);
      idvd_poly_feat[713] = pow(input_x[2], 1) * pow(input_x[3], 8);
      idvd_poly_feat[714] = pow(input_x[3], 9);
      idvd_poly_feat[715] = pow(input_x[0], 10);
      idvd_poly_feat[716] = pow(input_x[1], 10);
      idvd_poly_feat[717] = pow(input_x[2], 10);
      idvd_poly_feat[718] = pow(input_x[3], 10);
      idvd_poly_feat[719] = pow(input_x[0], 11);
      idvd_poly_feat[720] = pow(input_x[1], 11);
      idvd_poly_feat[721] = pow(input_x[2], 11);
      idvd_poly_feat[722] = pow(input_x[3], 11);
      for(i=0; i<5; i=i+1) begin
        tmp = idvd_poly_b[i];
        for(j=0; j<723; j=j+1) tmp = tmp + idvd_poly_w[i*723 + j] * idvd_poly_feat[j];
        idvd_z[i] = tmp * idvd_sl_mul[i] + idvd_sl_add[i];
      end
      for(i=0; i<68; i=i+1) begin
        tmp = idvd_ae_b0[i];
        for(j=0; j<5; j=j+1) tmp = tmp + idvd_ae_w0[i*5 + j] * idvd_z[j];
        idvd_h0[i] = (tmp > 0.0) ? tmp : 0.0;
      end
      for(i=0; i<270; i=i+1) begin
        tmp = idvd_ae_b1[i];
        for(j=0; j<68; j=j+1) tmp = tmp + idvd_ae_w1[i*68 + j] * idvd_h0[j];
        idvd_h1[i] = (tmp > 0.0) ? tmp : 0.0;
      end
      for(i=0; i<540; i=i+1) begin
        tmp = idvd_ae_b2[i];
        for(j=0; j<270; j=j+1) tmp = tmp + idvd_ae_w2[i*270 + j] * idvd_h1[j];
        idvd_h2[i] = (tmp > 0.0) ? tmp : 0.0;
      end
      for(i=0; i<1080; i=i+1) begin
        tmp = idvd_ae_b3[i];
        for(j=0; j<540; j=j+1) tmp = tmp + idvd_ae_w3[i*540 + j] * idvd_h2[j];
        tmp = 1.0 / (1.0 + exp(-tmp));
        idvd_out[i] = -1.0 * (tmp * idvd_siv_mul[i] + idvd_siv_add[i]);
      end

      input_x[0] = (1.0e-3 * Lg) * idvg_sx_mul[0] + idvg_sx_add[0];
      input_x[1] = (1.0e-3 * Lgs) * idvg_sx_mul[1] + idvg_sx_add[1];
      input_x[2] = (1.0e-3 * Tox) * idvg_sx_mul[2] + idvg_sx_add[2];
      input_x[3] = Rc * idvg_sx_mul[3] + idvg_sx_add[3];
      idvg_poly_feat[0] = 1.0;
      idvg_poly_feat[1] = pow(input_x[0], 1);
      idvg_poly_feat[2] = pow(input_x[1], 1);
      idvg_poly_feat[3] = pow(input_x[2], 1);
      idvg_poly_feat[4] = pow(input_x[3], 1);
      idvg_poly_feat[5] = pow(input_x[0], 2);
      idvg_poly_feat[6] = pow(input_x[0], 1) * pow(input_x[1], 1);
      idvg_poly_feat[7] = pow(input_x[0], 1) * pow(input_x[2], 1);
      idvg_poly_feat[8] = pow(input_x[0], 1) * pow(input_x[3], 1);
      idvg_poly_feat[9] = pow(input_x[1], 2);
      idvg_poly_feat[10] = pow(input_x[1], 1) * pow(input_x[2], 1);
      idvg_poly_feat[11] = pow(input_x[1], 1) * pow(input_x[3], 1);
      idvg_poly_feat[12] = pow(input_x[2], 2);
      idvg_poly_feat[13] = pow(input_x[2], 1) * pow(input_x[3], 1);
      idvg_poly_feat[14] = pow(input_x[3], 2);
      idvg_poly_feat[15] = pow(input_x[0], 3);
      idvg_poly_feat[16] = pow(input_x[0], 2) * pow(input_x[1], 1);
      idvg_poly_feat[17] = pow(input_x[0], 2) * pow(input_x[2], 1);
      idvg_poly_feat[18] = pow(input_x[0], 2) * pow(input_x[3], 1);
      idvg_poly_feat[19] = pow(input_x[0], 1) * pow(input_x[1], 2);
      idvg_poly_feat[20] = pow(input_x[0], 1) * pow(input_x[1], 1) * pow(input_x[2], 1);
      idvg_poly_feat[21] = pow(input_x[0], 1) * pow(input_x[1], 1) * pow(input_x[3], 1);
      idvg_poly_feat[22] = pow(input_x[0], 1) * pow(input_x[2], 2);
      idvg_poly_feat[23] = pow(input_x[0], 1) * pow(input_x[2], 1) * pow(input_x[3], 1);
      idvg_poly_feat[24] = pow(input_x[0], 1) * pow(input_x[3], 2);
      idvg_poly_feat[25] = pow(input_x[1], 3);
      idvg_poly_feat[26] = pow(input_x[1], 2) * pow(input_x[2], 1);
      idvg_poly_feat[27] = pow(input_x[1], 2) * pow(input_x[3], 1);
      idvg_poly_feat[28] = pow(input_x[1], 1) * pow(input_x[2], 2);
      idvg_poly_feat[29] = pow(input_x[1], 1) * pow(input_x[2], 1) * pow(input_x[3], 1);
      idvg_poly_feat[30] = pow(input_x[1], 1) * pow(input_x[3], 2);
      idvg_poly_feat[31] = pow(input_x[2], 3);
      idvg_poly_feat[32] = pow(input_x[2], 2) * pow(input_x[3], 1);
      idvg_poly_feat[33] = pow(input_x[2], 1) * pow(input_x[3], 2);
      idvg_poly_feat[34] = pow(input_x[3], 3);
      idvg_poly_feat[35] = pow(input_x[0], 4);
      idvg_poly_feat[36] = pow(input_x[0], 3) * pow(input_x[1], 1);
      idvg_poly_feat[37] = pow(input_x[0], 3) * pow(input_x[2], 1);
      idvg_poly_feat[38] = pow(input_x[0], 3) * pow(input_x[3], 1);
      idvg_poly_feat[39] = pow(input_x[0], 2) * pow(input_x[1], 2);
      idvg_poly_feat[40] = pow(input_x[0], 2) * pow(input_x[1], 1) * pow(input_x[2], 1);
      idvg_poly_feat[41] = pow(input_x[0], 2) * pow(input_x[1], 1) * pow(input_x[3], 1);
      idvg_poly_feat[42] = pow(input_x[0], 2) * pow(input_x[2], 2);
      idvg_poly_feat[43] = pow(input_x[0], 2) * pow(input_x[2], 1) * pow(input_x[3], 1);
      idvg_poly_feat[44] = pow(input_x[0], 2) * pow(input_x[3], 2);
      idvg_poly_feat[45] = pow(input_x[0], 1) * pow(input_x[1], 3);
      idvg_poly_feat[46] = pow(input_x[0], 1) * pow(input_x[1], 2) * pow(input_x[2], 1);
      idvg_poly_feat[47] = pow(input_x[0], 1) * pow(input_x[1], 2) * pow(input_x[3], 1);
      idvg_poly_feat[48] = pow(input_x[0], 1) * pow(input_x[1], 1) * pow(input_x[2], 2);
      idvg_poly_feat[49] = pow(input_x[0], 1) * pow(input_x[1], 1) * pow(input_x[2], 1) * pow(input_x[3], 1);
      idvg_poly_feat[50] = pow(input_x[0], 1) * pow(input_x[1], 1) * pow(input_x[3], 2);
      idvg_poly_feat[51] = pow(input_x[0], 1) * pow(input_x[2], 3);
      idvg_poly_feat[52] = pow(input_x[0], 1) * pow(input_x[2], 2) * pow(input_x[3], 1);
      idvg_poly_feat[53] = pow(input_x[0], 1) * pow(input_x[2], 1) * pow(input_x[3], 2);
      idvg_poly_feat[54] = pow(input_x[0], 1) * pow(input_x[3], 3);
      idvg_poly_feat[55] = pow(input_x[1], 4);
      idvg_poly_feat[56] = pow(input_x[1], 3) * pow(input_x[2], 1);
      idvg_poly_feat[57] = pow(input_x[1], 3) * pow(input_x[3], 1);
      idvg_poly_feat[58] = pow(input_x[1], 2) * pow(input_x[2], 2);
      idvg_poly_feat[59] = pow(input_x[1], 2) * pow(input_x[2], 1) * pow(input_x[3], 1);
      idvg_poly_feat[60] = pow(input_x[1], 2) * pow(input_x[3], 2);
      idvg_poly_feat[61] = pow(input_x[1], 1) * pow(input_x[2], 3);
      idvg_poly_feat[62] = pow(input_x[1], 1) * pow(input_x[2], 2) * pow(input_x[3], 1);
      idvg_poly_feat[63] = pow(input_x[1], 1) * pow(input_x[2], 1) * pow(input_x[3], 2);
      idvg_poly_feat[64] = pow(input_x[1], 1) * pow(input_x[3], 3);
      idvg_poly_feat[65] = pow(input_x[2], 4);
      idvg_poly_feat[66] = pow(input_x[2], 3) * pow(input_x[3], 1);
      idvg_poly_feat[67] = pow(input_x[2], 2) * pow(input_x[3], 2);
      idvg_poly_feat[68] = pow(input_x[2], 1) * pow(input_x[3], 3);
      idvg_poly_feat[69] = pow(input_x[3], 4);
      idvg_poly_feat[70] = pow(input_x[0], 5);
      idvg_poly_feat[71] = pow(input_x[0], 4) * pow(input_x[1], 1);
      idvg_poly_feat[72] = pow(input_x[0], 4) * pow(input_x[2], 1);
      idvg_poly_feat[73] = pow(input_x[0], 4) * pow(input_x[3], 1);
      idvg_poly_feat[74] = pow(input_x[0], 3) * pow(input_x[1], 2);
      idvg_poly_feat[75] = pow(input_x[0], 3) * pow(input_x[1], 1) * pow(input_x[2], 1);
      idvg_poly_feat[76] = pow(input_x[0], 3) * pow(input_x[1], 1) * pow(input_x[3], 1);
      idvg_poly_feat[77] = pow(input_x[0], 3) * pow(input_x[2], 2);
      idvg_poly_feat[78] = pow(input_x[0], 3) * pow(input_x[2], 1) * pow(input_x[3], 1);
      idvg_poly_feat[79] = pow(input_x[0], 3) * pow(input_x[3], 2);
      idvg_poly_feat[80] = pow(input_x[0], 2) * pow(input_x[1], 3);
      idvg_poly_feat[81] = pow(input_x[0], 2) * pow(input_x[1], 2) * pow(input_x[2], 1);
      idvg_poly_feat[82] = pow(input_x[0], 2) * pow(input_x[1], 2) * pow(input_x[3], 1);
      idvg_poly_feat[83] = pow(input_x[0], 2) * pow(input_x[1], 1) * pow(input_x[2], 2);
      idvg_poly_feat[84] = pow(input_x[0], 2) * pow(input_x[1], 1) * pow(input_x[2], 1) * pow(input_x[3], 1);
      idvg_poly_feat[85] = pow(input_x[0], 2) * pow(input_x[1], 1) * pow(input_x[3], 2);
      idvg_poly_feat[86] = pow(input_x[0], 2) * pow(input_x[2], 3);
      idvg_poly_feat[87] = pow(input_x[0], 2) * pow(input_x[2], 2) * pow(input_x[3], 1);
      idvg_poly_feat[88] = pow(input_x[0], 2) * pow(input_x[2], 1) * pow(input_x[3], 2);
      idvg_poly_feat[89] = pow(input_x[0], 2) * pow(input_x[3], 3);
      idvg_poly_feat[90] = pow(input_x[0], 1) * pow(input_x[1], 4);
      idvg_poly_feat[91] = pow(input_x[0], 1) * pow(input_x[1], 3) * pow(input_x[2], 1);
      idvg_poly_feat[92] = pow(input_x[0], 1) * pow(input_x[1], 3) * pow(input_x[3], 1);
      idvg_poly_feat[93] = pow(input_x[0], 1) * pow(input_x[1], 2) * pow(input_x[2], 2);
      idvg_poly_feat[94] = pow(input_x[0], 1) * pow(input_x[1], 2) * pow(input_x[2], 1) * pow(input_x[3], 1);
      idvg_poly_feat[95] = pow(input_x[0], 1) * pow(input_x[1], 2) * pow(input_x[3], 2);
      idvg_poly_feat[96] = pow(input_x[0], 1) * pow(input_x[1], 1) * pow(input_x[2], 3);
      idvg_poly_feat[97] = pow(input_x[0], 1) * pow(input_x[1], 1) * pow(input_x[2], 2) * pow(input_x[3], 1);
      idvg_poly_feat[98] = pow(input_x[0], 1) * pow(input_x[1], 1) * pow(input_x[2], 1) * pow(input_x[3], 2);
      idvg_poly_feat[99] = pow(input_x[0], 1) * pow(input_x[1], 1) * pow(input_x[3], 3);
      idvg_poly_feat[100] = pow(input_x[0], 1) * pow(input_x[2], 4);
      idvg_poly_feat[101] = pow(input_x[0], 1) * pow(input_x[2], 3) * pow(input_x[3], 1);
      idvg_poly_feat[102] = pow(input_x[0], 1) * pow(input_x[2], 2) * pow(input_x[3], 2);
      idvg_poly_feat[103] = pow(input_x[0], 1) * pow(input_x[2], 1) * pow(input_x[3], 3);
      idvg_poly_feat[104] = pow(input_x[0], 1) * pow(input_x[3], 4);
      idvg_poly_feat[105] = pow(input_x[1], 5);
      idvg_poly_feat[106] = pow(input_x[1], 4) * pow(input_x[2], 1);
      idvg_poly_feat[107] = pow(input_x[1], 4) * pow(input_x[3], 1);
      idvg_poly_feat[108] = pow(input_x[1], 3) * pow(input_x[2], 2);
      idvg_poly_feat[109] = pow(input_x[1], 3) * pow(input_x[2], 1) * pow(input_x[3], 1);
      idvg_poly_feat[110] = pow(input_x[1], 3) * pow(input_x[3], 2);
      idvg_poly_feat[111] = pow(input_x[1], 2) * pow(input_x[2], 3);
      idvg_poly_feat[112] = pow(input_x[1], 2) * pow(input_x[2], 2) * pow(input_x[3], 1);
      idvg_poly_feat[113] = pow(input_x[1], 2) * pow(input_x[2], 1) * pow(input_x[3], 2);
      idvg_poly_feat[114] = pow(input_x[1], 2) * pow(input_x[3], 3);
      idvg_poly_feat[115] = pow(input_x[1], 1) * pow(input_x[2], 4);
      idvg_poly_feat[116] = pow(input_x[1], 1) * pow(input_x[2], 3) * pow(input_x[3], 1);
      idvg_poly_feat[117] = pow(input_x[1], 1) * pow(input_x[2], 2) * pow(input_x[3], 2);
      idvg_poly_feat[118] = pow(input_x[1], 1) * pow(input_x[2], 1) * pow(input_x[3], 3);
      idvg_poly_feat[119] = pow(input_x[1], 1) * pow(input_x[3], 4);
      idvg_poly_feat[120] = pow(input_x[2], 5);
      idvg_poly_feat[121] = pow(input_x[2], 4) * pow(input_x[3], 1);
      idvg_poly_feat[122] = pow(input_x[2], 3) * pow(input_x[3], 2);
      idvg_poly_feat[123] = pow(input_x[2], 2) * pow(input_x[3], 3);
      idvg_poly_feat[124] = pow(input_x[2], 1) * pow(input_x[3], 4);
      idvg_poly_feat[125] = pow(input_x[3], 5);
      idvg_poly_feat[126] = pow(input_x[0], 6);
      idvg_poly_feat[127] = pow(input_x[0], 5) * pow(input_x[1], 1);
      idvg_poly_feat[128] = pow(input_x[0], 5) * pow(input_x[2], 1);
      idvg_poly_feat[129] = pow(input_x[0], 5) * pow(input_x[3], 1);
      idvg_poly_feat[130] = pow(input_x[0], 4) * pow(input_x[1], 2);
      idvg_poly_feat[131] = pow(input_x[0], 4) * pow(input_x[1], 1) * pow(input_x[2], 1);
      idvg_poly_feat[132] = pow(input_x[0], 4) * pow(input_x[1], 1) * pow(input_x[3], 1);
      idvg_poly_feat[133] = pow(input_x[0], 4) * pow(input_x[2], 2);
      idvg_poly_feat[134] = pow(input_x[0], 4) * pow(input_x[2], 1) * pow(input_x[3], 1);
      idvg_poly_feat[135] = pow(input_x[0], 4) * pow(input_x[3], 2);
      idvg_poly_feat[136] = pow(input_x[0], 3) * pow(input_x[1], 3);
      idvg_poly_feat[137] = pow(input_x[0], 3) * pow(input_x[1], 2) * pow(input_x[2], 1);
      idvg_poly_feat[138] = pow(input_x[0], 3) * pow(input_x[1], 2) * pow(input_x[3], 1);
      idvg_poly_feat[139] = pow(input_x[0], 3) * pow(input_x[1], 1) * pow(input_x[2], 2);
      idvg_poly_feat[140] = pow(input_x[0], 3) * pow(input_x[1], 1) * pow(input_x[2], 1) * pow(input_x[3], 1);
      idvg_poly_feat[141] = pow(input_x[0], 3) * pow(input_x[1], 1) * pow(input_x[3], 2);
      idvg_poly_feat[142] = pow(input_x[0], 3) * pow(input_x[2], 3);
      idvg_poly_feat[143] = pow(input_x[0], 3) * pow(input_x[2], 2) * pow(input_x[3], 1);
      idvg_poly_feat[144] = pow(input_x[0], 3) * pow(input_x[2], 1) * pow(input_x[3], 2);
      idvg_poly_feat[145] = pow(input_x[0], 3) * pow(input_x[3], 3);
      idvg_poly_feat[146] = pow(input_x[0], 2) * pow(input_x[1], 4);
      idvg_poly_feat[147] = pow(input_x[0], 2) * pow(input_x[1], 3) * pow(input_x[2], 1);
      idvg_poly_feat[148] = pow(input_x[0], 2) * pow(input_x[1], 3) * pow(input_x[3], 1);
      idvg_poly_feat[149] = pow(input_x[0], 2) * pow(input_x[1], 2) * pow(input_x[2], 2);
      idvg_poly_feat[150] = pow(input_x[0], 2) * pow(input_x[1], 2) * pow(input_x[2], 1) * pow(input_x[3], 1);
      idvg_poly_feat[151] = pow(input_x[0], 2) * pow(input_x[1], 2) * pow(input_x[3], 2);
      idvg_poly_feat[152] = pow(input_x[0], 2) * pow(input_x[1], 1) * pow(input_x[2], 3);
      idvg_poly_feat[153] = pow(input_x[0], 2) * pow(input_x[1], 1) * pow(input_x[2], 2) * pow(input_x[3], 1);
      idvg_poly_feat[154] = pow(input_x[0], 2) * pow(input_x[1], 1) * pow(input_x[2], 1) * pow(input_x[3], 2);
      idvg_poly_feat[155] = pow(input_x[0], 2) * pow(input_x[1], 1) * pow(input_x[3], 3);
      idvg_poly_feat[156] = pow(input_x[0], 2) * pow(input_x[2], 4);
      idvg_poly_feat[157] = pow(input_x[0], 2) * pow(input_x[2], 3) * pow(input_x[3], 1);
      idvg_poly_feat[158] = pow(input_x[0], 2) * pow(input_x[2], 2) * pow(input_x[3], 2);
      idvg_poly_feat[159] = pow(input_x[0], 2) * pow(input_x[2], 1) * pow(input_x[3], 3);
      idvg_poly_feat[160] = pow(input_x[0], 2) * pow(input_x[3], 4);
      idvg_poly_feat[161] = pow(input_x[0], 1) * pow(input_x[1], 5);
      idvg_poly_feat[162] = pow(input_x[0], 1) * pow(input_x[1], 4) * pow(input_x[2], 1);
      idvg_poly_feat[163] = pow(input_x[0], 1) * pow(input_x[1], 4) * pow(input_x[3], 1);
      idvg_poly_feat[164] = pow(input_x[0], 1) * pow(input_x[1], 3) * pow(input_x[2], 2);
      idvg_poly_feat[165] = pow(input_x[0], 1) * pow(input_x[1], 3) * pow(input_x[2], 1) * pow(input_x[3], 1);
      idvg_poly_feat[166] = pow(input_x[0], 1) * pow(input_x[1], 3) * pow(input_x[3], 2);
      idvg_poly_feat[167] = pow(input_x[0], 1) * pow(input_x[1], 2) * pow(input_x[2], 3);
      idvg_poly_feat[168] = pow(input_x[0], 1) * pow(input_x[1], 2) * pow(input_x[2], 2) * pow(input_x[3], 1);
      idvg_poly_feat[169] = pow(input_x[0], 1) * pow(input_x[1], 2) * pow(input_x[2], 1) * pow(input_x[3], 2);
      idvg_poly_feat[170] = pow(input_x[0], 1) * pow(input_x[1], 2) * pow(input_x[3], 3);
      idvg_poly_feat[171] = pow(input_x[0], 1) * pow(input_x[1], 1) * pow(input_x[2], 4);
      idvg_poly_feat[172] = pow(input_x[0], 1) * pow(input_x[1], 1) * pow(input_x[2], 3) * pow(input_x[3], 1);
      idvg_poly_feat[173] = pow(input_x[0], 1) * pow(input_x[1], 1) * pow(input_x[2], 2) * pow(input_x[3], 2);
      idvg_poly_feat[174] = pow(input_x[0], 1) * pow(input_x[1], 1) * pow(input_x[2], 1) * pow(input_x[3], 3);
      idvg_poly_feat[175] = pow(input_x[0], 1) * pow(input_x[1], 1) * pow(input_x[3], 4);
      idvg_poly_feat[176] = pow(input_x[0], 1) * pow(input_x[2], 5);
      idvg_poly_feat[177] = pow(input_x[0], 1) * pow(input_x[2], 4) * pow(input_x[3], 1);
      idvg_poly_feat[178] = pow(input_x[0], 1) * pow(input_x[2], 3) * pow(input_x[3], 2);
      idvg_poly_feat[179] = pow(input_x[0], 1) * pow(input_x[2], 2) * pow(input_x[3], 3);
      idvg_poly_feat[180] = pow(input_x[0], 1) * pow(input_x[2], 1) * pow(input_x[3], 4);
      idvg_poly_feat[181] = pow(input_x[0], 1) * pow(input_x[3], 5);
      idvg_poly_feat[182] = pow(input_x[1], 6);
      idvg_poly_feat[183] = pow(input_x[1], 5) * pow(input_x[2], 1);
      idvg_poly_feat[184] = pow(input_x[1], 5) * pow(input_x[3], 1);
      idvg_poly_feat[185] = pow(input_x[1], 4) * pow(input_x[2], 2);
      idvg_poly_feat[186] = pow(input_x[1], 4) * pow(input_x[2], 1) * pow(input_x[3], 1);
      idvg_poly_feat[187] = pow(input_x[1], 4) * pow(input_x[3], 2);
      idvg_poly_feat[188] = pow(input_x[1], 3) * pow(input_x[2], 3);
      idvg_poly_feat[189] = pow(input_x[1], 3) * pow(input_x[2], 2) * pow(input_x[3], 1);
      idvg_poly_feat[190] = pow(input_x[1], 3) * pow(input_x[2], 1) * pow(input_x[3], 2);
      idvg_poly_feat[191] = pow(input_x[1], 3) * pow(input_x[3], 3);
      idvg_poly_feat[192] = pow(input_x[1], 2) * pow(input_x[2], 4);
      idvg_poly_feat[193] = pow(input_x[1], 2) * pow(input_x[2], 3) * pow(input_x[3], 1);
      idvg_poly_feat[194] = pow(input_x[1], 2) * pow(input_x[2], 2) * pow(input_x[3], 2);
      idvg_poly_feat[195] = pow(input_x[1], 2) * pow(input_x[2], 1) * pow(input_x[3], 3);
      idvg_poly_feat[196] = pow(input_x[1], 2) * pow(input_x[3], 4);
      idvg_poly_feat[197] = pow(input_x[1], 1) * pow(input_x[2], 5);
      idvg_poly_feat[198] = pow(input_x[1], 1) * pow(input_x[2], 4) * pow(input_x[3], 1);
      idvg_poly_feat[199] = pow(input_x[1], 1) * pow(input_x[2], 3) * pow(input_x[3], 2);
      idvg_poly_feat[200] = pow(input_x[1], 1) * pow(input_x[2], 2) * pow(input_x[3], 3);
      idvg_poly_feat[201] = pow(input_x[1], 1) * pow(input_x[2], 1) * pow(input_x[3], 4);
      idvg_poly_feat[202] = pow(input_x[1], 1) * pow(input_x[3], 5);
      idvg_poly_feat[203] = pow(input_x[2], 6);
      idvg_poly_feat[204] = pow(input_x[2], 5) * pow(input_x[3], 1);
      idvg_poly_feat[205] = pow(input_x[2], 4) * pow(input_x[3], 2);
      idvg_poly_feat[206] = pow(input_x[2], 3) * pow(input_x[3], 3);
      idvg_poly_feat[207] = pow(input_x[2], 2) * pow(input_x[3], 4);
      idvg_poly_feat[208] = pow(input_x[2], 1) * pow(input_x[3], 5);
      idvg_poly_feat[209] = pow(input_x[3], 6);
      idvg_poly_feat[210] = pow(input_x[0], 7);
      idvg_poly_feat[211] = pow(input_x[0], 6) * pow(input_x[1], 1);
      idvg_poly_feat[212] = pow(input_x[0], 6) * pow(input_x[2], 1);
      idvg_poly_feat[213] = pow(input_x[0], 6) * pow(input_x[3], 1);
      idvg_poly_feat[214] = pow(input_x[0], 5) * pow(input_x[1], 2);
      idvg_poly_feat[215] = pow(input_x[0], 5) * pow(input_x[1], 1) * pow(input_x[2], 1);
      idvg_poly_feat[216] = pow(input_x[0], 5) * pow(input_x[1], 1) * pow(input_x[3], 1);
      idvg_poly_feat[217] = pow(input_x[0], 5) * pow(input_x[2], 2);
      idvg_poly_feat[218] = pow(input_x[0], 5) * pow(input_x[2], 1) * pow(input_x[3], 1);
      idvg_poly_feat[219] = pow(input_x[0], 5) * pow(input_x[3], 2);
      idvg_poly_feat[220] = pow(input_x[0], 4) * pow(input_x[1], 3);
      idvg_poly_feat[221] = pow(input_x[0], 4) * pow(input_x[1], 2) * pow(input_x[2], 1);
      idvg_poly_feat[222] = pow(input_x[0], 4) * pow(input_x[1], 2) * pow(input_x[3], 1);
      idvg_poly_feat[223] = pow(input_x[0], 4) * pow(input_x[1], 1) * pow(input_x[2], 2);
      idvg_poly_feat[224] = pow(input_x[0], 4) * pow(input_x[1], 1) * pow(input_x[2], 1) * pow(input_x[3], 1);
      idvg_poly_feat[225] = pow(input_x[0], 4) * pow(input_x[1], 1) * pow(input_x[3], 2);
      idvg_poly_feat[226] = pow(input_x[0], 4) * pow(input_x[2], 3);
      idvg_poly_feat[227] = pow(input_x[0], 4) * pow(input_x[2], 2) * pow(input_x[3], 1);
      idvg_poly_feat[228] = pow(input_x[0], 4) * pow(input_x[2], 1) * pow(input_x[3], 2);
      idvg_poly_feat[229] = pow(input_x[0], 4) * pow(input_x[3], 3);
      idvg_poly_feat[230] = pow(input_x[0], 3) * pow(input_x[1], 4);
      idvg_poly_feat[231] = pow(input_x[0], 3) * pow(input_x[1], 3) * pow(input_x[2], 1);
      idvg_poly_feat[232] = pow(input_x[0], 3) * pow(input_x[1], 3) * pow(input_x[3], 1);
      idvg_poly_feat[233] = pow(input_x[0], 3) * pow(input_x[1], 2) * pow(input_x[2], 2);
      idvg_poly_feat[234] = pow(input_x[0], 3) * pow(input_x[1], 2) * pow(input_x[2], 1) * pow(input_x[3], 1);
      idvg_poly_feat[235] = pow(input_x[0], 3) * pow(input_x[1], 2) * pow(input_x[3], 2);
      idvg_poly_feat[236] = pow(input_x[0], 3) * pow(input_x[1], 1) * pow(input_x[2], 3);
      idvg_poly_feat[237] = pow(input_x[0], 3) * pow(input_x[1], 1) * pow(input_x[2], 2) * pow(input_x[3], 1);
      idvg_poly_feat[238] = pow(input_x[0], 3) * pow(input_x[1], 1) * pow(input_x[2], 1) * pow(input_x[3], 2);
      idvg_poly_feat[239] = pow(input_x[0], 3) * pow(input_x[1], 1) * pow(input_x[3], 3);
      idvg_poly_feat[240] = pow(input_x[0], 3) * pow(input_x[2], 4);
      idvg_poly_feat[241] = pow(input_x[0], 3) * pow(input_x[2], 3) * pow(input_x[3], 1);
      idvg_poly_feat[242] = pow(input_x[0], 3) * pow(input_x[2], 2) * pow(input_x[3], 2);
      idvg_poly_feat[243] = pow(input_x[0], 3) * pow(input_x[2], 1) * pow(input_x[3], 3);
      idvg_poly_feat[244] = pow(input_x[0], 3) * pow(input_x[3], 4);
      idvg_poly_feat[245] = pow(input_x[0], 2) * pow(input_x[1], 5);
      idvg_poly_feat[246] = pow(input_x[0], 2) * pow(input_x[1], 4) * pow(input_x[2], 1);
      idvg_poly_feat[247] = pow(input_x[0], 2) * pow(input_x[1], 4) * pow(input_x[3], 1);
      idvg_poly_feat[248] = pow(input_x[0], 2) * pow(input_x[1], 3) * pow(input_x[2], 2);
      idvg_poly_feat[249] = pow(input_x[0], 2) * pow(input_x[1], 3) * pow(input_x[2], 1) * pow(input_x[3], 1);
      idvg_poly_feat[250] = pow(input_x[0], 2) * pow(input_x[1], 3) * pow(input_x[3], 2);
      idvg_poly_feat[251] = pow(input_x[0], 2) * pow(input_x[1], 2) * pow(input_x[2], 3);
      idvg_poly_feat[252] = pow(input_x[0], 2) * pow(input_x[1], 2) * pow(input_x[2], 2) * pow(input_x[3], 1);
      idvg_poly_feat[253] = pow(input_x[0], 2) * pow(input_x[1], 2) * pow(input_x[2], 1) * pow(input_x[3], 2);
      idvg_poly_feat[254] = pow(input_x[0], 2) * pow(input_x[1], 2) * pow(input_x[3], 3);
      idvg_poly_feat[255] = pow(input_x[0], 2) * pow(input_x[1], 1) * pow(input_x[2], 4);
      idvg_poly_feat[256] = pow(input_x[0], 2) * pow(input_x[1], 1) * pow(input_x[2], 3) * pow(input_x[3], 1);
      idvg_poly_feat[257] = pow(input_x[0], 2) * pow(input_x[1], 1) * pow(input_x[2], 2) * pow(input_x[3], 2);
      idvg_poly_feat[258] = pow(input_x[0], 2) * pow(input_x[1], 1) * pow(input_x[2], 1) * pow(input_x[3], 3);
      idvg_poly_feat[259] = pow(input_x[0], 2) * pow(input_x[1], 1) * pow(input_x[3], 4);
      idvg_poly_feat[260] = pow(input_x[0], 2) * pow(input_x[2], 5);
      idvg_poly_feat[261] = pow(input_x[0], 2) * pow(input_x[2], 4) * pow(input_x[3], 1);
      idvg_poly_feat[262] = pow(input_x[0], 2) * pow(input_x[2], 3) * pow(input_x[3], 2);
      idvg_poly_feat[263] = pow(input_x[0], 2) * pow(input_x[2], 2) * pow(input_x[3], 3);
      idvg_poly_feat[264] = pow(input_x[0], 2) * pow(input_x[2], 1) * pow(input_x[3], 4);
      idvg_poly_feat[265] = pow(input_x[0], 2) * pow(input_x[3], 5);
      idvg_poly_feat[266] = pow(input_x[0], 1) * pow(input_x[1], 6);
      idvg_poly_feat[267] = pow(input_x[0], 1) * pow(input_x[1], 5) * pow(input_x[2], 1);
      idvg_poly_feat[268] = pow(input_x[0], 1) * pow(input_x[1], 5) * pow(input_x[3], 1);
      idvg_poly_feat[269] = pow(input_x[0], 1) * pow(input_x[1], 4) * pow(input_x[2], 2);
      idvg_poly_feat[270] = pow(input_x[0], 1) * pow(input_x[1], 4) * pow(input_x[2], 1) * pow(input_x[3], 1);
      idvg_poly_feat[271] = pow(input_x[0], 1) * pow(input_x[1], 4) * pow(input_x[3], 2);
      idvg_poly_feat[272] = pow(input_x[0], 1) * pow(input_x[1], 3) * pow(input_x[2], 3);
      idvg_poly_feat[273] = pow(input_x[0], 1) * pow(input_x[1], 3) * pow(input_x[2], 2) * pow(input_x[3], 1);
      idvg_poly_feat[274] = pow(input_x[0], 1) * pow(input_x[1], 3) * pow(input_x[2], 1) * pow(input_x[3], 2);
      idvg_poly_feat[275] = pow(input_x[0], 1) * pow(input_x[1], 3) * pow(input_x[3], 3);
      idvg_poly_feat[276] = pow(input_x[0], 1) * pow(input_x[1], 2) * pow(input_x[2], 4);
      idvg_poly_feat[277] = pow(input_x[0], 1) * pow(input_x[1], 2) * pow(input_x[2], 3) * pow(input_x[3], 1);
      idvg_poly_feat[278] = pow(input_x[0], 1) * pow(input_x[1], 2) * pow(input_x[2], 2) * pow(input_x[3], 2);
      idvg_poly_feat[279] = pow(input_x[0], 1) * pow(input_x[1], 2) * pow(input_x[2], 1) * pow(input_x[3], 3);
      idvg_poly_feat[280] = pow(input_x[0], 1) * pow(input_x[1], 2) * pow(input_x[3], 4);
      idvg_poly_feat[281] = pow(input_x[0], 1) * pow(input_x[1], 1) * pow(input_x[2], 5);
      idvg_poly_feat[282] = pow(input_x[0], 1) * pow(input_x[1], 1) * pow(input_x[2], 4) * pow(input_x[3], 1);
      idvg_poly_feat[283] = pow(input_x[0], 1) * pow(input_x[1], 1) * pow(input_x[2], 3) * pow(input_x[3], 2);
      idvg_poly_feat[284] = pow(input_x[0], 1) * pow(input_x[1], 1) * pow(input_x[2], 2) * pow(input_x[3], 3);
      idvg_poly_feat[285] = pow(input_x[0], 1) * pow(input_x[1], 1) * pow(input_x[2], 1) * pow(input_x[3], 4);
      idvg_poly_feat[286] = pow(input_x[0], 1) * pow(input_x[1], 1) * pow(input_x[3], 5);
      idvg_poly_feat[287] = pow(input_x[0], 1) * pow(input_x[2], 6);
      idvg_poly_feat[288] = pow(input_x[0], 1) * pow(input_x[2], 5) * pow(input_x[3], 1);
      idvg_poly_feat[289] = pow(input_x[0], 1) * pow(input_x[2], 4) * pow(input_x[3], 2);
      idvg_poly_feat[290] = pow(input_x[0], 1) * pow(input_x[2], 3) * pow(input_x[3], 3);
      idvg_poly_feat[291] = pow(input_x[0], 1) * pow(input_x[2], 2) * pow(input_x[3], 4);
      idvg_poly_feat[292] = pow(input_x[0], 1) * pow(input_x[2], 1) * pow(input_x[3], 5);
      idvg_poly_feat[293] = pow(input_x[0], 1) * pow(input_x[3], 6);
      idvg_poly_feat[294] = pow(input_x[1], 7);
      idvg_poly_feat[295] = pow(input_x[1], 6) * pow(input_x[2], 1);
      idvg_poly_feat[296] = pow(input_x[1], 6) * pow(input_x[3], 1);
      idvg_poly_feat[297] = pow(input_x[1], 5) * pow(input_x[2], 2);
      idvg_poly_feat[298] = pow(input_x[1], 5) * pow(input_x[2], 1) * pow(input_x[3], 1);
      idvg_poly_feat[299] = pow(input_x[1], 5) * pow(input_x[3], 2);
      idvg_poly_feat[300] = pow(input_x[1], 4) * pow(input_x[2], 3);
      idvg_poly_feat[301] = pow(input_x[1], 4) * pow(input_x[2], 2) * pow(input_x[3], 1);
      idvg_poly_feat[302] = pow(input_x[1], 4) * pow(input_x[2], 1) * pow(input_x[3], 2);
      idvg_poly_feat[303] = pow(input_x[1], 4) * pow(input_x[3], 3);
      idvg_poly_feat[304] = pow(input_x[1], 3) * pow(input_x[2], 4);
      idvg_poly_feat[305] = pow(input_x[1], 3) * pow(input_x[2], 3) * pow(input_x[3], 1);
      idvg_poly_feat[306] = pow(input_x[1], 3) * pow(input_x[2], 2) * pow(input_x[3], 2);
      idvg_poly_feat[307] = pow(input_x[1], 3) * pow(input_x[2], 1) * pow(input_x[3], 3);
      idvg_poly_feat[308] = pow(input_x[1], 3) * pow(input_x[3], 4);
      idvg_poly_feat[309] = pow(input_x[1], 2) * pow(input_x[2], 5);
      idvg_poly_feat[310] = pow(input_x[1], 2) * pow(input_x[2], 4) * pow(input_x[3], 1);
      idvg_poly_feat[311] = pow(input_x[1], 2) * pow(input_x[2], 3) * pow(input_x[3], 2);
      idvg_poly_feat[312] = pow(input_x[1], 2) * pow(input_x[2], 2) * pow(input_x[3], 3);
      idvg_poly_feat[313] = pow(input_x[1], 2) * pow(input_x[2], 1) * pow(input_x[3], 4);
      idvg_poly_feat[314] = pow(input_x[1], 2) * pow(input_x[3], 5);
      idvg_poly_feat[315] = pow(input_x[1], 1) * pow(input_x[2], 6);
      idvg_poly_feat[316] = pow(input_x[1], 1) * pow(input_x[2], 5) * pow(input_x[3], 1);
      idvg_poly_feat[317] = pow(input_x[1], 1) * pow(input_x[2], 4) * pow(input_x[3], 2);
      idvg_poly_feat[318] = pow(input_x[1], 1) * pow(input_x[2], 3) * pow(input_x[3], 3);
      idvg_poly_feat[319] = pow(input_x[1], 1) * pow(input_x[2], 2) * pow(input_x[3], 4);
      idvg_poly_feat[320] = pow(input_x[1], 1) * pow(input_x[2], 1) * pow(input_x[3], 5);
      idvg_poly_feat[321] = pow(input_x[1], 1) * pow(input_x[3], 6);
      idvg_poly_feat[322] = pow(input_x[2], 7);
      idvg_poly_feat[323] = pow(input_x[2], 6) * pow(input_x[3], 1);
      idvg_poly_feat[324] = pow(input_x[2], 5) * pow(input_x[3], 2);
      idvg_poly_feat[325] = pow(input_x[2], 4) * pow(input_x[3], 3);
      idvg_poly_feat[326] = pow(input_x[2], 3) * pow(input_x[3], 4);
      idvg_poly_feat[327] = pow(input_x[2], 2) * pow(input_x[3], 5);
      idvg_poly_feat[328] = pow(input_x[2], 1) * pow(input_x[3], 6);
      idvg_poly_feat[329] = pow(input_x[3], 7);
      idvg_poly_feat[330] = pow(input_x[0], 8);
      idvg_poly_feat[331] = pow(input_x[0], 7) * pow(input_x[1], 1);
      idvg_poly_feat[332] = pow(input_x[0], 7) * pow(input_x[2], 1);
      idvg_poly_feat[333] = pow(input_x[0], 7) * pow(input_x[3], 1);
      idvg_poly_feat[334] = pow(input_x[0], 6) * pow(input_x[1], 2);
      idvg_poly_feat[335] = pow(input_x[0], 6) * pow(input_x[1], 1) * pow(input_x[2], 1);
      idvg_poly_feat[336] = pow(input_x[0], 6) * pow(input_x[1], 1) * pow(input_x[3], 1);
      idvg_poly_feat[337] = pow(input_x[0], 6) * pow(input_x[2], 2);
      idvg_poly_feat[338] = pow(input_x[0], 6) * pow(input_x[2], 1) * pow(input_x[3], 1);
      idvg_poly_feat[339] = pow(input_x[0], 6) * pow(input_x[3], 2);
      idvg_poly_feat[340] = pow(input_x[0], 5) * pow(input_x[1], 3);
      idvg_poly_feat[341] = pow(input_x[0], 5) * pow(input_x[1], 2) * pow(input_x[2], 1);
      idvg_poly_feat[342] = pow(input_x[0], 5) * pow(input_x[1], 2) * pow(input_x[3], 1);
      idvg_poly_feat[343] = pow(input_x[0], 5) * pow(input_x[1], 1) * pow(input_x[2], 2);
      idvg_poly_feat[344] = pow(input_x[0], 5) * pow(input_x[1], 1) * pow(input_x[2], 1) * pow(input_x[3], 1);
      idvg_poly_feat[345] = pow(input_x[0], 5) * pow(input_x[1], 1) * pow(input_x[3], 2);
      idvg_poly_feat[346] = pow(input_x[0], 5) * pow(input_x[2], 3);
      idvg_poly_feat[347] = pow(input_x[0], 5) * pow(input_x[2], 2) * pow(input_x[3], 1);
      idvg_poly_feat[348] = pow(input_x[0], 5) * pow(input_x[2], 1) * pow(input_x[3], 2);
      idvg_poly_feat[349] = pow(input_x[0], 5) * pow(input_x[3], 3);
      idvg_poly_feat[350] = pow(input_x[0], 4) * pow(input_x[1], 4);
      idvg_poly_feat[351] = pow(input_x[0], 4) * pow(input_x[1], 3) * pow(input_x[2], 1);
      idvg_poly_feat[352] = pow(input_x[0], 4) * pow(input_x[1], 3) * pow(input_x[3], 1);
      idvg_poly_feat[353] = pow(input_x[0], 4) * pow(input_x[1], 2) * pow(input_x[2], 2);
      idvg_poly_feat[354] = pow(input_x[0], 4) * pow(input_x[1], 2) * pow(input_x[2], 1) * pow(input_x[3], 1);
      idvg_poly_feat[355] = pow(input_x[0], 4) * pow(input_x[1], 2) * pow(input_x[3], 2);
      idvg_poly_feat[356] = pow(input_x[0], 4) * pow(input_x[1], 1) * pow(input_x[2], 3);
      idvg_poly_feat[357] = pow(input_x[0], 4) * pow(input_x[1], 1) * pow(input_x[2], 2) * pow(input_x[3], 1);
      idvg_poly_feat[358] = pow(input_x[0], 4) * pow(input_x[1], 1) * pow(input_x[2], 1) * pow(input_x[3], 2);
      idvg_poly_feat[359] = pow(input_x[0], 4) * pow(input_x[1], 1) * pow(input_x[3], 3);
      idvg_poly_feat[360] = pow(input_x[0], 4) * pow(input_x[2], 4);
      idvg_poly_feat[361] = pow(input_x[0], 4) * pow(input_x[2], 3) * pow(input_x[3], 1);
      idvg_poly_feat[362] = pow(input_x[0], 4) * pow(input_x[2], 2) * pow(input_x[3], 2);
      idvg_poly_feat[363] = pow(input_x[0], 4) * pow(input_x[2], 1) * pow(input_x[3], 3);
      idvg_poly_feat[364] = pow(input_x[0], 4) * pow(input_x[3], 4);
      idvg_poly_feat[365] = pow(input_x[0], 3) * pow(input_x[1], 5);
      idvg_poly_feat[366] = pow(input_x[0], 3) * pow(input_x[1], 4) * pow(input_x[2], 1);
      idvg_poly_feat[367] = pow(input_x[0], 3) * pow(input_x[1], 4) * pow(input_x[3], 1);
      idvg_poly_feat[368] = pow(input_x[0], 3) * pow(input_x[1], 3) * pow(input_x[2], 2);
      idvg_poly_feat[369] = pow(input_x[0], 3) * pow(input_x[1], 3) * pow(input_x[2], 1) * pow(input_x[3], 1);
      idvg_poly_feat[370] = pow(input_x[0], 3) * pow(input_x[1], 3) * pow(input_x[3], 2);
      idvg_poly_feat[371] = pow(input_x[0], 3) * pow(input_x[1], 2) * pow(input_x[2], 3);
      idvg_poly_feat[372] = pow(input_x[0], 3) * pow(input_x[1], 2) * pow(input_x[2], 2) * pow(input_x[3], 1);
      idvg_poly_feat[373] = pow(input_x[0], 3) * pow(input_x[1], 2) * pow(input_x[2], 1) * pow(input_x[3], 2);
      idvg_poly_feat[374] = pow(input_x[0], 3) * pow(input_x[1], 2) * pow(input_x[3], 3);
      idvg_poly_feat[375] = pow(input_x[0], 3) * pow(input_x[1], 1) * pow(input_x[2], 4);
      idvg_poly_feat[376] = pow(input_x[0], 3) * pow(input_x[1], 1) * pow(input_x[2], 3) * pow(input_x[3], 1);
      idvg_poly_feat[377] = pow(input_x[0], 3) * pow(input_x[1], 1) * pow(input_x[2], 2) * pow(input_x[3], 2);
      idvg_poly_feat[378] = pow(input_x[0], 3) * pow(input_x[1], 1) * pow(input_x[2], 1) * pow(input_x[3], 3);
      idvg_poly_feat[379] = pow(input_x[0], 3) * pow(input_x[1], 1) * pow(input_x[3], 4);
      idvg_poly_feat[380] = pow(input_x[0], 3) * pow(input_x[2], 5);
      idvg_poly_feat[381] = pow(input_x[0], 3) * pow(input_x[2], 4) * pow(input_x[3], 1);
      idvg_poly_feat[382] = pow(input_x[0], 3) * pow(input_x[2], 3) * pow(input_x[3], 2);
      idvg_poly_feat[383] = pow(input_x[0], 3) * pow(input_x[2], 2) * pow(input_x[3], 3);
      idvg_poly_feat[384] = pow(input_x[0], 3) * pow(input_x[2], 1) * pow(input_x[3], 4);
      idvg_poly_feat[385] = pow(input_x[0], 3) * pow(input_x[3], 5);
      idvg_poly_feat[386] = pow(input_x[0], 2) * pow(input_x[1], 6);
      idvg_poly_feat[387] = pow(input_x[0], 2) * pow(input_x[1], 5) * pow(input_x[2], 1);
      idvg_poly_feat[388] = pow(input_x[0], 2) * pow(input_x[1], 5) * pow(input_x[3], 1);
      idvg_poly_feat[389] = pow(input_x[0], 2) * pow(input_x[1], 4) * pow(input_x[2], 2);
      idvg_poly_feat[390] = pow(input_x[0], 2) * pow(input_x[1], 4) * pow(input_x[2], 1) * pow(input_x[3], 1);
      idvg_poly_feat[391] = pow(input_x[0], 2) * pow(input_x[1], 4) * pow(input_x[3], 2);
      idvg_poly_feat[392] = pow(input_x[0], 2) * pow(input_x[1], 3) * pow(input_x[2], 3);
      idvg_poly_feat[393] = pow(input_x[0], 2) * pow(input_x[1], 3) * pow(input_x[2], 2) * pow(input_x[3], 1);
      idvg_poly_feat[394] = pow(input_x[0], 2) * pow(input_x[1], 3) * pow(input_x[2], 1) * pow(input_x[3], 2);
      idvg_poly_feat[395] = pow(input_x[0], 2) * pow(input_x[1], 3) * pow(input_x[3], 3);
      idvg_poly_feat[396] = pow(input_x[0], 2) * pow(input_x[1], 2) * pow(input_x[2], 4);
      idvg_poly_feat[397] = pow(input_x[0], 2) * pow(input_x[1], 2) * pow(input_x[2], 3) * pow(input_x[3], 1);
      idvg_poly_feat[398] = pow(input_x[0], 2) * pow(input_x[1], 2) * pow(input_x[2], 2) * pow(input_x[3], 2);
      idvg_poly_feat[399] = pow(input_x[0], 2) * pow(input_x[1], 2) * pow(input_x[2], 1) * pow(input_x[3], 3);
      idvg_poly_feat[400] = pow(input_x[0], 2) * pow(input_x[1], 2) * pow(input_x[3], 4);
      idvg_poly_feat[401] = pow(input_x[0], 2) * pow(input_x[1], 1) * pow(input_x[2], 5);
      idvg_poly_feat[402] = pow(input_x[0], 2) * pow(input_x[1], 1) * pow(input_x[2], 4) * pow(input_x[3], 1);
      idvg_poly_feat[403] = pow(input_x[0], 2) * pow(input_x[1], 1) * pow(input_x[2], 3) * pow(input_x[3], 2);
      idvg_poly_feat[404] = pow(input_x[0], 2) * pow(input_x[1], 1) * pow(input_x[2], 2) * pow(input_x[3], 3);
      idvg_poly_feat[405] = pow(input_x[0], 2) * pow(input_x[1], 1) * pow(input_x[2], 1) * pow(input_x[3], 4);
      idvg_poly_feat[406] = pow(input_x[0], 2) * pow(input_x[1], 1) * pow(input_x[3], 5);
      idvg_poly_feat[407] = pow(input_x[0], 2) * pow(input_x[2], 6);
      idvg_poly_feat[408] = pow(input_x[0], 2) * pow(input_x[2], 5) * pow(input_x[3], 1);
      idvg_poly_feat[409] = pow(input_x[0], 2) * pow(input_x[2], 4) * pow(input_x[3], 2);
      idvg_poly_feat[410] = pow(input_x[0], 2) * pow(input_x[2], 3) * pow(input_x[3], 3);
      idvg_poly_feat[411] = pow(input_x[0], 2) * pow(input_x[2], 2) * pow(input_x[3], 4);
      idvg_poly_feat[412] = pow(input_x[0], 2) * pow(input_x[2], 1) * pow(input_x[3], 5);
      idvg_poly_feat[413] = pow(input_x[0], 2) * pow(input_x[3], 6);
      idvg_poly_feat[414] = pow(input_x[0], 1) * pow(input_x[1], 7);
      idvg_poly_feat[415] = pow(input_x[0], 1) * pow(input_x[1], 6) * pow(input_x[2], 1);
      idvg_poly_feat[416] = pow(input_x[0], 1) * pow(input_x[1], 6) * pow(input_x[3], 1);
      idvg_poly_feat[417] = pow(input_x[0], 1) * pow(input_x[1], 5) * pow(input_x[2], 2);
      idvg_poly_feat[418] = pow(input_x[0], 1) * pow(input_x[1], 5) * pow(input_x[2], 1) * pow(input_x[3], 1);
      idvg_poly_feat[419] = pow(input_x[0], 1) * pow(input_x[1], 5) * pow(input_x[3], 2);
      idvg_poly_feat[420] = pow(input_x[0], 1) * pow(input_x[1], 4) * pow(input_x[2], 3);
      idvg_poly_feat[421] = pow(input_x[0], 1) * pow(input_x[1], 4) * pow(input_x[2], 2) * pow(input_x[3], 1);
      idvg_poly_feat[422] = pow(input_x[0], 1) * pow(input_x[1], 4) * pow(input_x[2], 1) * pow(input_x[3], 2);
      idvg_poly_feat[423] = pow(input_x[0], 1) * pow(input_x[1], 4) * pow(input_x[3], 3);
      idvg_poly_feat[424] = pow(input_x[0], 1) * pow(input_x[1], 3) * pow(input_x[2], 4);
      idvg_poly_feat[425] = pow(input_x[0], 1) * pow(input_x[1], 3) * pow(input_x[2], 3) * pow(input_x[3], 1);
      idvg_poly_feat[426] = pow(input_x[0], 1) * pow(input_x[1], 3) * pow(input_x[2], 2) * pow(input_x[3], 2);
      idvg_poly_feat[427] = pow(input_x[0], 1) * pow(input_x[1], 3) * pow(input_x[2], 1) * pow(input_x[3], 3);
      idvg_poly_feat[428] = pow(input_x[0], 1) * pow(input_x[1], 3) * pow(input_x[3], 4);
      idvg_poly_feat[429] = pow(input_x[0], 1) * pow(input_x[1], 2) * pow(input_x[2], 5);
      idvg_poly_feat[430] = pow(input_x[0], 1) * pow(input_x[1], 2) * pow(input_x[2], 4) * pow(input_x[3], 1);
      idvg_poly_feat[431] = pow(input_x[0], 1) * pow(input_x[1], 2) * pow(input_x[2], 3) * pow(input_x[3], 2);
      idvg_poly_feat[432] = pow(input_x[0], 1) * pow(input_x[1], 2) * pow(input_x[2], 2) * pow(input_x[3], 3);
      idvg_poly_feat[433] = pow(input_x[0], 1) * pow(input_x[1], 2) * pow(input_x[2], 1) * pow(input_x[3], 4);
      idvg_poly_feat[434] = pow(input_x[0], 1) * pow(input_x[1], 2) * pow(input_x[3], 5);
      idvg_poly_feat[435] = pow(input_x[0], 1) * pow(input_x[1], 1) * pow(input_x[2], 6);
      idvg_poly_feat[436] = pow(input_x[0], 1) * pow(input_x[1], 1) * pow(input_x[2], 5) * pow(input_x[3], 1);
      idvg_poly_feat[437] = pow(input_x[0], 1) * pow(input_x[1], 1) * pow(input_x[2], 4) * pow(input_x[3], 2);
      idvg_poly_feat[438] = pow(input_x[0], 1) * pow(input_x[1], 1) * pow(input_x[2], 3) * pow(input_x[3], 3);
      idvg_poly_feat[439] = pow(input_x[0], 1) * pow(input_x[1], 1) * pow(input_x[2], 2) * pow(input_x[3], 4);
      idvg_poly_feat[440] = pow(input_x[0], 1) * pow(input_x[1], 1) * pow(input_x[2], 1) * pow(input_x[3], 5);
      idvg_poly_feat[441] = pow(input_x[0], 1) * pow(input_x[1], 1) * pow(input_x[3], 6);
      idvg_poly_feat[442] = pow(input_x[0], 1) * pow(input_x[2], 7);
      idvg_poly_feat[443] = pow(input_x[0], 1) * pow(input_x[2], 6) * pow(input_x[3], 1);
      idvg_poly_feat[444] = pow(input_x[0], 1) * pow(input_x[2], 5) * pow(input_x[3], 2);
      idvg_poly_feat[445] = pow(input_x[0], 1) * pow(input_x[2], 4) * pow(input_x[3], 3);
      idvg_poly_feat[446] = pow(input_x[0], 1) * pow(input_x[2], 3) * pow(input_x[3], 4);
      idvg_poly_feat[447] = pow(input_x[0], 1) * pow(input_x[2], 2) * pow(input_x[3], 5);
      idvg_poly_feat[448] = pow(input_x[0], 1) * pow(input_x[2], 1) * pow(input_x[3], 6);
      idvg_poly_feat[449] = pow(input_x[0], 1) * pow(input_x[3], 7);
      idvg_poly_feat[450] = pow(input_x[1], 8);
      idvg_poly_feat[451] = pow(input_x[1], 7) * pow(input_x[2], 1);
      idvg_poly_feat[452] = pow(input_x[1], 7) * pow(input_x[3], 1);
      idvg_poly_feat[453] = pow(input_x[1], 6) * pow(input_x[2], 2);
      idvg_poly_feat[454] = pow(input_x[1], 6) * pow(input_x[2], 1) * pow(input_x[3], 1);
      idvg_poly_feat[455] = pow(input_x[1], 6) * pow(input_x[3], 2);
      idvg_poly_feat[456] = pow(input_x[1], 5) * pow(input_x[2], 3);
      idvg_poly_feat[457] = pow(input_x[1], 5) * pow(input_x[2], 2) * pow(input_x[3], 1);
      idvg_poly_feat[458] = pow(input_x[1], 5) * pow(input_x[2], 1) * pow(input_x[3], 2);
      idvg_poly_feat[459] = pow(input_x[1], 5) * pow(input_x[3], 3);
      idvg_poly_feat[460] = pow(input_x[1], 4) * pow(input_x[2], 4);
      idvg_poly_feat[461] = pow(input_x[1], 4) * pow(input_x[2], 3) * pow(input_x[3], 1);
      idvg_poly_feat[462] = pow(input_x[1], 4) * pow(input_x[2], 2) * pow(input_x[3], 2);
      idvg_poly_feat[463] = pow(input_x[1], 4) * pow(input_x[2], 1) * pow(input_x[3], 3);
      idvg_poly_feat[464] = pow(input_x[1], 4) * pow(input_x[3], 4);
      idvg_poly_feat[465] = pow(input_x[1], 3) * pow(input_x[2], 5);
      idvg_poly_feat[466] = pow(input_x[1], 3) * pow(input_x[2], 4) * pow(input_x[3], 1);
      idvg_poly_feat[467] = pow(input_x[1], 3) * pow(input_x[2], 3) * pow(input_x[3], 2);
      idvg_poly_feat[468] = pow(input_x[1], 3) * pow(input_x[2], 2) * pow(input_x[3], 3);
      idvg_poly_feat[469] = pow(input_x[1], 3) * pow(input_x[2], 1) * pow(input_x[3], 4);
      idvg_poly_feat[470] = pow(input_x[1], 3) * pow(input_x[3], 5);
      idvg_poly_feat[471] = pow(input_x[1], 2) * pow(input_x[2], 6);
      idvg_poly_feat[472] = pow(input_x[1], 2) * pow(input_x[2], 5) * pow(input_x[3], 1);
      idvg_poly_feat[473] = pow(input_x[1], 2) * pow(input_x[2], 4) * pow(input_x[3], 2);
      idvg_poly_feat[474] = pow(input_x[1], 2) * pow(input_x[2], 3) * pow(input_x[3], 3);
      idvg_poly_feat[475] = pow(input_x[1], 2) * pow(input_x[2], 2) * pow(input_x[3], 4);
      idvg_poly_feat[476] = pow(input_x[1], 2) * pow(input_x[2], 1) * pow(input_x[3], 5);
      idvg_poly_feat[477] = pow(input_x[1], 2) * pow(input_x[3], 6);
      idvg_poly_feat[478] = pow(input_x[1], 1) * pow(input_x[2], 7);
      idvg_poly_feat[479] = pow(input_x[1], 1) * pow(input_x[2], 6) * pow(input_x[3], 1);
      idvg_poly_feat[480] = pow(input_x[1], 1) * pow(input_x[2], 5) * pow(input_x[3], 2);
      idvg_poly_feat[481] = pow(input_x[1], 1) * pow(input_x[2], 4) * pow(input_x[3], 3);
      idvg_poly_feat[482] = pow(input_x[1], 1) * pow(input_x[2], 3) * pow(input_x[3], 4);
      idvg_poly_feat[483] = pow(input_x[1], 1) * pow(input_x[2], 2) * pow(input_x[3], 5);
      idvg_poly_feat[484] = pow(input_x[1], 1) * pow(input_x[2], 1) * pow(input_x[3], 6);
      idvg_poly_feat[485] = pow(input_x[1], 1) * pow(input_x[3], 7);
      idvg_poly_feat[486] = pow(input_x[2], 8);
      idvg_poly_feat[487] = pow(input_x[2], 7) * pow(input_x[3], 1);
      idvg_poly_feat[488] = pow(input_x[2], 6) * pow(input_x[3], 2);
      idvg_poly_feat[489] = pow(input_x[2], 5) * pow(input_x[3], 3);
      idvg_poly_feat[490] = pow(input_x[2], 4) * pow(input_x[3], 4);
      idvg_poly_feat[491] = pow(input_x[2], 3) * pow(input_x[3], 5);
      idvg_poly_feat[492] = pow(input_x[2], 2) * pow(input_x[3], 6);
      idvg_poly_feat[493] = pow(input_x[2], 1) * pow(input_x[3], 7);
      idvg_poly_feat[494] = pow(input_x[3], 8);
      for(i=0; i<7; i=i+1) begin
        tmp = idvg_poly_b[i];
        for(j=0; j<495; j=j+1) tmp = tmp + idvg_poly_w[i*495 + j] * idvg_poly_feat[j];
        idvg_z[i] = tmp * idvg_sl_mul[i] + idvg_sl_add[i];
      end
      for(i=0; i<151; i=i+1) begin
        tmp = idvg_ae_b0[i];
        for(j=0; j<7; j=j+1) tmp = tmp + idvg_ae_w0[i*7 + j] * idvg_z[j];
        idvg_h0[i] = (tmp > 0.0) ? tmp : 0.0;
      end
      for(i=0; i<603; i=i+1) begin
        tmp = idvg_ae_b1[i];
        for(j=0; j<151; j=j+1) tmp = tmp + idvg_ae_w1[i*151 + j] * idvg_h0[j];
        idvg_h1[i] = (tmp > 0.0) ? tmp : 0.0;
      end
      for(i=0; i<1206; i=i+1) begin
        tmp = idvg_ae_b2[i];
        for(j=0; j<603; j=j+1) tmp = tmp + idvg_ae_w2[i*603 + j] * idvg_h1[j];
        idvg_h2[i] = (tmp > 0.0) ? tmp : 0.0;
      end
      for(i=0; i<1206; i=i+1) begin
        tmp = idvg_ae_b3[i];
        for(j=0; j<1206; j=j+1) tmp = tmp + idvg_ae_w3[i*1206 + j] * idvg_h2[j];
        tmp = 1.0 / (1.0 + exp(-tmp));
        idvg_out[i] = -1.0 * (tmp * idvg_siv_mul[i] + idvg_siv_add[i]);
      end
    end

    val_vg = V(g, s);
    val_vd = V(d, s);
    vd_mag = sqrt(val_vd*val_vd + vds_sign_delta*vds_sign_delta);
    sign_vd = val_vd / vd_mag;

    // The ML data was trained for negative drain bias. Use |Vds| for the
    // surface lookup and apply the drain-current sign afterwards.

    // Id-Vd surface: 9 Vg anchors x 120 Vd samples
    if(val_vg <= -5.0) begin
      idvd_vg0_idx = 0;
      idvd_vg1_idx = 1;
      idvd_vg_frac = 0.0;
      idvd_excess = -5.0 - val_vg;
    end else if(val_vg >= 11.0) begin
      idvd_vg0_idx = 7;
      idvd_vg1_idx = 8;
      idvd_vg_frac = 1.0;
      idvd_excess = val_vg - 11.0;
    end else begin
      idvd_vg_pos = (val_vg + 5.0) / 2.0;
      idvd_vg0_idx = $rtoi(idvd_vg_pos);
      if(idvd_vg0_idx > 7) idvd_vg0_idx = 7;
      idvd_vg1_idx = idvd_vg0_idx + 1;
      idvd_vg_frac = idvd_vg_pos - idvd_vg0_idx;
      idvd_excess = 0.0;
    end

    if(vd_mag >= 12.0) begin
      idvd_vd0_idx = 0;
      idvd_vd1_idx = 1;
      idvd_vd_frac = 0.0;
    end else if(vd_mag > 0.02) begin
      idvd_vd_pos = (12.0 - vd_mag) / ((12.0 - 0.02) / 118.0);
      idvd_vd0_idx = $rtoi(idvd_vd_pos);
      if(idvd_vd0_idx > 117) idvd_vd0_idx = 117;
      idvd_vd1_idx = idvd_vd0_idx + 1;
      idvd_vd_frac = idvd_vd_pos - idvd_vd0_idx;
    end else begin
      idvd_vd0_idx = 118;
      idvd_vd1_idx = 119;
      idvd_vd_frac = (0.02 - vd_mag) / 0.02;
    end

    idvd_i00 = idvd_out[idvd_vg0_idx * 120 + idvd_vd0_idx];
    idvd_i01 = idvd_out[idvd_vg0_idx * 120 + idvd_vd1_idx];
    idvd_i10 = idvd_out[idvd_vg1_idx * 120 + idvd_vd0_idx];
    idvd_i11 = idvd_out[idvd_vg1_idx * 120 + idvd_vd1_idx];
    idvd_interp = (1.0 - idvd_vg_frac) * ((1.0 - idvd_vd_frac) * idvd_i00 + idvd_vd_frac * idvd_i01)
                + idvd_vg_frac * ((1.0 - idvd_vd_frac) * idvd_i10 + idvd_vd_frac * idvd_i11);

    // Id-Vg surface: 6 Vd anchors x 201 Vg samples
    if(val_vg <= -5.0) begin
      idvg_vg0_idx = 0;
      idvg_vg1_idx = 1;
      idvg_vg_frac = 0.0;
    end else if(val_vg >= 12.0) begin
      idvg_vg0_idx = 199;
      idvg_vg1_idx = 200;
      idvg_vg_frac = 1.0;
    end else begin
      idvg_vg_pos = (val_vg + 5.0) / (17.0 / 200.0);
      idvg_vg0_idx = $rtoi(idvg_vg_pos);
      if(idvg_vg0_idx > 199) idvg_vg0_idx = 199;
      idvg_vg1_idx = idvg_vg0_idx + 1;
      idvg_vg_frac = idvg_vg_pos - idvg_vg0_idx;
    end

    if(vd_mag >= 11.0) begin
      idvg_vd0_idx = 0;
      idvg_vd1_idx = 1;
      idvg_vd_frac = 0.0;
      idvg_excess = vd_mag - 11.0;
    end else if(vd_mag <= 1.0) begin
      idvg_vd0_idx = 4;
      idvg_vd1_idx = 5;
      idvg_vd_frac = 1.0;
      idvg_excess = 1.0 - vd_mag;
    end else begin
      idvg_vd_pos = (11.0 - vd_mag) / 2.0;
      idvg_vd0_idx = $rtoi(idvg_vd_pos);
      if(idvg_vd0_idx > 4) idvg_vd0_idx = 4;
      idvg_vd1_idx = idvg_vd0_idx + 1;
      idvg_vd_frac = idvg_vd_pos - idvg_vd0_idx;
      idvg_excess = 0.0;
    end

    idvg_i00 = idvg_out[idvg_vd0_idx * 201 + idvg_vg0_idx];
    idvg_i01 = idvg_out[idvg_vd0_idx * 201 + idvg_vg1_idx];
    idvg_i10 = idvg_out[idvg_vd1_idx * 201 + idvg_vg0_idx];
    idvg_i11 = idvg_out[idvg_vd1_idx * 201 + idvg_vg1_idx];
    idvg_interp = (1.0 - idvg_vd_frac) * ((1.0 - idvg_vg_frac) * idvg_i00 + idvg_vg_frac * idvg_i01)
                + idvg_vd_frac * ((1.0 - idvg_vg_frac) * idvg_i10 + idvg_vg_frac * idvg_i11);

    if(idvd_vg_frac < 0.5) idvd_vg_dist = 2.0 * idvd_vg_frac;
    else idvd_vg_dist = 2.0 * (1.0 - idvd_vg_frac);
    if(idvg_vd_frac < 0.5) idvg_vd_dist = 2.0 * idvg_vd_frac;
    else idvg_vd_dist = 2.0 * (1.0 - idvg_vd_frac);

    w_idvd = 1.0 / (0.05 + (idvd_vg_dist + 2.0 * idvd_excess) * (idvd_vg_dist + 2.0 * idvd_excess));
    w_idvg = 1.0 / (0.05 + (idvg_vd_dist + 2.0 * idvg_excess) * (idvg_vd_dist + 2.0 * idvg_excess));

    if(current_mode == 1) begin
      res_id_ref = idvd_interp;
    end else if(current_mode == 2) begin
      res_id_ref = idvg_interp;
    end else begin
      w_sum = w_idvd + w_idvg;
      if(w_sum > 0.0) res_id_ref = (w_idvd * idvd_interp + w_idvg * idvg_interp) / w_sum;
      else res_id_ref = 0.5 * (idvd_interp + idvg_interp);
    end

    I(d, s) <+ -sign_vd * res_id_ref;
    I(d, s) <+ gmin_ds * V(d, s);
  end
endmodule
